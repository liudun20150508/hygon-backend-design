* CDL Netlist generated by OpenROAD

*.BUSDELIMITER [

.SUBCKT picorv32 VNB clk
+ mem_addr[10] mem_addr[11]
+ mem_addr[12] mem_addr[13] mem_addr[14] mem_addr[15] mem_addr[16]
+ mem_addr[17] mem_addr[18] mem_addr[19] mem_addr[20]
+ mem_addr[21] mem_addr[22] mem_addr[23] mem_addr[24] mem_addr[25]
+ mem_addr[26] mem_addr[27] mem_addr[28] mem_addr[29] mem_addr[2]
+ mem_addr[30] mem_addr[31] mem_addr[3] mem_addr[4] mem_addr[5]
+ mem_addr[6] mem_addr[7] mem_addr[8] mem_addr[9] mem_instr
+ mem_la_addr[10] mem_la_addr[11] mem_la_addr[12]
+ mem_la_addr[13] mem_la_addr[14] mem_la_addr[15] mem_la_addr[16]
+ mem_la_addr[17] mem_la_addr[18] mem_la_addr[19]
+ mem_la_addr[20] mem_la_addr[21] mem_la_addr[22] mem_la_addr[23]
+ mem_la_addr[24] mem_la_addr[25] mem_la_addr[26] mem_la_addr[27]
+ mem_la_addr[28] mem_la_addr[29] mem_la_addr[2] mem_la_addr[30]
+ mem_la_addr[31] mem_la_addr[3] mem_la_addr[4] mem_la_addr[5]
+ mem_la_addr[6] mem_la_addr[7] mem_la_addr[8] mem_la_addr[9]
+ mem_la_read mem_la_wdata[0] mem_la_wdata[10] mem_la_wdata[11]
+ mem_la_wdata[12] mem_la_wdata[13] mem_la_wdata[14] mem_la_wdata[15]
+ mem_la_wdata[16] mem_la_wdata[17] mem_la_wdata[18] mem_la_wdata[19]
+ mem_la_wdata[1] mem_la_wdata[20] mem_la_wdata[21] mem_la_wdata[22]
+ mem_la_wdata[23] mem_la_wdata[24] mem_la_wdata[25] mem_la_wdata[26]
+ mem_la_wdata[27] mem_la_wdata[28] mem_la_wdata[29] mem_la_wdata[2]
+ mem_la_wdata[30] mem_la_wdata[31] mem_la_wdata[3] mem_la_wdata[4]
+ mem_la_wdata[5] mem_la_wdata[6] mem_la_wdata[7] mem_la_wdata[8]
+ mem_la_wdata[9] mem_la_write mem_la_wstrb[0] mem_la_wstrb[1]
+ mem_la_wstrb[2] mem_la_wstrb[3] mem_rdata[0] mem_rdata[10]
+ mem_rdata[11] mem_rdata[12] mem_rdata[13] mem_rdata[14] mem_rdata[15]
+ mem_rdata[16] mem_rdata[17] mem_rdata[18] mem_rdata[19] mem_rdata[1]
+ mem_rdata[20] mem_rdata[21] mem_rdata[22] mem_rdata[23] mem_rdata[24]
+ mem_rdata[25] mem_rdata[26] mem_rdata[27] mem_rdata[28] mem_rdata[29]
+ mem_rdata[2] mem_rdata[30] mem_rdata[31] mem_rdata[3] mem_rdata[4]
+ mem_rdata[5] mem_rdata[6] mem_rdata[7] mem_rdata[8] mem_rdata[9]
+ mem_ready mem_valid mem_wdata[0] mem_wdata[10] mem_wdata[11]
+ mem_wdata[12] mem_wdata[13] mem_wdata[14] mem_wdata[15] mem_wdata[16]
+ mem_wdata[17] mem_wdata[18] mem_wdata[19] mem_wdata[1] mem_wdata[20]
+ mem_wdata[21] mem_wdata[22] mem_wdata[23] mem_wdata[24] mem_wdata[25]
+ mem_wdata[26] mem_wdata[27] mem_wdata[28] mem_wdata[29] mem_wdata[2]
+ mem_wdata[30] mem_wdata[31] mem_wdata[3] mem_wdata[4] mem_wdata[5]
+ mem_wdata[6] mem_wdata[7] mem_wdata[8] mem_wdata[9] mem_wstrb[0]
+ mem_wstrb[1] mem_wstrb[2] mem_wstrb[3]
+ pcpi_rs1[0] pcpi_rs1[10] pcpi_rs1[11]
+ pcpi_rs1[12] pcpi_rs1[13] pcpi_rs1[14] pcpi_rs1[15] pcpi_rs1[16]
+ pcpi_rs1[17] pcpi_rs1[18] pcpi_rs1[19] pcpi_rs1[1] pcpi_rs1[20]
+ pcpi_rs1[21] pcpi_rs1[22] pcpi_rs1[23] pcpi_rs1[24] pcpi_rs1[25]
+ pcpi_rs1[26] pcpi_rs1[27] pcpi_rs1[28] pcpi_rs1[29] pcpi_rs1[2]
+ pcpi_rs1[30] pcpi_rs1[31] pcpi_rs1[3] pcpi_rs1[4] pcpi_rs1[5]
+ pcpi_rs1[6] pcpi_rs1[7] pcpi_rs1[8] pcpi_rs1[9] pcpi_rs2[0]
+ pcpi_rs2[10] pcpi_rs2[11] pcpi_rs2[12] pcpi_rs2[13] pcpi_rs2[14]
+ pcpi_rs2[15] pcpi_rs2[16] pcpi_rs2[17] pcpi_rs2[18] pcpi_rs2[19]
+ pcpi_rs2[1] pcpi_rs2[20] pcpi_rs2[21] pcpi_rs2[22] pcpi_rs2[23]
+ pcpi_rs2[24] pcpi_rs2[25] pcpi_rs2[26] pcpi_rs2[27] pcpi_rs2[28]
+ pcpi_rs2[29] pcpi_rs2[2] pcpi_rs2[30] pcpi_rs2[31] pcpi_rs2[3]
+ pcpi_rs2[4] pcpi_rs2[5] pcpi_rs2[6] pcpi_rs2[7] pcpi_rs2[8]
+ pcpi_rs2[9] resetn
+ VDD VSS
X_4688_ decoder_trigger VSS VSS VDD VDD _0864_ sky130_fd_sc_hd__inv_1
X_4689_ net699 decoder_pseudo_trigger VSS VSS VDD VDD _0812_
+ sky130_fd_sc_hd__nor2_4
X_4690_ net271 net170 VSS VSS VDD VDD _0865_ sky130_fd_sc_hd__nand2_1
X_4691_ _0500_ net698 _0505_ VSS VSS VDD VDD _0866_ sky130_fd_sc_hd__o21bai_1
X_4692_ mem_do_rdata mem_do_wdata VSS VSS VDD VDD _0867_ sky130_fd_sc_hd__nor2_1
X_4693_ _0500_ net698 _0867_ VSS VSS VDD VDD _0868_ sky130_fd_sc_hd__nor3_1
X_4694_ mem_do_rinst _0866_ _0868_ VSS VSS VDD VDD _0869_
+ sky130_fd_sc_hd__a21oi_1
X_4695_ net661 VSS VSS VDD VDD _0870_ sky130_fd_sc_hd__inv_1
X_4696_ mem_do_rinst net776 _0870_ VSS VSS VDD VDD _0871_
+ sky130_fd_sc_hd__nand3_1
Xclkbuf_leaf_88_clk clknet_4_15_0_clk VSS VSS VDD VDD clknet_leaf_88_clk
+ sky130_fd_sc_hd__clkbuf_16
X_4698_ net618 VSS VSS VDD VDD _0830_ sky130_fd_sc_hd__inv_1
Xclkbuf_leaf_87_clk clknet_4_15_0_clk VSS VSS VDD VDD clknet_leaf_87_clk
+ sky130_fd_sc_hd__clkbuf_16
Xclkbuf_leaf_86_clk clknet_4_13_0_clk VSS VSS VDD VDD clknet_leaf_86_clk
+ sky130_fd_sc_hd__clkbuf_16
X_4701_ net736 net738 VSS VSS VDD VDD _0875_ sky130_fd_sc_hd__nand2_1
Xclkbuf_leaf_85_clk clknet_4_13_0_clk VSS VSS VDD VDD clknet_leaf_85_clk
+ sky130_fd_sc_hd__clkbuf_16
Xclkbuf_leaf_84_clk clknet_4_13_0_clk VSS VSS VDD VDD clknet_leaf_84_clk
+ sky130_fd_sc_hd__clkbuf_16
Xclkbuf_leaf_83_clk clknet_4_7_0_clk VSS VSS VDD VDD clknet_leaf_83_clk
+ sky130_fd_sc_hd__clkbuf_16
Xclkbuf_leaf_82_clk clknet_4_7_0_clk VSS VSS VDD VDD clknet_leaf_82_clk
+ sky130_fd_sc_hd__clkbuf_16
Xclkbuf_leaf_81_clk clknet_4_13_0_clk VSS VSS VDD VDD clknet_leaf_81_clk
+ sky130_fd_sc_hd__clkbuf_16
Xclkbuf_leaf_80_clk clknet_4_13_0_clk VSS VSS VDD VDD clknet_leaf_80_clk
+ sky130_fd_sc_hd__clkbuf_16
X_4708_ reg_out\[1\] alu_out_q\[1\] net737 VSS VSS VDD VDD
+ _0882_ sky130_fd_sc_hd__mux2i_1
X_4709_ reg_next_pc\[1\] _0875_ VSS VSS VDD VDD _0883_ sky130_fd_sc_hd__nand2_1
X_4710_ _0875_ _0882_ _0883_ VSS VSS VDD VDD _0420_ sky130_fd_sc_hd__o21ai_0
Xclkbuf_leaf_79_clk clknet_4_13_0_clk VSS VSS VDD VDD clknet_leaf_79_clk
+ sky130_fd_sc_hd__clkbuf_16
X_4712_ reg_out\[2\] alu_out_q\[2\] net737 VSS VSS VDD VDD
+ _0885_ sky130_fd_sc_hd__mux2_2
X_4713_ net736 net738 VSS VSS VDD VDD _0886_ sky130_fd_sc_hd__and2_4
Xclkbuf_leaf_78_clk clknet_4_12_0_clk VSS VSS VDD VDD clknet_leaf_78_clk
+ sky130_fd_sc_hd__clkbuf_16
X_4715_ reg_next_pc\[2\] _0885_ _0886_ VSS VSS VDD VDD _0888_
+ sky130_fd_sc_hd__mux2i_1
X_4716_ _0888_ VSS VSS VDD VDD _0052_ sky130_fd_sc_hd__inv_1
Xclkbuf_leaf_77_clk clknet_4_6_0_clk VSS VSS VDD VDD clknet_leaf_77_clk
+ sky130_fd_sc_hd__clkbuf_16
X_4718_ reg_out\[3\] alu_out_q\[3\] net737 VSS VSS VDD VDD
+ _0890_ sky130_fd_sc_hd__mux2i_1
X_4719_ net736 net738 reg_next_pc\[3\] VSS VSS VDD VDD _0891_
+ sky130_fd_sc_hd__a21oi_1
X_4720_ _0886_ _0890_ _0891_ VSS VSS VDD VDD _0266_ sky130_fd_sc_hd__a21oi_1
X_4721_ reg_out\[4\] alu_out_q\[4\] net737 VSS VSS VDD VDD
+ _0892_ sky130_fd_sc_hd__mux2i_1
X_4722_ net736 net738 reg_next_pc\[4\] VSS VSS VDD VDD _0893_
+ sky130_fd_sc_hd__a21oi_1
X_4723_ _0886_ _0892_ _0893_ VSS VSS VDD VDD _0457_ sky130_fd_sc_hd__a21oi_2
X_4724_ reg_out\[5\] alu_out_q\[5\] net737 VSS VSS VDD VDD
+ _0894_ sky130_fd_sc_hd__mux2_2
X_4725_ reg_next_pc\[5\] _0894_ _0886_ VSS VSS VDD VDD _0895_
+ sky130_fd_sc_hd__mux2i_1
X_4726_ _0895_ VSS VSS VDD VDD _0273_ sky130_fd_sc_hd__inv_1
X_4727_ reg_out\[6\] alu_out_q\[6\] net737 VSS VSS VDD VDD
+ _0896_ sky130_fd_sc_hd__mux2_2
X_4728_ reg_next_pc\[6\] _0896_ _0886_ VSS VSS VDD VDD _0897_
+ sky130_fd_sc_hd__mux2i_1
X_4729_ _0897_ VSS VSS VDD VDD _0405_ sky130_fd_sc_hd__inv_1
X_4730_ reg_out\[7\] alu_out_q\[7\] net737 VSS VSS VDD VDD
+ _0898_ sky130_fd_sc_hd__mux2_2
X_4731_ reg_next_pc\[7\] _0898_ _0886_ VSS VSS VDD VDD _0899_
+ sky130_fd_sc_hd__mux2i_1
X_4732_ _0899_ VSS VSS VDD VDD _0434_ sky130_fd_sc_hd__inv_1
X_4733_ reg_out\[8\] alu_out_q\[8\] net737 VSS VSS VDD VDD
+ _0900_ sky130_fd_sc_hd__mux2_2
X_4734_ reg_next_pc\[8\] _0900_ _0886_ VSS VSS VDD VDD _0901_
+ sky130_fd_sc_hd__mux2i_1
X_4735_ _0901_ VSS VSS VDD VDD _0365_ sky130_fd_sc_hd__inv_1
X_4736_ reg_out\[9\] alu_out_q\[9\] net737 VSS VSS VDD VDD
+ _0902_ sky130_fd_sc_hd__mux2_2
X_4737_ reg_next_pc\[9\] _0902_ _0886_ VSS VSS VDD VDD _0903_
+ sky130_fd_sc_hd__mux2i_2
X_4738_ _0903_ VSS VSS VDD VDD _0117_ sky130_fd_sc_hd__inv_1
X_4739_ reg_out\[10\] alu_out_q\[10\] net737 VSS VSS VDD VDD
+ _0904_ sky130_fd_sc_hd__mux2_2
X_4740_ reg_next_pc\[10\] _0904_ _0886_ VSS VSS VDD VDD _0905_
+ sky130_fd_sc_hd__mux2i_1
X_4741_ _0905_ VSS VSS VDD VDD _0402_ sky130_fd_sc_hd__inv_1
X_4742_ reg_out\[11\] alu_out_q\[11\] net737 VSS VSS VDD VDD
+ _0906_ sky130_fd_sc_hd__mux2_2
X_4743_ reg_next_pc\[11\] _0906_ _0886_ VSS VSS VDD VDD _0907_
+ sky130_fd_sc_hd__mux2i_1
X_4744_ _0907_ VSS VSS VDD VDD _0460_ sky130_fd_sc_hd__inv_1
X_4745_ reg_out\[12\] alu_out_q\[12\] net737 VSS VSS VDD VDD
+ _0908_ sky130_fd_sc_hd__mux2_2
X_4746_ reg_next_pc\[12\] _0908_ _0886_ VSS VSS VDD VDD _0909_
+ sky130_fd_sc_hd__mux2i_1
X_4747_ _0909_ VSS VSS VDD VDD _0120_ sky130_fd_sc_hd__inv_1
X_4748_ reg_out\[13\] alu_out_q\[13\] net737 VSS VSS VDD VDD
+ _0910_ sky130_fd_sc_hd__mux2_2
X_4749_ reg_next_pc\[13\] _0910_ _0886_ VSS VSS VDD VDD _0911_
+ sky130_fd_sc_hd__mux2i_1
X_4750_ _0911_ VSS VSS VDD VDD _0425_ sky130_fd_sc_hd__inv_1
Xclkbuf_leaf_76_clk clknet_4_6_0_clk VSS VSS VDD VDD clknet_leaf_76_clk
+ sky130_fd_sc_hd__clkbuf_16
X_4752_ reg_out\[14\] alu_out_q\[14\] net737 VSS VSS VDD VDD
+ _0913_ sky130_fd_sc_hd__mux2_2
X_4753_ _0886_ _0913_ VSS VSS VDD VDD _0914_ sky130_fd_sc_hd__nand2_1
X_4754_ reg_next_pc\[14\] net697 VSS VSS VDD VDD _0915_ sky130_fd_sc_hd__nand2_1
X_4755_ _0914_ _0915_ VSS VSS VDD VDD _0916_ sky130_fd_sc_hd__and2_1
X_4756_ _0916_ VSS VSS VDD VDD _0399_ sky130_fd_sc_hd__inv_1
X_4757_ reg_out\[15\] alu_out_q\[15\] net737 VSS VSS VDD VDD
+ _0917_ sky130_fd_sc_hd__mux2_2
X_4758_ _0886_ _0917_ VSS VSS VDD VDD _0918_ sky130_fd_sc_hd__nand2_1
X_4759_ reg_next_pc\[15\] net697 VSS VSS VDD VDD _0919_ sky130_fd_sc_hd__nand2_1
X_4760_ _0918_ _0919_ VSS VSS VDD VDD _0261_ sky130_fd_sc_hd__nand2_1
X_4761_ reg_out\[16\] alu_out_q\[16\] net737 VSS VSS VDD VDD
+ _0920_ sky130_fd_sc_hd__mux2_2
X_4762_ _0886_ _0920_ VSS VSS VDD VDD _0921_ sky130_fd_sc_hd__nand2_1
X_4763_ reg_next_pc\[16\] net697 VSS VSS VDD VDD _0922_ sky130_fd_sc_hd__nand2_1
X_4764_ _0921_ _0922_ VSS VSS VDD VDD _0923_ sky130_fd_sc_hd__and2_1
X_4765_ _0923_ VSS VSS VDD VDD _0097_ sky130_fd_sc_hd__inv_1
X_4766_ reg_out\[17\] alu_out_q\[17\] net737 VSS VSS VDD VDD
+ _0924_ sky130_fd_sc_hd__mux2_2
X_4767_ reg_next_pc\[17\] net697 VSS VSS VDD VDD _0925_ sky130_fd_sc_hd__nand2_1
X_4768_ _0886_ _0924_ _0925_ VSS VSS VDD VDD _0926_ sky130_fd_sc_hd__a21boi_1
X_4769_ _0926_ VSS VSS VDD VDD _0417_ sky130_fd_sc_hd__inv_1
X_4770_ reg_out\[18\] alu_out_q\[18\] net737 VSS VSS VDD VDD
+ _0927_ sky130_fd_sc_hd__mux2_2
X_4771_ _0886_ _0927_ VSS VSS VDD VDD _0928_ sky130_fd_sc_hd__nand2_1
X_4772_ reg_next_pc\[18\] net697 VSS VSS VDD VDD _0929_ sky130_fd_sc_hd__nand2_1
X_4773_ _0928_ _0929_ VSS VSS VDD VDD _0930_ sky130_fd_sc_hd__and2_1
X_4774_ _0930_ VSS VSS VDD VDD _0396_ sky130_fd_sc_hd__inv_1
X_4775_ reg_out\[19\] alu_out_q\[19\] net737 VSS VSS VDD VDD
+ _0931_ sky130_fd_sc_hd__mux2_2
X_4776_ reg_next_pc\[19\] _0931_ _0886_ VSS VSS VDD VDD _0932_
+ sky130_fd_sc_hd__mux2i_1
X_4777_ _0932_ VSS VSS VDD VDD _0428_ sky130_fd_sc_hd__inv_1
X_4778_ reg_out\[20\] alu_out_q\[20\] net737 VSS VSS VDD VDD
+ _0933_ sky130_fd_sc_hd__mux2_2
X_4779_ reg_next_pc\[20\] _0933_ _0886_ VSS VSS VDD VDD _0934_
+ sky130_fd_sc_hd__mux2i_1
X_4780_ _0934_ VSS VSS VDD VDD _0072_ sky130_fd_sc_hd__inv_1
X_4781_ reg_out\[21\] alu_out_q\[21\] net737 VSS VSS VDD VDD
+ _0935_ sky130_fd_sc_hd__mux2i_1
X_4782_ net736 net738 reg_next_pc\[21\] VSS VSS VDD VDD _0936_
+ sky130_fd_sc_hd__a21oi_1
X_4783_ _0886_ _0935_ _0936_ VSS VSS VDD VDD _0094_ sky130_fd_sc_hd__a21oi_2
X_4784_ reg_out\[22\] alu_out_q\[22\] net737 VSS VSS VDD VDD
+ _0937_ sky130_fd_sc_hd__mux2i_1
X_4785_ net736 net738 reg_next_pc\[22\] VSS VSS VDD VDD _0938_
+ sky130_fd_sc_hd__a21oi_1
X_4786_ _0886_ _0937_ _0938_ VSS VSS VDD VDD _0393_ sky130_fd_sc_hd__a21oi_2
X_4787_ reg_out\[23\] alu_out_q\[23\] net737 VSS VSS VDD VDD
+ _0939_ sky130_fd_sc_hd__mux2i_1
X_4788_ reg_next_pc\[23\] net697 VSS VSS VDD VDD _0940_ sky130_fd_sc_hd__nand2_1
X_4789_ net697 _0939_ _0940_ VSS VSS VDD VDD _0431_ sky130_fd_sc_hd__o21ai_1
X_4790_ reg_out\[24\] alu_out_q\[24\] net737 VSS VSS VDD VDD
+ _0941_ sky130_fd_sc_hd__mux2i_1
X_4791_ reg_next_pc\[24\] net697 VSS VSS VDD VDD _0942_ sky130_fd_sc_hd__nand2_1
X_4792_ net697 _0941_ _0942_ VSS VSS VDD VDD _0258_ sky130_fd_sc_hd__o21ai_1
X_4793_ reg_out\[25\] alu_out_q\[25\] net737 VSS VSS VDD VDD
+ _0943_ sky130_fd_sc_hd__mux2_2
X_4794_ _0886_ _0943_ VSS VSS VDD VDD _0944_ sky130_fd_sc_hd__nand2_1
X_4795_ reg_next_pc\[25\] net697 VSS VSS VDD VDD _0945_ sky130_fd_sc_hd__nand2_1
X_4796_ _0944_ _0945_ VSS VSS VDD VDD _0075_ sky130_fd_sc_hd__nand2_1
X_4797_ reg_out\[26\] alu_out_q\[26\] net737 VSS VSS VDD VDD
+ _0946_ sky130_fd_sc_hd__mux2_2
X_4798_ reg_next_pc\[26\] _0946_ _0886_ VSS VSS VDD VDD _0947_
+ sky130_fd_sc_hd__mux2i_1
X_4799_ _0947_ VSS VSS VDD VDD _0390_ sky130_fd_sc_hd__inv_1
X_4800_ reg_out\[27\] alu_out_q\[27\] net737 VSS VSS VDD VDD
+ _0948_ sky130_fd_sc_hd__mux2i_1
X_4801_ reg_next_pc\[27\] net697 VSS VSS VDD VDD _0949_ sky130_fd_sc_hd__nand2_1
X_4802_ net697 _0948_ _0949_ VSS VSS VDD VDD _0380_ sky130_fd_sc_hd__o21ai_1
X_4803_ reg_out\[28\] alu_out_q\[28\] net737 VSS VSS VDD VDD
+ _0950_ sky130_fd_sc_hd__mux2i_1
X_4804_ reg_next_pc\[28\] net697 VSS VSS VDD VDD _0951_ sky130_fd_sc_hd__nand2_1
X_4805_ net697 _0950_ _0951_ VSS VSS VDD VDD _0952_ sky130_fd_sc_hd__o21a_1
X_4806_ _0952_ VSS VSS VDD VDD _0337_ sky130_fd_sc_hd__inv_1
X_4807_ reg_out\[29\] alu_out_q\[29\] net737 VSS VSS VDD VDD
+ _0953_ sky130_fd_sc_hd__mux2i_1
X_4808_ reg_next_pc\[29\] net697 VSS VSS VDD VDD _0954_ sky130_fd_sc_hd__nand2_1
X_4809_ net697 _0953_ _0954_ VSS VSS VDD VDD _0955_ sky130_fd_sc_hd__o21a_1
X_4810_ _0955_ VSS VSS VDD VDD _0422_ sky130_fd_sc_hd__inv_1
X_4811_ reg_out\[30\] alu_out_q\[30\] net737 VSS VSS VDD VDD
+ _0956_ sky130_fd_sc_hd__mux2i_1
X_4812_ reg_next_pc\[30\] net697 VSS VSS VDD VDD _0957_ sky130_fd_sc_hd__nand2_1
X_4813_ net697 _0956_ _0957_ VSS VSS VDD VDD _0958_ sky130_fd_sc_hd__o21a_1
X_4814_ _0958_ VSS VSS VDD VDD _0387_ sky130_fd_sc_hd__inv_1
X_4815_ net340 VSS VSS VDD VDD _0284_ sky130_fd_sc_hd__inv_1
X_4816_ net719 VSS VSS VDD VDD _0198_ sky130_fd_sc_hd__inv_1
X_4817_ net263 VSS VSS VDD VDD _0451_ sky130_fd_sc_hd__inv_1
X_4818_ net727 VSS VSS VDD VDD _0346_ sky130_fd_sc_hd__inv_1
X_4819_ net713 VSS VSS VDD VDD _0297_ sky130_fd_sc_hd__inv_1
X_4820_ net729 VSS VSS VDD VDD _0210_ sky130_fd_sc_hd__inv_1
X_4821_ net716 VSS VSS VDD VDD _0368_ sky130_fd_sc_hd__inv_1
X_4822_ net703 VSS VSS VDD VDD _0325_ sky130_fd_sc_hd__inv_1
X_4823_ net354 VSS VSS VDD VDD _0369_ sky130_fd_sc_hd__inv_1
X_4824_ net352 VSS VSS VDD VDD _0229_ sky130_fd_sc_hd__inv_1
X_4825_ net351 VSS VSS VDD VDD _0199_ sky130_fd_sc_hd__inv_1
X_4826_ net702 VSS VSS VDD VDD _0411_ sky130_fd_sc_hd__inv_1
X_4827_ net362 VSS VSS VDD VDD _0136_ sky130_fd_sc_hd__inv_1
X_4828_ net730 VSS VSS VDD VDD _0321_ sky130_fd_sc_hd__inv_1
X_4829_ net341 VSS VSS VDD VDD _0148_ sky130_fd_sc_hd__inv_1
X_4830_ reg_sh\[3\] VSS VSS VDD VDD _0156_ sky130_fd_sc_hd__inv_1
X_4831_ reg_sh\[2\] VSS VSS VDD VDD _0155_ sky130_fd_sc_hd__inv_1
X_4832_ reg_sh\[1\] VSS VSS VDD VDD _0164_ sky130_fd_sc_hd__inv_1
X_4833_ net720 VSS VSS VDD VDD _0108_ sky130_fd_sc_hd__inv_1
X_4834_ reg_sh\[0\] VSS VSS VDD VDD _0163_ sky130_fd_sc_hd__inv_1
Xclkbuf_leaf_75_clk clknet_4_6_0_clk VSS VSS VDD VDD clknet_leaf_75_clk
+ sky130_fd_sc_hd__clkbuf_16
X_4836_ net732 VSS VSS VDD VDD _0485_ sky130_fd_sc_hd__inv_1
X_4837_ net359 VSS VSS VDD VDD _0192_ sky130_fd_sc_hd__inv_1
X_4838_ net701 VSS VSS VDD VDD _0145_ sky130_fd_sc_hd__inv_1
Xclkbuf_leaf_74_clk clknet_4_6_0_clk VSS VSS VDD VDD clknet_leaf_74_clk
+ sky130_fd_sc_hd__clkbuf_16
Xclkbuf_leaf_73_clk clknet_4_6_0_clk VSS VSS VDD VDD clknet_leaf_73_clk
+ sky130_fd_sc_hd__clkbuf_16
X_4841_ net733 net734 VSS VSS VDD VDD _0962_ sky130_fd_sc_hd__or2_2
Xclkbuf_leaf_72_clk clknet_4_6_0_clk VSS VSS VDD VDD clknet_leaf_72_clk
+ sky130_fd_sc_hd__clkbuf_16
Xclkbuf_leaf_71_clk clknet_4_6_0_clk VSS VSS VDD VDD clknet_leaf_71_clk
+ sky130_fd_sc_hd__clkbuf_16
X_4844_ net733 net344 VSS VSS VDD VDD _0965_ sky130_fd_sc_hd__nand2_1
Xclkbuf_leaf_70_clk clknet_4_6_0_clk VSS VSS VDD VDD clknet_leaf_70_clk
+ sky130_fd_sc_hd__clkbuf_16
X_4846_ net734 net262 VSS VSS VDD VDD _0967_ sky130_fd_sc_hd__nand2_1
X_4847_ _0145_ _0962_ _0965_ _0967_ VSS VSS VDD VDD net257
+ sky130_fd_sc_hd__o211ai_1
X_4848_ net733 net343 net261 net734 VSS VSS VDD VDD _0968_
+ sky130_fd_sc_hd__a22oi_1
X_4849_ _0192_ _0962_ _0968_ VSS VSS VDD VDD net255 sky130_fd_sc_hd__o21ai_0
X_4850_ net358 VSS VSS VDD VDD _0476_ sky130_fd_sc_hd__inv_1
X_4851_ net734 net260 VSS VSS VDD VDD _0969_ sky130_fd_sc_hd__nand2_1
X_4852_ net733 net342 VSS VSS VDD VDD _0970_ sky130_fd_sc_hd__nand2_1
X_4853_ _0476_ _0962_ _0969_ _0970_ VSS VSS VDD VDD net254
+ sky130_fd_sc_hd__o211ai_1
X_4854_ net357 VSS VSS VDD VDD _0114_ sky130_fd_sc_hd__inv_1
X_4855_ net734 net259 VSS VSS VDD VDD _0971_ sky130_fd_sc_hd__nand2_1
X_4856_ net341 net733 VSS VSS VDD VDD _0972_ sky130_fd_sc_hd__nand2_1
X_4857_ _0114_ _0962_ _0971_ _0972_ VSS VSS VDD VDD net253
+ sky130_fd_sc_hd__o211ai_1
X_4858_ net356 VSS VSS VDD VDD _0195_ sky130_fd_sc_hd__inv_1
X_4859_ net734 net256 VSS VSS VDD VDD _0973_ sky130_fd_sc_hd__nand2_1
X_4860_ net340 net733 VSS VSS VDD VDD _0974_ sky130_fd_sc_hd__nand2_1
X_4861_ _0195_ _0962_ _0973_ _0974_ VSS VSS VDD VDD net252
+ sky130_fd_sc_hd__o211ai_1
X_4862_ net355 VSS VSS VDD VDD _0127_ sky130_fd_sc_hd__inv_1
X_4863_ net734 net245 VSS VSS VDD VDD _0975_ sky130_fd_sc_hd__nand2_1
X_4864_ net733 net363 VSS VSS VDD VDD _0976_ sky130_fd_sc_hd__nand2_1
X_4865_ _0127_ _0962_ _0975_ _0976_ VSS VSS VDD VDD net251
+ sky130_fd_sc_hd__o211ai_1
X_4866_ net362 net733 net734 net234 VSS VSS VDD VDD _0977_
+ sky130_fd_sc_hd__a22oi_1
X_4867_ _0369_ _0962_ _0977_ VSS VSS VDD VDD net250 sky130_fd_sc_hd__o21ai_0
X_4868_ net733 net734 VSS VSS VDD VDD _0978_ sky130_fd_sc_hd__nor2_2
Xclkbuf_leaf_69_clk clknet_4_6_0_clk VSS VSS VDD VDD clknet_leaf_69_clk
+ sky130_fd_sc_hd__clkbuf_16
X_4870_ net353 net696 VSS VSS VDD VDD _0980_ sky130_fd_sc_hd__nand2_1
X_4871_ _0451_ net696 _0980_ VSS VSS VDD VDD net249 sky130_fd_sc_hd__o21ai_0
X_4872_ net262 VSS VSS VDD VDD _0374_ sky130_fd_sc_hd__inv_1
X_4873_ net352 net696 VSS VSS VDD VDD _0981_ sky130_fd_sc_hd__nand2_1
X_4874_ _0374_ net696 _0981_ VSS VSS VDD VDD net248 sky130_fd_sc_hd__o21ai_0
X_4875_ net261 VSS VSS VDD VDD _0234_ sky130_fd_sc_hd__inv_1
X_4876_ net351 net696 VSS VSS VDD VDD _0982_ sky130_fd_sc_hd__nand2_1
X_4877_ _0234_ net696 _0982_ VSS VSS VDD VDD net247 sky130_fd_sc_hd__o21ai_0
X_4878_ net260 VSS VSS VDD VDD _0463_ sky130_fd_sc_hd__inv_1
X_4879_ net350 net696 VSS VSS VDD VDD _0983_ sky130_fd_sc_hd__nand2_1
X_4880_ _0463_ net696 _0983_ VSS VSS VDD VDD net246 sky130_fd_sc_hd__o21ai_0
X_4881_ net259 VSS VSS VDD VDD _0469_ sky130_fd_sc_hd__inv_1
X_4882_ net349 net696 VSS VSS VDD VDD _0984_ sky130_fd_sc_hd__nand2_1
X_4883_ _0469_ net696 _0984_ VSS VSS VDD VDD net244 sky130_fd_sc_hd__o21ai_0
X_4884_ net256 VSS VSS VDD VDD _0278_ sky130_fd_sc_hd__inv_1
X_4885_ net348 net696 VSS VSS VDD VDD _0985_ sky130_fd_sc_hd__nand2_1
X_4886_ _0278_ net696 _0985_ VSS VSS VDD VDD net243 sky130_fd_sc_hd__o21ai_0
X_4887_ net245 VSS VSS VDD VDD _0059_ sky130_fd_sc_hd__inv_1
X_4888_ net347 net696 VSS VSS VDD VDD _0986_ sky130_fd_sc_hd__nand2_1
X_4889_ _0059_ net696 _0986_ VSS VSS VDD VDD net242 sky130_fd_sc_hd__o21ai_0
X_4890_ net234 VSS VSS VDD VDD _0484_ sky130_fd_sc_hd__inv_1
X_4891_ net346 net696 VSS VSS VDD VDD _0987_ sky130_fd_sc_hd__nand2_1
X_4892_ _0484_ net696 _0987_ VSS VSS VDD VDD net241 sky130_fd_sc_hd__o21ai_0
X_4893_ net733 net734 VSS VSS VDD VDD _0988_ sky130_fd_sc_hd__nand2b_1
Xclkbuf_leaf_68_clk clknet_4_7_0_clk VSS VSS VDD VDD clknet_leaf_68_clk
+ sky130_fd_sc_hd__clkbuf_16
X_4895_ net263 net734 _0988_ net345 VSS VSS VDD VDD net240
+ sky130_fd_sc_hd__a22o_1
X_4896_ net344 _0988_ VSS VSS VDD VDD _0990_ sky130_fd_sc_hd__nand2_1
X_4897_ _0967_ _0990_ VSS VSS VDD VDD net239 sky130_fd_sc_hd__nand2_1
X_4898_ net734 net261 _0988_ net343 VSS VSS VDD VDD net238
+ sky130_fd_sc_hd__a22o_1
X_4899_ net342 _0988_ VSS VSS VDD VDD _0991_ sky130_fd_sc_hd__nand2_1
X_4900_ _0969_ _0991_ VSS VSS VDD VDD net237 sky130_fd_sc_hd__nand2_1
X_4901_ net341 _0988_ VSS VSS VDD VDD _0992_ sky130_fd_sc_hd__nand2_1
X_4902_ _0971_ _0992_ VSS VSS VDD VDD net236 sky130_fd_sc_hd__nand2_1
X_4903_ net704 VSS VSS VDD VDD _0452_ sky130_fd_sc_hd__inv_1
X_4904_ net340 _0988_ VSS VSS VDD VDD _0993_ sky130_fd_sc_hd__nand2_1
X_4905_ _0973_ _0993_ VSS VSS VDD VDD net235 sky130_fd_sc_hd__nand2_1
X_4906_ net363 _0988_ VSS VSS VDD VDD _0994_ sky130_fd_sc_hd__nand2_1
X_4907_ _0975_ _0994_ VSS VSS VDD VDD net265 sky130_fd_sc_hd__nand2_1
X_4908_ net734 net234 _0988_ net362 VSS VSS VDD VDD net264
+ sky130_fd_sc_hd__a22o_1
Xclkbuf_leaf_67_clk clknet_4_7_0_clk VSS VSS VDD VDD clknet_leaf_67_clk
+ sky130_fd_sc_hd__clkbuf_16
Xclkbuf_leaf_66_clk clknet_4_7_0_clk VSS VSS VDD VDD clknet_leaf_66_clk
+ sky130_fd_sc_hd__clkbuf_16
X_4911_ mem_wordsize\[2\] net308 VSS VSS VDD VDD _0997_ sky130_fd_sc_hd__nand2b_1
X_4912_ net721 _0997_ VSS VSS VDD VDD _0998_ sky130_fd_sc_hd__nand2_1
X_4913_ _0962_ _0998_ VSS VSS VDD VDD net269 sky130_fd_sc_hd__nand2_1
X_4914_ net308 net733 VSS VSS VDD VDD _0999_ sky130_fd_sc_hd__nor2_1
X_4915_ net721 _0999_ _0962_ VSS VSS VDD VDD net268 sky130_fd_sc_hd__o21ai_0
X_4916_ net721 VSS VSS VDD VDD _0055_ sky130_fd_sc_hd__inv_1
X_4917_ _0055_ _0997_ net696 VSS VSS VDD VDD net267 sky130_fd_sc_hd__a21o_1
Xclkbuf_leaf_65_clk clknet_4_7_0_clk VSS VSS VDD VDD clknet_leaf_65_clk
+ sky130_fd_sc_hd__clkbuf_16
X_4919_ net724 VSS VSS VDD VDD _0250_ sky130_fd_sc_hd__inv_1
Xclkbuf_leaf_64_clk clknet_4_7_0_clk VSS VSS VDD VDD clknet_leaf_64_clk
+ sky130_fd_sc_hd__clkbuf_16
X_4921_ net709 VSS VSS VDD VDD _0487_ sky130_fd_sc_hd__inv_1
X_4922_ net348 VSS VSS VDD VDD _0204_ sky130_fd_sc_hd__inv_1
X_4923_ net723 VSS VSS VDD VDD _0246_ sky130_fd_sc_hd__inv_1
X_4924_ mem_do_prefetch mem_do_rinst VSS VSS VDD VDD _1002_
+ sky130_fd_sc_hd__or2_2
Xclkbuf_leaf_63_clk clknet_4_7_0_clk VSS VSS VDD VDD clknet_leaf_63_clk
+ sky130_fd_sc_hd__clkbuf_16
X_4926_ mem_do_rdata net695 _0500_ VSS VSS VDD VDD _1004_
+ sky130_fd_sc_hd__o21a_1
Xclkbuf_leaf_62_clk clknet_4_7_0_clk VSS VSS VDD VDD clknet_leaf_62_clk
+ sky130_fd_sc_hd__clkbuf_16
X_4928_ mem_do_wdata _0500_ net171 VSS VSS VDD VDD net266
+ sky130_fd_sc_hd__and3_1
Xclkbuf_leaf_61_clk clknet_4_7_0_clk VSS VSS VDD VDD clknet_leaf_61_clk
+ sky130_fd_sc_hd__clkbuf_16
X_4930_ net306 net269 net266 VSS VSS VDD VDD _1007_ sky130_fd_sc_hd__mux2i_1
X_4931_ _1004_ _1007_ VSS VSS VDD VDD _4631_ sky130_fd_sc_hd__nor2_1
X_4932_ net305 net268 net266 VSS VSS VDD VDD _1008_ sky130_fd_sc_hd__mux2i_1
X_4933_ _1004_ _1008_ VSS VSS VDD VDD _4630_ sky130_fd_sc_hd__nor2_1
X_4934_ net304 net267 net266 VSS VSS VDD VDD _1009_ sky130_fd_sc_hd__mux2i_1
X_4935_ _1004_ _1009_ VSS VSS VDD VDD _4629_ sky130_fd_sc_hd__nor2_1
X_4936_ net344 VSS VSS VDD VDD _0347_ sky130_fd_sc_hd__inv_1
X_4937_ net353 VSS VSS VDD VDD _0105_ sky130_fd_sc_hd__inv_1
X_4938_ net717 VSS VSS VDD VDD _0123_ sky130_fd_sc_hd__inv_1
X_4939_ net342 VSS VSS VDD VDD _0211_ sky130_fd_sc_hd__inv_1
X_4940_ net726 VSS VSS VDD VDD _0313_ sky130_fd_sc_hd__inv_1
X_4941_ instr_jalr is_lb_lh_lw_lbu_lhu is_alu_reg_imm VSS
+ VSS VDD VDD _1010_ sky130_fd_sc_hd__or3_1
Xclkbuf_leaf_60_clk clknet_4_7_0_clk VSS VSS VDD VDD clknet_leaf_60_clk
+ sky130_fd_sc_hd__clkbuf_16
X_4943_ is_sb_sh_sw mem_rdata_q\[7\] _1010_ mem_rdata_q\[20\]
+ VSS VSS VDD VDD _4628_ sky130_fd_sc_hd__a22o_1
X_4944_ is_compare VSS VSS VDD VDD _1012_ sky130_fd_sc_hd__inv_1
X_4945_ instr_xor instr_xori VSS VSS VDD VDD _1013_ sky130_fd_sc_hd__or2_2
Xclkbuf_leaf_59_clk clknet_4_7_0_clk VSS VSS VDD VDD clknet_leaf_59_clk
+ sky130_fd_sc_hd__clkbuf_16
X_4947_ instr_or instr_ori VSS VSS VDD VDD _1015_ sky130_fd_sc_hd__or2_2
X_4948_ instr_and instr_andi VSS VSS VDD VDD _1016_ sky130_fd_sc_hd__or2_2
Xclkbuf_leaf_58_clk clknet_4_7_0_clk VSS VSS VDD VDD clknet_leaf_58_clk
+ sky130_fd_sc_hd__clkbuf_16
X_4950_ _1013_ _1015_ _1016_ VSS VSS VDD VDD _1018_ sky130_fd_sc_hd__nor3_1
X_4951_ _1012_ _1018_ VSS VSS VDD VDD _1019_ sky130_fd_sc_hd__nand2_2
Xclkbuf_leaf_57_clk clknet_4_5_0_clk VSS VSS VDD VDD clknet_leaf_57_clk
+ sky130_fd_sc_hd__clkbuf_16
Xclkbuf_leaf_56_clk clknet_4_5_0_clk VSS VSS VDD VDD clknet_leaf_56_clk
+ sky130_fd_sc_hd__clkbuf_16
Xclkbuf_leaf_55_clk clknet_4_5_0_clk VSS VSS VDD VDD clknet_leaf_55_clk
+ sky130_fd_sc_hd__clkbuf_16
X_4955_ instr_or instr_ori VSS VSS VDD VDD _1023_ sky130_fd_sc_hd__nor2_2
Xclkbuf_leaf_54_clk clknet_4_5_0_clk VSS VSS VDD VDD clknet_leaf_54_clk
+ sky130_fd_sc_hd__clkbuf_16
X_4957_ _0294_ net694 VSS VSS VDD VDD _1025_ sky130_fd_sc_hd__nor2_1
X_4958_ _0295_ _1013_ _1016_ _0296_ _1025_ VSS VSS VDD VDD
+ _1026_ sky130_fd_sc_hd__a221oi_1
X_4959_ _0478_ VSS VSS VDD VDD _1027_ sky130_fd_sc_hd__inv_1
Xclkbuf_leaf_53_clk clknet_4_5_0_clk VSS VSS VDD VDD clknet_leaf_53_clk
+ sky130_fd_sc_hd__clkbuf_16
X_4961_ _0299_ _0304_ _0300_ VSS VSS VDD VDD _1029_ sky130_fd_sc_hd__a21oi_1
X_4962_ _1027_ _1029_ _0480_ VSS VSS VDD VDD _1030_ sky130_fd_sc_hd__o21bai_1
X_4963_ _0271_ _1030_ _0272_ VSS VSS VDD VDD _1031_ sky130_fd_sc_hd__a21o_1
Xclkbuf_leaf_52_clk clknet_4_5_0_clk VSS VSS VDD VDD clknet_leaf_52_clk
+ sky130_fd_sc_hd__clkbuf_16
Xclkbuf_leaf_51_clk clknet_4_5_0_clk VSS VSS VDD VDD clknet_leaf_51_clk
+ sky130_fd_sc_hd__clkbuf_16
X_4966_ net675 net739 _0295_ VSS VSS VDD VDD _1034_ sky130_fd_sc_hd__nor3b_1
Xclkbuf_leaf_50_clk clknet_4_5_0_clk VSS VSS VDD VDD clknet_leaf_50_clk
+ sky130_fd_sc_hd__clkbuf_16
X_4968_ _0371_ VSS VSS VDD VDD _1036_ sky130_fd_sc_hd__inv_1
X_4969_ _0129_ _1036_ VSS VSS VDD VDD _1037_ sky130_fd_sc_hd__nand2_1
Xclkbuf_leaf_49_clk clknet_4_5_0_clk VSS VSS VDD VDD clknet_leaf_49_clk
+ sky130_fd_sc_hd__clkbuf_16
X_4971_ _0194_ _0116_ _0197_ _1027_ VSS VSS VDD VDD _1039_
+ sky130_fd_sc_hd__nand4_1
X_4972_ _1037_ _1039_ VSS VSS VDD VDD _1040_ sky130_fd_sc_hd__nor2_1
X_4973_ _0279_ VSS VSS VDD VDD _1041_ sky130_fd_sc_hd__inv_1
X_4974_ _0057_ _0280_ VSS VSS VDD VDD _1042_ sky130_fd_sc_hd__nand2b_1
Xclkbuf_leaf_48_clk clknet_4_4_0_clk VSS VSS VDD VDD clknet_leaf_48_clk
+ sky130_fd_sc_hd__clkbuf_16
X_4976_ _1041_ _1042_ _0472_ VSS VSS VDD VDD _1044_ sky130_fd_sc_hd__a21oi_1
X_4977_ _0473_ _1044_ VSS VSS VDD VDD _1045_ sky130_fd_sc_hd__nor2_1
X_4978_ _0236_ VSS VSS VDD VDD _1046_ sky130_fd_sc_hd__inv_1
Xclkbuf_leaf_47_clk clknet_4_5_0_clk VSS VSS VDD VDD clknet_leaf_47_clk
+ sky130_fd_sc_hd__clkbuf_16
Xclkbuf_leaf_46_clk clknet_4_5_0_clk VSS VSS VDD VDD clknet_leaf_46_clk
+ sky130_fd_sc_hd__clkbuf_16
Xclkbuf_leaf_45_clk clknet_4_4_0_clk VSS VSS VDD VDD clknet_leaf_45_clk
+ sky130_fd_sc_hd__clkbuf_16
X_4982_ _0454_ _0377_ VSS VSS VDD VDD _1050_ sky130_fd_sc_hd__or2_1
X_4983_ _1046_ _0466_ _1050_ VSS VSS VDD VDD _1051_ sky130_fd_sc_hd__or3_1
X_4984_ _0236_ _0467_ _0235_ VSS VSS VDD VDD _1052_ sky130_fd_sc_hd__a21oi_1
X_4985_ _0454_ _0378_ VSS VSS VDD VDD _1053_ sky130_fd_sc_hd__nor2b_1
X_4986_ _0455_ _1053_ VSS VSS VDD VDD _1054_ sky130_fd_sc_hd__nor2_1
X_4987_ _1050_ _1052_ _1054_ VSS VSS VDD VDD _1055_ sky130_fd_sc_hd__o21ai_0
X_4988_ _1045_ _1051_ _1055_ VSS VSS VDD VDD _1056_ sky130_fd_sc_hd__o21ba_2
Xclkbuf_leaf_44_clk clknet_4_4_0_clk VSS VSS VDD VDD clknet_leaf_44_clk
+ sky130_fd_sc_hd__clkbuf_16
X_4990_ _0343_ _0209_ VSS VSS VDD VDD _1058_ sky130_fd_sc_hd__nand2b_1
Xclkbuf_leaf_43_clk clknet_4_4_0_clk VSS VSS VDD VDD clknet_leaf_43_clk
+ sky130_fd_sc_hd__clkbuf_16
X_4992_ _0350_ _0349_ VSS VSS VDD VDD _1060_ sky130_fd_sc_hd__nand2b_1
X_4993_ _0141_ _1060_ _0140_ VSS VSS VDD VDD _1061_ sky130_fd_sc_hd__a21oi_1
X_4994_ _0209_ _0344_ _0208_ VSS VSS VDD VDD _1062_ sky130_fd_sc_hd__a21oi_1
X_4995_ _1058_ _1061_ _1062_ VSS VSS VDD VDD _1063_ sky130_fd_sc_hd__o21ai_0
X_4996_ _0144_ VSS VSS VDD VDD _1064_ sky130_fd_sc_hd__inv_1
X_4997_ _0213_ _0150_ VSS VSS VDD VDD _1065_ sky130_fd_sc_hd__nand2b_1
X_4998_ _1064_ _0286_ _1065_ VSS VSS VDD VDD _1066_ sky130_fd_sc_hd__or3_1
X_4999_ _0414_ _0138_ VSS VSS VDD VDD _1067_ sky130_fd_sc_hd__nand2b_1
X_5000_ _1066_ _1067_ VSS VSS VDD VDD _1068_ sky130_fd_sc_hd__nor2_1
X_5001_ _1063_ _1068_ VSS VSS VDD VDD _1069_ sky130_fd_sc_hd__nand2_1
X_5002_ _0213_ VSS VSS VDD VDD _1070_ sky130_fd_sc_hd__inv_1
X_5003_ _0150_ _0287_ _0149_ VSS VSS VDD VDD _1071_ sky130_fd_sc_hd__a21o_1
X_5004_ _1070_ _1071_ _0214_ VSS VSS VDD VDD _1072_ sky130_fd_sc_hd__a21oi_1
X_5005_ _0141_ _0350_ _0143_ _0140_ VSS VSS VDD VDD _1073_
+ sky130_fd_sc_hd__a211oi_1
X_5006_ _1064_ _1072_ _1073_ _1062_ VSS VSS VDD VDD _1074_
+ sky130_fd_sc_hd__o211ai_1
X_5007_ _0414_ VSS VSS VDD VDD _1075_ sky130_fd_sc_hd__inv_1
X_5008_ _0137_ _1075_ _0415_ VSS VSS VDD VDD _1076_ sky130_fd_sc_hd__a21oi_1
X_5009_ _1066_ _1076_ VSS VSS VDD VDD _1077_ sky130_fd_sc_hd__nor2_1
X_5010_ _1074_ _1077_ _1063_ VSS VSS VDD VDD _1078_ sky130_fd_sc_hd__o21ai_0
X_5011_ _1056_ _1069_ _1078_ VSS VSS VDD VDD _1079_ sky130_fd_sc_hd__o21ai_1
Xclkbuf_leaf_42_clk clknet_4_4_0_clk VSS VSS VDD VDD clknet_leaf_42_clk
+ sky130_fd_sc_hd__clkbuf_16
X_5013_ _0201_ VSS VSS VDD VDD _1081_ sky130_fd_sc_hd__inv_1
X_5014_ _0111_ VSS VSS VDD VDD _1082_ sky130_fd_sc_hd__inv_1
X_5015_ _0231_ _0218_ _1081_ _1082_ VSS VSS VDD VDD _1083_
+ sky130_fd_sc_hd__nand4_1
X_5016_ _0206_ _0107_ VSS VSS VDD VDD _1084_ sky130_fd_sc_hd__nand2_1
X_5017_ _1083_ _1084_ VSS VSS VDD VDD _1085_ sky130_fd_sc_hd__nor2_1
X_5018_ _1081_ _0112_ _0202_ VSS VSS VDD VDD _1086_ sky130_fd_sc_hd__a21o_1
X_5019_ _0205_ _0218_ _0217_ VSS VSS VDD VDD _1087_ sky130_fd_sc_hd__a21oi_1
X_5020_ _0201_ _0111_ _1087_ _0231_ VSS VSS VDD VDD _1088_
+ sky130_fd_sc_hd__nor4b_1
X_5021_ _0231_ _1086_ _1088_ _0230_ VSS VSS VDD VDD _1089_
+ sky130_fd_sc_hd__a211o_1
X_5022_ _0107_ _1089_ _0106_ VSS VSS VDD VDD _1090_ sky130_fd_sc_hd__a21o_1
X_5023_ net609 _1085_ _1090_ VSS VSS VDD VDD _1091_ sky130_fd_sc_hd__a21o_1
X_5024_ _0116_ _0196_ _0115_ VSS VSS VDD VDD _1092_ sky130_fd_sc_hd__a21oi_1
X_5025_ _0478_ _1092_ VSS VSS VDD VDD _1093_ sky130_fd_sc_hd__nor2_1
X_5026_ _0479_ _1093_ _0194_ VSS VSS VDD VDD _1094_ sky130_fd_sc_hd__o21a_1
X_5027_ _0129_ _0372_ _0128_ VSS VSS VDD VDD _1095_ sky130_fd_sc_hd__a21o_1
X_5028_ _1039_ _1095_ VSS VSS VDD VDD _1096_ sky130_fd_sc_hd__nor2b_1
X_5029_ _1040_ _1091_ _1094_ _1096_ _0193_ VSS VSS VDD VDD
+ _1097_ sky130_fd_sc_hd__a2111oi_0
X_5030_ _0147_ _1097_ VSS VSS VDD VDD _1098_ sky130_fd_sc_hd__xor2_1
X_5031_ is_compare _1013_ _1015_ _1016_ VSS VSS VDD VDD _1099_
+ sky130_fd_sc_hd__nor4_2
X_5032_ net739 net679 VSS VSS VDD VDD _1100_ sky130_fd_sc_hd__and2_1
X_5033_ _1031_ _1034_ _1098_ _1100_ VSS VSS VDD VDD _1101_
+ sky130_fd_sc_hd__a22o_1
X_5034_ net739 _0295_ _1031_ net675 VSS VSS VDD VDD _1102_
+ sky130_fd_sc_hd__nor4_1
X_5035_ _0271_ _0478_ _0299_ VSS VSS VDD VDD _1103_ sky130_fd_sc_hd__and3_1
X_5036_ _0213_ _0323_ VSS VSS VDD VDD _1104_ sky130_fd_sc_hd__nand2_1
Xclkbuf_leaf_41_clk clknet_4_4_0_clk VSS VSS VDD VDD clknet_leaf_41_clk
+ sky130_fd_sc_hd__clkbuf_16
X_5038_ _0315_ _0349_ _0319_ VSS VSS VDD VDD _1106_ sky130_fd_sc_hd__nand3_1
X_5039_ _1104_ _1106_ VSS VSS VDD VDD _1107_ sky130_fd_sc_hd__nor2_1
X_5040_ _0327_ VSS VSS VDD VDD _1108_ sky130_fd_sc_hd__inv_1
X_5041_ _0377_ _0332_ _0379_ VSS VSS VDD VDD _1109_ sky130_fd_sc_hd__a21o_1
X_5042_ _0454_ _1109_ _0456_ VSS VSS VDD VDD _1110_ sky130_fd_sc_hd__a21oi_1
X_5043_ _0335_ _0061_ _0336_ VSS VSS VDD VDD _1111_ sky130_fd_sc_hd__a21o_1
X_5044_ _0466_ _0474_ _0468_ VSS VSS VDD VDD _1112_ sky130_fd_sc_hd__a21o_1
X_5045_ _0466_ _0472_ _1111_ _1112_ VSS VSS VDD VDD _1113_
+ sky130_fd_sc_hd__a31oi_1
X_5046_ _0327_ _0454_ _0377_ _0331_ VSS VSS VDD VDD _1114_
+ sky130_fd_sc_hd__nand4_1
X_5047_ _0416_ _0328_ VSS VSS VDD VDD _1115_ sky130_fd_sc_hd__nor2_1
X_5048_ _1108_ _1110_ _1113_ _1114_ _1115_ VSS VSS VDD VDD
+ _1116_ sky130_fd_sc_hd__o221ai_1
Xclkbuf_leaf_40_clk clknet_4_4_0_clk VSS VSS VDD VDD clknet_leaf_40_clk
+ sky130_fd_sc_hd__clkbuf_16
X_5050_ _0416_ _0414_ _0286_ VSS VSS VDD VDD _1118_ sky130_fd_sc_hd__o21a_1
X_5051_ _0349_ VSS VSS VDD VDD _1119_ sky130_fd_sc_hd__inv_1
X_5052_ _0319_ _0215_ _0320_ VSS VSS VDD VDD _1120_ sky130_fd_sc_hd__a21oi_1
X_5053_ _0323_ _0288_ _0324_ VSS VSS VDD VDD _1121_ sky130_fd_sc_hd__a21oi_1
X_5054_ _0349_ _0319_ _0213_ VSS VSS VDD VDD _1122_ sky130_fd_sc_hd__nand3_1
X_5055_ _0351_ VSS VSS VDD VDD _1123_ sky130_fd_sc_hd__inv_1
X_5056_ _1119_ _1120_ _1121_ _1122_ _1123_ VSS VSS VDD VDD
+ _1124_ sky130_fd_sc_hd__o221ai_1
X_5057_ _0315_ _1124_ _0316_ VSS VSS VDD VDD _1125_ sky130_fd_sc_hd__a21o_1
X_5058_ _1107_ _1116_ _1118_ _1125_ VSS VSS VDD VDD _1126_
+ sky130_fd_sc_hd__a31oi_1
Xclkbuf_leaf_39_clk clknet_4_4_0_clk VSS VSS VDD VDD clknet_leaf_39_clk
+ sky130_fd_sc_hd__clkbuf_16
X_5060_ _0111_ _0311_ _0248_ _0252_ VSS VSS VDD VDD _1128_
+ sky130_fd_sc_hd__and4_1
X_5061_ _1126_ _1128_ _0343_ _0201_ VSS VSS VDD VDD _1129_
+ sky130_fd_sc_hd__nand4b_1
X_5062_ _0252_ _0345_ _0253_ VSS VSS VDD VDD _1130_ sky130_fd_sc_hd__a21o_1
X_5063_ _0248_ _1130_ _0249_ VSS VSS VDD VDD _1131_ sky130_fd_sc_hd__a21o_1
X_5064_ _0311_ _1131_ _0312_ VSS VSS VDD VDD _1132_ sky130_fd_sc_hd__a21oi_1
X_5065_ _0201_ _0113_ _0203_ VSS VSS VDD VDD _1133_ sky130_fd_sc_hd__a21oi_1
X_5066_ _1081_ _1082_ _1132_ _1133_ VSS VSS VDD VDD _1134_
+ sky130_fd_sc_hd__o31ai_1
X_5067_ _0126_ _0308_ _1134_ VSS VSS VDD VDD _1135_ sky130_fd_sc_hd__nor3_1
X_5068_ _0126_ _0308_ _0307_ VSS VSS VDD VDD _1136_ sky130_fd_sc_hd__nor3_1
X_5069_ _0126_ _0125_ VSS VSS VDD VDD _1137_ sky130_fd_sc_hd__nor2_1
X_5070_ _1129_ _1135_ _1136_ _1137_ VSS VSS VDD VDD _1138_
+ sky130_fd_sc_hd__a211o_1
X_5071_ _0256_ _0371_ VSS VSS VDD VDD _1139_ sky130_fd_sc_hd__nand2_1
X_5072_ _0256_ _0373_ _0257_ VSS VSS VDD VDD _1140_ sky130_fd_sc_hd__a21oi_1
X_5073_ _1138_ _1139_ _1140_ VSS VSS VDD VDD _1141_ sky130_fd_sc_hd__o21ai_0
X_5074_ _0303_ _1103_ _1141_ VSS VSS VDD VDD _1142_ sky130_fd_sc_hd__nand3_1
X_5075_ _1034_ _1102_ _1142_ VSS VSS VDD VDD _1143_ sky130_fd_sc_hd__mux2_2
X_5076_ net675 _1026_ _1101_ _1143_ VSS VSS VDD VDD alu_out\[30\]
+ sky130_fd_sc_hd__a211oi_1
X_5077_ _0371_ _0106_ VSS VSS VDD VDD _1144_ sky130_fd_sc_hd__nor2b_1
X_5078_ _0372_ _1144_ _0129_ VSS VSS VDD VDD _1145_ sky130_fd_sc_hd__o21ai_0
X_5079_ _0128_ _1145_ VSS VSS VDD VDD _1146_ sky130_fd_sc_hd__nand2b_1
X_5080_ _0138_ _0455_ _0415_ _0137_ VSS VSS VDD VDD _1147_
+ sky130_fd_sc_hd__a211oi_1
X_5081_ _0415_ _0414_ VSS VSS VDD VDD _1148_ sky130_fd_sc_hd__nor2b_1
X_5082_ _0214_ _0149_ _0287_ VSS VSS VDD VDD _1149_ sky130_fd_sc_hd__nor3_1
X_5083_ _0286_ _1147_ _1148_ _1149_ VSS VSS VDD VDD _1150_
+ sky130_fd_sc_hd__o31ai_1
X_5084_ _0214_ _0149_ _0150_ VSS VSS VDD VDD _1151_ sky130_fd_sc_hd__or3_1
X_5085_ _0214_ _1070_ _1150_ _1151_ VSS VSS VDD VDD _1152_
+ sky130_fd_sc_hd__o211ai_1
X_5086_ _0102_ _0056_ VSS VSS VDD VDD _1153_ sky130_fd_sc_hd__nor2_1
X_5087_ _0279_ _0280_ _0472_ VSS VSS VDD VDD _1154_ sky130_fd_sc_hd__o21ba_2
X_5088_ _0279_ _0492_ _1153_ _1154_ VSS VSS VDD VDD _1155_
+ sky130_fd_sc_hd__o31a_1
X_5089_ _0235_ _0467_ _0473_ VSS VSS VDD VDD _1156_ sky130_fd_sc_hd__or3_1
X_5090_ _0235_ _0467_ VSS VSS VDD VDD _1157_ sky130_fd_sc_hd__nor2_1
X_5091_ _0235_ _0236_ VSS VSS VDD VDD _1158_ sky130_fd_sc_hd__nor2_1
X_5092_ _0466_ _1157_ _1158_ VSS VSS VDD VDD _1159_ sky130_fd_sc_hd__a21oi_1
X_5093_ _0286_ _1065_ _1050_ _1067_ VSS VSS VDD VDD _1160_
+ sky130_fd_sc_hd__nor4_1
X_5094_ _1155_ _1156_ _1159_ _1160_ VSS VSS VDD VDD _1161_
+ sky130_fd_sc_hd__o211ai_1
X_5095_ _0286_ _1067_ VSS VSS VDD VDD _1162_ sky130_fd_sc_hd__nor2_1
X_5096_ _0150_ _1070_ _1053_ _1162_ VSS VSS VDD VDD _1163_
+ sky130_fd_sc_hd__nand4_1
X_5097_ _1152_ _1161_ _1163_ VSS VSS VDD VDD _1164_ sky130_fd_sc_hd__nand3_1
X_5098_ _0141_ _0143_ VSS VSS VDD VDD _1165_ sky130_fd_sc_hd__nand2_1
X_5099_ _0141_ _0350_ _0140_ VSS VSS VDD VDD _1166_ sky130_fd_sc_hd__a21oi_1
X_5100_ _0349_ _1165_ _1166_ VSS VSS VDD VDD _1167_ sky130_fd_sc_hd__o21ai_0
X_5101_ _0205_ VSS VSS VDD VDD _1168_ sky130_fd_sc_hd__inv_1
X_5102_ _1167_ _1168_ _1062_ VSS VSS VDD VDD _1169_ sky130_fd_sc_hd__nand3b_1
X_5103_ _0349_ _0141_ VSS VSS VDD VDD _1170_ sky130_fd_sc_hd__nor2b_1
X_5104_ _0144_ _1170_ _1167_ VSS VSS VDD VDD _1171_ sky130_fd_sc_hd__a21oi_1
X_5105_ _1058_ _1171_ _1168_ _1062_ VSS VSS VDD VDD _1172_
+ sky130_fd_sc_hd__o211ai_1
X_5106_ _0206_ _0205_ _1164_ _1169_ _1172_ VSS VSS VDD VDD
+ _1173_ sky130_fd_sc_hd__o221ai_1
X_5107_ _1082_ _0217_ _0112_ VSS VSS VDD VDD _1174_ sky130_fd_sc_hd__a21oi_1
X_5108_ _0201_ _1174_ _0202_ VSS VSS VDD VDD _1175_ sky130_fd_sc_hd__o21bai_1
X_5109_ _0231_ _1175_ _0230_ VSS VSS VDD VDD _1176_ sky130_fd_sc_hd__a21oi_1
X_5110_ _1083_ _1173_ _1176_ VSS VSS VDD VDD _1177_ sky130_fd_sc_hd__o21ai_1
X_5111_ _0371_ _0129_ VSS VSS VDD VDD _1178_ sky130_fd_sc_hd__nor2b_1
X_5112_ _0197_ _0107_ _1178_ VSS VSS VDD VDD _1179_ sky130_fd_sc_hd__and3_1
X_5113_ _0197_ _1146_ _1177_ _1179_ _0196_ VSS VSS VDD VDD
+ _1180_ sky130_fd_sc_hd__a221o_1
X_5114_ _1027_ _0115_ _0479_ VSS VSS VDD VDD _1181_ sky130_fd_sc_hd__a21o_1
X_5115_ _0116_ _1027_ _1180_ _1181_ VSS VSS VDD VDD _1182_
+ sky130_fd_sc_hd__a31oi_1
X_5116_ _0194_ _1182_ VSS VSS VDD VDD _1183_ sky130_fd_sc_hd__xor2_1
Xclkbuf_leaf_38_clk clknet_4_1_0_clk VSS VSS VDD VDD clknet_leaf_38_clk
+ sky130_fd_sc_hd__clkbuf_16
Xclkbuf_leaf_37_clk clknet_4_1_0_clk VSS VSS VDD VDD clknet_leaf_37_clk
+ sky130_fd_sc_hd__clkbuf_16
Xclkbuf_leaf_36_clk clknet_4_1_0_clk VSS VSS VDD VDD clknet_leaf_36_clk
+ sky130_fd_sc_hd__clkbuf_16
X_5120_ _0270_ net694 VSS VSS VDD VDD _1187_ sky130_fd_sc_hd__nor2_1
X_5121_ _0271_ _1013_ _1016_ _0272_ _1187_ VSS VSS VDD VDD
+ _1188_ sky130_fd_sc_hd__a221oi_1
Xclkbuf_leaf_35_clk clknet_4_1_0_clk VSS VSS VDD VDD clknet_leaf_35_clk
+ sky130_fd_sc_hd__clkbuf_16
Xclkbuf_leaf_34_clk clknet_4_1_0_clk VSS VSS VDD VDD clknet_leaf_34_clk
+ sky130_fd_sc_hd__clkbuf_16
X_5124_ _0286_ _0416_ _0288_ VSS VSS VDD VDD _1191_ sky130_fd_sc_hd__a21oi_1
X_5125_ _0327_ _0456_ _0328_ VSS VSS VDD VDD _1192_ sky130_fd_sc_hd__a21oi_1
X_5126_ _1191_ _1192_ VSS VSS VDD VDD _1193_ sky130_fd_sc_hd__nand2_1
X_5127_ _0377_ _0332_ _0379_ VSS VSS VDD VDD _1194_ sky130_fd_sc_hd__a21oi_1
X_5128_ _0102_ _0060_ _0336_ _0493_ VSS VSS VDD VDD _1195_
+ sky130_fd_sc_hd__a211o_1
X_5129_ _0336_ _0335_ _0466_ _0472_ VSS VSS VDD VDD _1196_
+ sky130_fd_sc_hd__o211a_1
X_5130_ _1195_ _1196_ _1112_ VSS VSS VDD VDD _1197_ sky130_fd_sc_hd__a21oi_1
X_5131_ _0332_ _0331_ _0377_ VSS VSS VDD VDD _1198_ sky130_fd_sc_hd__o21a_1
X_5132_ _0379_ _1198_ _0327_ _0454_ VSS VSS VDD VDD _1199_
+ sky130_fd_sc_hd__o211ai_1
X_5133_ _1194_ _1197_ _1199_ VSS VSS VDD VDD _1200_ sky130_fd_sc_hd__a21oi_1
X_5134_ _0343_ _0315_ _0349_ _0319_ VSS VSS VDD VDD _1201_
+ sky130_fd_sc_hd__and4_1
X_5135_ _1128_ _1201_ VSS VSS VDD VDD _1202_ sky130_fd_sc_hd__and2_1
X_5136_ _0288_ _1118_ VSS VSS VDD VDD _1203_ sky130_fd_sc_hd__nor2_1
X_5137_ _1104_ _1203_ VSS VSS VDD VDD _1204_ sky130_fd_sc_hd__nor2_1
X_5138_ _1193_ _1200_ _1202_ _1204_ VSS VSS VDD VDD _1205_
+ sky130_fd_sc_hd__o211ai_1
X_5139_ _0213_ _0324_ _0215_ VSS VSS VDD VDD _1206_ sky130_fd_sc_hd__a21o_1
X_5140_ _0343_ _0315_ VSS VSS VDD VDD _1207_ sky130_fd_sc_hd__nand2_1
X_5141_ _0349_ _0320_ _0351_ VSS VSS VDD VDD _1208_ sky130_fd_sc_hd__a21oi_1
X_5142_ _0343_ _0316_ _0345_ VSS VSS VDD VDD _1209_ sky130_fd_sc_hd__a21oi_1
X_5143_ _1207_ _1208_ _1209_ VSS VSS VDD VDD _1210_ sky130_fd_sc_hd__o21ai_0
X_5144_ _0111_ _0311_ VSS VSS VDD VDD _1211_ sky130_fd_sc_hd__nand2_1
X_5145_ _0248_ _0253_ _0249_ VSS VSS VDD VDD _1212_ sky130_fd_sc_hd__a21oi_1
X_5146_ _0111_ _0312_ _0113_ VSS VSS VDD VDD _1213_ sky130_fd_sc_hd__a21oi_1
X_5147_ _1211_ _1212_ _1213_ VSS VSS VDD VDD _1214_ sky130_fd_sc_hd__o21ai_0
X_5148_ _1202_ _1206_ _1210_ _1128_ _1214_ VSS VSS VDD VDD
+ _1215_ sky130_fd_sc_hd__a221oi_1
X_5149_ _0308_ _0203_ _1215_ VSS VSS VDD VDD _1216_ sky130_fd_sc_hd__nor3b_1
X_5150_ _0203_ _0201_ _0307_ VSS VSS VDD VDD _1217_ sky130_fd_sc_hd__o21a_1
X_5151_ _0308_ _1217_ VSS VSS VDD VDD _1218_ sky130_fd_sc_hd__nor2_1
X_5152_ _1205_ _1216_ _1218_ VSS VSS VDD VDD _1219_ sky130_fd_sc_hd__a21oi_1
X_5153_ _0303_ _0256_ VSS VSS VDD VDD _1220_ sky130_fd_sc_hd__and2_1
X_5154_ _0371_ _0126_ _0373_ VSS VSS VDD VDD _1221_ sky130_fd_sc_hd__a21oi_1
X_5155_ _1221_ _1220_ VSS VSS VDD VDD _1222_ sky130_fd_sc_hd__nor2b_1
X_5156_ _0371_ _0125_ _1219_ _1220_ _1222_ VSS VSS VDD VDD
+ _1223_ sky130_fd_sc_hd__a41oi_1
X_5157_ _0303_ _0257_ VSS VSS VDD VDD _1224_ sky130_fd_sc_hd__nand2_1
X_5158_ _0304_ _1224_ VSS VSS VDD VDD _1225_ sky130_fd_sc_hd__nand2b_1
X_5159_ _0480_ _0300_ _1225_ VSS VSS VDD VDD _1226_ sky130_fd_sc_hd__nor3_1
X_5160_ _0480_ _0300_ _0299_ VSS VSS VDD VDD _1227_ sky130_fd_sc_hd__nor3_1
X_5161_ _0480_ _0478_ VSS VSS VDD VDD _1228_ sky130_fd_sc_hd__nor2_1
X_5162_ _1223_ _1226_ _1227_ _1228_ VSS VSS VDD VDD _1229_
+ sky130_fd_sc_hd__a211o_1
X_5163_ _0271_ _1229_ VSS VSS VDD VDD _1230_ sky130_fd_sc_hd__xnor2_1
Xclkbuf_leaf_33_clk clknet_4_1_0_clk VSS VSS VDD VDD clknet_leaf_33_clk
+ sky130_fd_sc_hd__clkbuf_16
X_5165_ net739 _1230_ net679 VSS VSS VDD VDD _1232_ sky130_fd_sc_hd__o21ai_0
X_5166_ _1100_ _1183_ _1188_ _1232_ VSS VSS VDD VDD alu_out\[29\]
+ sky130_fd_sc_hd__a22oi_1
Xclkbuf_leaf_32_clk clknet_4_1_0_clk VSS VSS VDD VDD clknet_leaf_32_clk
+ sky130_fd_sc_hd__clkbuf_16
X_5168_ _0299_ _1225_ net739 _0300_ VSS VSS VDD VDD _1234_
+ sky130_fd_sc_hd__a211oi_1
X_5169_ _1138_ _1220_ _0299_ _0371_ VSS VSS VDD VDD _1235_
+ sky130_fd_sc_hd__nand4b_1
X_5170_ _0299_ _0373_ _1220_ VSS VSS VDD VDD _1236_ sky130_fd_sc_hd__nand3_1
X_5171_ _0197_ _1095_ _0196_ VSS VSS VDD VDD _1237_ sky130_fd_sc_hd__a21o_1
X_5172_ _0116_ _1237_ _0115_ VSS VSS VDD VDD _1238_ sky130_fd_sc_hd__a21o_1
X_5173_ _0116_ _0197_ _1178_ _1091_ _1238_ VSS VSS VDD VDD
+ _1239_ sky130_fd_sc_hd__a41o_1
Xclkbuf_leaf_31_clk clknet_4_4_0_clk VSS VSS VDD VDD clknet_leaf_31_clk
+ sky130_fd_sc_hd__clkbuf_16
X_5175_ _1234_ _1235_ _1236_ _1239_ net739 VSS VSS VDD VDD
+ _1241_ sky130_fd_sc_hd__a32oi_1
X_5176_ _0478_ _1241_ VSS VSS VDD VDD _1242_ sky130_fd_sc_hd__xnor2_1
Xclkbuf_leaf_30_clk clknet_4_4_0_clk VSS VSS VDD VDD clknet_leaf_30_clk
+ sky130_fd_sc_hd__clkbuf_16
X_5178_ _0477_ net694 VSS VSS VDD VDD _1244_ sky130_fd_sc_hd__nor2_1
X_5179_ _0478_ _1013_ _1016_ _0480_ _1244_ VSS VSS VDD VDD
+ _1245_ sky130_fd_sc_hd__a221oi_1
X_5180_ net675 _1242_ _1245_ VSS VSS VDD VDD alu_out\[28\]
+ sky130_fd_sc_hd__o21ai_0
X_5181_ _0298_ net694 VSS VSS VDD VDD _1246_ sky130_fd_sc_hd__nor2_1
X_5182_ _0299_ _1013_ _1016_ _0300_ _1246_ VSS VSS VDD VDD
+ _1247_ sky130_fd_sc_hd__a221o_1
X_5183_ _0116_ _1180_ VSS VSS VDD VDD _1248_ sky130_fd_sc_hd__xnor2_1
Xclkbuf_leaf_29_clk clknet_4_6_0_clk VSS VSS VDD VDD clknet_leaf_29_clk
+ sky130_fd_sc_hd__clkbuf_16
X_5185_ net739 _1248_ net675 VSS VSS VDD VDD _1250_ sky130_fd_sc_hd__a21oi_1
X_5186_ _1225_ _1223_ VSS VSS VDD VDD _1251_ sky130_fd_sc_hd__nand2b_1
X_5187_ _0299_ _1251_ VSS VSS VDD VDD _1252_ sky130_fd_sc_hd__xnor2_1
Xclkbuf_leaf_28_clk clknet_4_6_0_clk VSS VSS VDD VDD clknet_leaf_28_clk
+ sky130_fd_sc_hd__clkbuf_16
X_5189_ net739 net675 VSS VSS VDD VDD _1254_ sky130_fd_sc_hd__nor2_1
X_5190_ _1247_ _1250_ _1252_ _1254_ VSS VSS VDD VDD alu_out\[27\]
+ sky130_fd_sc_hd__a2bb2oi_1
X_5191_ _0303_ _1141_ VSS VSS VDD VDD _1255_ sky130_fd_sc_hd__xnor2_1
X_5192_ _1178_ _1091_ _1095_ VSS VSS VDD VDD _1256_ sky130_fd_sc_hd__a21oi_1
X_5193_ _0197_ _1256_ VSS VSS VDD VDD _1257_ sky130_fd_sc_hd__xor2_1
X_5194_ _0304_ _1016_ VSS VSS VDD VDD _1258_ sky130_fd_sc_hd__nand2_1
X_5195_ _0302_ net694 _1258_ VSS VSS VDD VDD _1259_ sky130_fd_sc_hd__o21ai_0
X_5196_ _0303_ _1013_ net679 _1259_ VSS VSS VDD VDD _1260_
+ sky130_fd_sc_hd__a211oi_1
X_5197_ _1254_ _1255_ _1257_ _1100_ _1260_ VSS VSS VDD VDD
+ alu_out\[26\] sky130_fd_sc_hd__a221oi_1
X_5198_ _0255_ net694 VSS VSS VDD VDD _1261_ sky130_fd_sc_hd__nor2_1
X_5199_ _0256_ _1013_ _1016_ _0257_ _1261_ VSS VSS VDD VDD
+ _1262_ sky130_fd_sc_hd__a221oi_1
Xclkbuf_leaf_27_clk clknet_4_3_0_clk VSS VSS VDD VDD clknet_leaf_27_clk
+ sky130_fd_sc_hd__clkbuf_16
X_5201_ _0107_ _1036_ _1177_ _1144_ _0372_ VSS VSS VDD VDD
+ _1264_ sky130_fd_sc_hd__a311oi_1
X_5202_ _0129_ _1264_ VSS VSS VDD VDD _1265_ sky130_fd_sc_hd__xnor2_1
X_5203_ _1221_ VSS VSS VDD VDD _1266_ sky130_fd_sc_hd__inv_1
X_5204_ _0371_ _0125_ _1219_ _1266_ VSS VSS VDD VDD _1267_
+ sky130_fd_sc_hd__a31oi_1
X_5205_ _0256_ _1267_ VSS VSS VDD VDD _1268_ sky130_fd_sc_hd__xor2_1
X_5206_ net739 _1268_ VSS VSS VDD VDD _1269_ sky130_fd_sc_hd__nor2_1
X_5207_ net739 _1265_ _1269_ net675 VSS VSS VDD VDD _1270_
+ sky130_fd_sc_hd__a211oi_1
X_5208_ net675 _1262_ _1270_ VSS VSS VDD VDD alu_out\[25\]
+ sky130_fd_sc_hd__a21oi_1
X_5209_ _1138_ _1091_ net739 VSS VSS VDD VDD _1271_ sky130_fd_sc_hd__mux2i_1
X_5210_ _0371_ _1271_ VSS VSS VDD VDD _1272_ sky130_fd_sc_hd__xnor2_1
Xclkbuf_leaf_26_clk clknet_4_3_0_clk VSS VSS VDD VDD clknet_leaf_26_clk
+ sky130_fd_sc_hd__clkbuf_16
Xclkbuf_leaf_25_clk clknet_4_6_0_clk VSS VSS VDD VDD clknet_leaf_25_clk
+ sky130_fd_sc_hd__clkbuf_16
X_5213_ _0370_ net694 VSS VSS VDD VDD _1275_ sky130_fd_sc_hd__nor2_1
X_5214_ _0371_ _1013_ _1016_ _0373_ _1275_ VSS VSS VDD VDD
+ _1276_ sky130_fd_sc_hd__a221oi_1
X_5215_ net675 _1272_ _1276_ VSS VSS VDD VDD alu_out\[24\]
+ sky130_fd_sc_hd__o21ai_0
X_5216_ _0107_ _1177_ VSS VSS VDD VDD _1277_ sky130_fd_sc_hd__xor2_1
X_5217_ _0125_ _1219_ VSS VSS VDD VDD _1278_ sky130_fd_sc_hd__xnor2_1
X_5218_ net739 _1278_ VSS VSS VDD VDD _1279_ sky130_fd_sc_hd__nor2_1
X_5219_ net739 _1277_ _1279_ VSS VSS VDD VDD _1280_ sky130_fd_sc_hd__a21oi_1
X_5220_ _0124_ net694 VSS VSS VDD VDD _1281_ sky130_fd_sc_hd__nor2_1
X_5221_ _0125_ _1013_ _1016_ _0126_ _1281_ VSS VSS VDD VDD
+ _1282_ sky130_fd_sc_hd__a221oi_1
X_5222_ net675 _1280_ _1282_ VSS VSS VDD VDD alu_out\[23\]
+ sky130_fd_sc_hd__o21ai_0
X_5223_ _0206_ net609 _0205_ VSS VSS VDD VDD _1283_ sky130_fd_sc_hd__a21o_1
X_5224_ _0218_ _1283_ _0217_ VSS VSS VDD VDD _1284_ sky130_fd_sc_hd__a21oi_1
X_5225_ _0111_ _1284_ VSS VSS VDD VDD _1285_ sky130_fd_sc_hd__or2_2
X_5226_ _0231_ net739 VSS VSS VDD VDD _1286_ sky130_fd_sc_hd__nand2b_1
X_5227_ _0202_ _1081_ _0231_ VSS VSS VDD VDD _1287_ sky130_fd_sc_hd__o21ai_0
X_5228_ _0231_ _1086_ _1287_ net739 VSS VSS VDD VDD _1288_
+ sky130_fd_sc_hd__o211ai_1
X_5229_ _0202_ _0112_ VSS VSS VDD VDD _1289_ sky130_fd_sc_hd__nor2_1
X_5230_ _0111_ _1284_ _1289_ _0231_ net739 VSS VSS VDD VDD
+ _1290_ sky130_fd_sc_hd__o2111ai_1
X_5231_ _0201_ _1285_ _1286_ _1288_ _1290_ VSS VSS VDD VDD
+ _1291_ sky130_fd_sc_hd__o311ai_1
X_5232_ _1134_ _1129_ VSS VSS VDD VDD _1292_ sky130_fd_sc_hd__nand2b_1
X_5233_ _0307_ _1292_ VSS VSS VDD VDD _1293_ sky130_fd_sc_hd__xnor2_1
X_5234_ net739 _1293_ net679 VSS VSS VDD VDD _1294_ sky130_fd_sc_hd__o21ai_0
X_5235_ _0306_ net694 VSS VSS VDD VDD _1295_ sky130_fd_sc_hd__nor2_1
X_5236_ _0307_ _1013_ _1016_ _0308_ _1295_ VSS VSS VDD VDD
+ _1296_ sky130_fd_sc_hd__a221oi_1
X_5237_ _1291_ _1294_ _1296_ net675 VSS VSS VDD VDD alu_out\[22\]
+ sky130_fd_sc_hd__a2bb2oi_1
X_5238_ _0112_ VSS VSS VDD VDD _1297_ sky130_fd_sc_hd__inv_1
X_5239_ _1173_ _0218_ VSS VSS VDD VDD _1298_ sky130_fd_sc_hd__nor2b_1
X_5240_ _0217_ _1298_ _1082_ VSS VSS VDD VDD _1299_ sky130_fd_sc_hd__o21ai_0
X_5241_ _1205_ _1215_ net739 VSS VSS VDD VDD _1300_ sky130_fd_sc_hd__a21oi_1
X_5242_ net739 _1297_ _1299_ _1300_ VSS VSS VDD VDD _1301_
+ sky130_fd_sc_hd__a31oi_1
X_5243_ _1081_ _1301_ VSS VSS VDD VDD _1302_ sky130_fd_sc_hd__xnor2_1
X_5244_ _0200_ net694 VSS VSS VDD VDD _1303_ sky130_fd_sc_hd__nor2_1
X_5245_ _0201_ _1013_ _1016_ _0203_ _1303_ VSS VSS VDD VDD
+ _1304_ sky130_fd_sc_hd__a221oi_1
X_5246_ net675 _1302_ _1304_ VSS VSS VDD VDD alu_out\[21\]
+ sky130_fd_sc_hd__o21ai_0
X_5247_ _0311_ _0248_ _0252_ _0343_ VSS VSS VDD VDD _1305_
+ sky130_fd_sc_hd__nand4_1
X_5248_ _1126_ _1305_ _1132_ VSS VSS VDD VDD _1306_ sky130_fd_sc_hd__o21ai_0
X_5249_ _1306_ _1284_ net739 VSS VSS VDD VDD _1307_ sky130_fd_sc_hd__mux2i_1
X_5250_ _1082_ _1307_ VSS VSS VDD VDD _1308_ sky130_fd_sc_hd__xnor2_1
X_5251_ _0110_ net694 VSS VSS VDD VDD _1309_ sky130_fd_sc_hd__nor2_1
X_5252_ _0111_ _1013_ _1016_ _0113_ _1309_ VSS VSS VDD VDD
+ _1310_ sky130_fd_sc_hd__a221oi_1
X_5253_ net675 _1308_ _1310_ VSS VSS VDD VDD alu_out\[20\]
+ sky130_fd_sc_hd__o21ai_0
X_5254_ _0248_ _0252_ VSS VSS VDD VDD _1311_ sky130_fd_sc_hd__nand2_1
X_5255_ _1193_ _1200_ _1204_ VSS VSS VDD VDD _1312_ sky130_fd_sc_hd__o21ai_0
X_5256_ _1206_ _1312_ VSS VSS VDD VDD _1313_ sky130_fd_sc_hd__nand2b_1
X_5257_ _1201_ _1313_ _1210_ VSS VSS VDD VDD _1314_ sky130_fd_sc_hd__a21oi_1
X_5258_ _1311_ _1314_ _1212_ VSS VSS VDD VDD _1315_ sky130_fd_sc_hd__o21ai_0
X_5259_ _0311_ _1315_ VSS VSS VDD VDD _1316_ sky130_fd_sc_hd__xor2_1
X_5260_ _0218_ _1173_ VSS VSS VDD VDD _1317_ sky130_fd_sc_hd__nor2b_1
X_5261_ _1298_ _1317_ net739 VSS VSS VDD VDD _1318_ sky130_fd_sc_hd__o21ai_0
X_5262_ net739 _1316_ _1318_ VSS VSS VDD VDD _1319_ sky130_fd_sc_hd__o21ai_0
X_5263_ _0312_ _1016_ VSS VSS VDD VDD _1320_ sky130_fd_sc_hd__nand2_1
X_5264_ _0310_ net694 _1320_ VSS VSS VDD VDD _1321_ sky130_fd_sc_hd__o21ai_0
X_5265_ _0311_ _1013_ net679 _1321_ VSS VSS VDD VDD _1322_
+ sky130_fd_sc_hd__a211oi_1
X_5266_ net679 _1319_ _1322_ VSS VSS VDD VDD alu_out\[19\]
+ sky130_fd_sc_hd__a21oi_1
X_5267_ _0247_ net694 VSS VSS VDD VDD _1323_ sky130_fd_sc_hd__nor2_1
X_5268_ _0248_ _1013_ _1016_ _0249_ _1323_ VSS VSS VDD VDD
+ _1324_ sky130_fd_sc_hd__a221oi_1
X_5269_ _0252_ _0343_ VSS VSS VDD VDD _1325_ sky130_fd_sc_hd__nand2_1
X_5270_ _1126_ _1325_ _1130_ VSS VSS VDD VDD _1326_ sky130_fd_sc_hd__o21bai_1
X_5271_ _0248_ _1326_ VSS VSS VDD VDD _1327_ sky130_fd_sc_hd__xor2_1
X_5272_ _0206_ net609 VSS VSS VDD VDD _1328_ sky130_fd_sc_hd__xnor2_1
X_5273_ net739 _1328_ net675 VSS VSS VDD VDD _1329_ sky130_fd_sc_hd__a21oi_1
X_5274_ net739 _1327_ _1329_ VSS VSS VDD VDD _1330_ sky130_fd_sc_hd__o21ai_0
X_5275_ _1324_ _1330_ VSS VSS VDD VDD alu_out\[18\] sky130_fd_sc_hd__nand2_1
X_5276_ _0251_ net694 VSS VSS VDD VDD _1331_ sky130_fd_sc_hd__nor2_1
X_5277_ _0252_ _1013_ _1016_ _0253_ _1331_ VSS VSS VDD VDD
+ _1332_ sky130_fd_sc_hd__a221oi_1
X_5278_ _0144_ _1170_ _1164_ _1167_ VSS VSS VDD VDD _1333_
+ sky130_fd_sc_hd__a31oi_1
X_5279_ _0343_ _1333_ VSS VSS VDD VDD _1334_ sky130_fd_sc_hd__nor2_1
X_5280_ _0344_ _1334_ VSS VSS VDD VDD _1335_ sky130_fd_sc_hd__nor2_1
X_5281_ _0209_ _1335_ VSS VSS VDD VDD _1336_ sky130_fd_sc_hd__xnor2_1
X_5282_ _0252_ _1314_ VSS VSS VDD VDD _1337_ sky130_fd_sc_hd__xor2_1
X_5283_ net739 _1337_ net679 VSS VSS VDD VDD _1338_ sky130_fd_sc_hd__o21ai_0
X_5284_ net739 _1336_ _1338_ VSS VSS VDD VDD _1339_ sky130_fd_sc_hd__a21oi_1
X_5285_ net675 _1332_ _1339_ VSS VSS VDD VDD alu_out\[17\]
+ sky130_fd_sc_hd__a21oi_1
X_5286_ _0287_ VSS VSS VDD VDD _1340_ sky130_fd_sc_hd__inv_1
X_5287_ _0286_ _1076_ _1340_ VSS VSS VDD VDD _1341_ sky130_fd_sc_hd__o21ai_0
X_5288_ _0150_ _1341_ _0149_ VSS VSS VDD VDD _1342_ sky130_fd_sc_hd__a21oi_1
X_5289_ _0213_ _1342_ VSS VSS VDD VDD _1343_ sky130_fd_sc_hd__nor2_1
X_5290_ _0214_ _1343_ _0144_ VSS VSS VDD VDD _1344_ sky130_fd_sc_hd__o21a_1
X_5291_ _0350_ _0143_ _1344_ _1060_ _0141_ VSS VSS VDD VDD
+ _1345_ sky130_fd_sc_hd__o311ai_0
X_5292_ _1045_ _1051_ _1055_ VSS VSS VDD VDD _1346_ sky130_fd_sc_hd__o21bai_1
X_5293_ _1066_ _1067_ _1170_ VSS VSS VDD VDD _1347_ sky130_fd_sc_hd__nor3b_1
X_5294_ _1346_ _1347_ _0140_ VSS VSS VDD VDD _1348_ sky130_fd_sc_hd__a21oi_1
X_5295_ net739 _1126_ VSS VSS VDD VDD _1349_ sky130_fd_sc_hd__nor2_1
X_5296_ net739 _1345_ _1348_ _1349_ VSS VSS VDD VDD _1350_
+ sky130_fd_sc_hd__a31oi_1
X_5297_ _0343_ _1350_ VSS VSS VDD VDD _1351_ sky130_fd_sc_hd__xor2_1
X_5298_ _0342_ net694 VSS VSS VDD VDD _1352_ sky130_fd_sc_hd__nor2_1
X_5299_ _0343_ _1013_ _1016_ _0345_ _1352_ VSS VSS VDD VDD
+ _1353_ sky130_fd_sc_hd__a221oi_1
X_5300_ net675 _1351_ _1353_ VSS VSS VDD VDD alu_out\[16\]
+ sky130_fd_sc_hd__o21ai_0
X_5301_ _0319_ _1313_ _0320_ VSS VSS VDD VDD _1354_ sky130_fd_sc_hd__a21o_1
X_5302_ _0349_ _1354_ _0351_ VSS VSS VDD VDD _1355_ sky130_fd_sc_hd__a21oi_1
X_5303_ _0315_ _1355_ VSS VSS VDD VDD _1356_ sky130_fd_sc_hd__xnor2_1
X_5304_ _0144_ _1164_ _0143_ VSS VSS VDD VDD _1357_ sky130_fd_sc_hd__a21oi_1
X_5305_ _0349_ _1357_ _0350_ VSS VSS VDD VDD _1358_ sky130_fd_sc_hd__o21bai_1
X_5306_ _0141_ _1358_ VSS VSS VDD VDD _1359_ sky130_fd_sc_hd__xnor2_1
X_5307_ net739 _1359_ VSS VSS VDD VDD _1360_ sky130_fd_sc_hd__nand2_1
X_5308_ net739 _1356_ _1360_ VSS VSS VDD VDD _1361_ sky130_fd_sc_hd__o21ai_0
X_5309_ _0316_ _1016_ VSS VSS VDD VDD _1362_ sky130_fd_sc_hd__nand2_1
X_5310_ _0314_ net694 _1362_ VSS VSS VDD VDD _1363_ sky130_fd_sc_hd__o21ai_0
X_5311_ _0315_ _1013_ net679 _1363_ VSS VSS VDD VDD _1364_
+ sky130_fd_sc_hd__a211oi_1
X_5312_ net679 _1361_ _1364_ VSS VSS VDD VDD alu_out\[15\]
+ sky130_fd_sc_hd__a21oi_1
X_5313_ _0319_ _0213_ VSS VSS VDD VDD _1365_ sky130_fd_sc_hd__nand2_1
X_5314_ _1116_ _1118_ _0288_ VSS VSS VDD VDD _1366_ sky130_fd_sc_hd__a21o_1
X_5315_ _0323_ _1366_ _0324_ VSS VSS VDD VDD _1367_ sky130_fd_sc_hd__a21oi_1
X_5316_ net739 _1365_ _1367_ VSS VSS VDD VDD _1368_ sky130_fd_sc_hd__nor3_1
X_5317_ _0286_ VSS VSS VDD VDD _1369_ sky130_fd_sc_hd__inv_1
X_5318_ _1056_ _1067_ _1076_ VSS VSS VDD VDD _1370_ sky130_fd_sc_hd__o21ai_0
X_5319_ _0150_ _1369_ _1370_ _1071_ VSS VSS VDD VDD _1371_
+ sky130_fd_sc_hd__a31o_2
X_5320_ _0143_ net739 VSS VSS VDD VDD _1372_ sky130_fd_sc_hd__nand2b_1
X_5321_ _1070_ _1371_ _1372_ _0214_ VSS VSS VDD VDD _1373_
+ sky130_fd_sc_hd__a211oi_1
X_5322_ net739 _1120_ _1372_ _0144_ VSS VSS VDD VDD _1374_
+ sky130_fd_sc_hd__o22ai_1
X_5323_ _1368_ _1373_ _1374_ VSS VSS VDD VDD _1375_ sky130_fd_sc_hd__nor3_1
X_5324_ _1119_ _1375_ VSS VSS VDD VDD _1376_ sky130_fd_sc_hd__xnor2_1
X_5325_ _0348_ net694 VSS VSS VDD VDD _1377_ sky130_fd_sc_hd__nor2_1
X_5326_ _0349_ _1013_ _1016_ _0351_ _1377_ VSS VSS VDD VDD
+ _1378_ sky130_fd_sc_hd__a221oi_1
X_5327_ net675 _1376_ _1378_ VSS VSS VDD VDD alu_out\[14\]
+ sky130_fd_sc_hd__o21ai_0
X_5328_ _0318_ net694 VSS VSS VDD VDD _1379_ sky130_fd_sc_hd__nor2_1
X_5329_ _0319_ _1013_ _1016_ _0320_ _1379_ VSS VSS VDD VDD
+ _1380_ sky130_fd_sc_hd__a221oi_1
X_5330_ _1064_ _1164_ VSS VSS VDD VDD _1381_ sky130_fd_sc_hd__xnor2_1
X_5331_ _0319_ _1313_ VSS VSS VDD VDD _1382_ sky130_fd_sc_hd__xnor2_1
X_5332_ net739 _1382_ VSS VSS VDD VDD _1383_ sky130_fd_sc_hd__nor2_1
X_5333_ net739 _1381_ _1383_ net675 VSS VSS VDD VDD _1384_
+ sky130_fd_sc_hd__a211oi_1
X_5334_ net675 _1380_ _1384_ VSS VSS VDD VDD alu_out\[13\]
+ sky130_fd_sc_hd__a21oi_1
X_5335_ _1367_ _1371_ net739 VSS VSS VDD VDD _1385_ sky130_fd_sc_hd__mux2_2
X_5336_ net679 _1385_ _1013_ VSS VSS VDD VDD _1386_ sky130_fd_sc_hd__a21oi_1
X_5337_ _0213_ net675 _1385_ VSS VSS VDD VDD _1387_ sky130_fd_sc_hd__or3_1
X_5338_ _0212_ net694 VSS VSS VDD VDD _1388_ sky130_fd_sc_hd__nor2_1
X_5339_ _0215_ _1016_ _1388_ VSS VSS VDD VDD _1389_ sky130_fd_sc_hd__a21oi_1
X_5340_ _1070_ _1386_ _1387_ _1389_ VSS VSS VDD VDD alu_out\[12\]
+ sky130_fd_sc_hd__o211ai_1
X_5341_ _0322_ net694 VSS VSS VDD VDD _1390_ sky130_fd_sc_hd__nor2_1
X_5342_ _0323_ _1013_ _1016_ _0324_ _1390_ VSS VSS VDD VDD
+ _1391_ sky130_fd_sc_hd__a221oi_1
X_5343_ _0378_ VSS VSS VDD VDD _1392_ sky130_fd_sc_hd__inv_1
X_5344_ _0377_ VSS VSS VDD VDD _1393_ sky130_fd_sc_hd__inv_1
X_5345_ _1155_ _1156_ _1159_ _1393_ VSS VSS VDD VDD _1394_
+ sky130_fd_sc_hd__o211ai_1
X_5346_ _1392_ _1394_ _0454_ VSS VSS VDD VDD _1395_ sky130_fd_sc_hd__a21oi_1
X_5347_ _0286_ _1147_ _1148_ _1340_ VSS VSS VDD VDD _1396_
+ sky130_fd_sc_hd__o31ai_1
X_5348_ _1162_ _1395_ _1396_ VSS VSS VDD VDD _1397_ sky130_fd_sc_hd__a21oi_1
X_5349_ _0150_ _1397_ VSS VSS VDD VDD _1398_ sky130_fd_sc_hd__xnor2_1
X_5350_ _1200_ _1192_ VSS VSS VDD VDD _1399_ sky130_fd_sc_hd__nand2b_1
X_5351_ _0414_ _1399_ _0416_ VSS VSS VDD VDD _1400_ sky130_fd_sc_hd__a21o_1
X_5352_ _0286_ _1400_ _0288_ VSS VSS VDD VDD _1401_ sky130_fd_sc_hd__a21oi_1
X_5353_ _0323_ _1401_ VSS VSS VDD VDD _1402_ sky130_fd_sc_hd__xor2_1
X_5354_ net739 _1402_ VSS VSS VDD VDD _1403_ sky130_fd_sc_hd__nor2_1
X_5355_ net739 _1398_ _1403_ net675 VSS VSS VDD VDD _1404_
+ sky130_fd_sc_hd__a211oi_1
X_5356_ net675 _1391_ _1404_ VSS VSS VDD VDD alu_out\[11\]
+ sky130_fd_sc_hd__a21oi_1
X_5357_ _1108_ _1110_ _1113_ _1114_ VSS VSS VDD VDD _1405_
+ sky130_fd_sc_hd__o22ai_1
X_5358_ _0328_ _1405_ VSS VSS VDD VDD _1406_ sky130_fd_sc_hd__nor2_1
X_5359_ _1075_ _1406_ VSS VSS VDD VDD _1407_ sky130_fd_sc_hd__nor2_1
X_5360_ net739 _0416_ _1407_ VSS VSS VDD VDD _1408_ sky130_fd_sc_hd__nor3_1
X_5361_ net739 _1370_ _1408_ VSS VSS VDD VDD _1409_ sky130_fd_sc_hd__a21oi_1
X_5362_ _0286_ _1409_ VSS VSS VDD VDD _1410_ sky130_fd_sc_hd__xnor2_1
X_5363_ _0285_ net694 VSS VSS VDD VDD _1411_ sky130_fd_sc_hd__nor2_1
X_5364_ _0286_ _1013_ _1016_ _0288_ _1411_ VSS VSS VDD VDD
+ _1412_ sky130_fd_sc_hd__a221oi_1
X_5365_ net675 _1410_ _1412_ VSS VSS VDD VDD alu_out\[10\]
+ sky130_fd_sc_hd__o21ai_0
X_5366_ _0455_ _1395_ _0138_ VSS VSS VDD VDD _1413_ sky130_fd_sc_hd__o21a_1
X_5367_ _0137_ _1413_ net739 VSS VSS VDD VDD _1414_ sky130_fd_sc_hd__o21ai_0
X_5368_ net739 _1399_ _1414_ VSS VSS VDD VDD _1415_ sky130_fd_sc_hd__o21ai_0
X_5369_ _1075_ net675 VSS VSS VDD VDD _1416_ sky130_fd_sc_hd__nor2_1
X_5370_ _0414_ net675 _1415_ VSS VSS VDD VDD _1417_ sky130_fd_sc_hd__nor3_1
X_5371_ _1415_ _1416_ _1417_ VSS VSS VDD VDD _1418_ sky130_fd_sc_hd__a21oi_1
X_5372_ _0414_ _1013_ VSS VSS VDD VDD _1419_ sky130_fd_sc_hd__nand2_1
X_5373_ _0413_ net694 VSS VSS VDD VDD _1420_ sky130_fd_sc_hd__nor2_1
X_5374_ _0416_ _1016_ _1420_ VSS VSS VDD VDD _1421_ sky130_fd_sc_hd__a21oi_1
X_5375_ _1418_ _1419_ _1421_ VSS VSS VDD VDD alu_out\[9\]
+ sky130_fd_sc_hd__nand3_1
X_5376_ _0326_ net694 VSS VSS VDD VDD _1422_ sky130_fd_sc_hd__nor2_1
X_5377_ _0327_ _1013_ _1016_ _0328_ _1422_ VSS VSS VDD VDD
+ _1423_ sky130_fd_sc_hd__a221oi_1
X_5378_ _1113_ VSS VSS VDD VDD _1424_ sky130_fd_sc_hd__inv_1
X_5379_ _0331_ _1424_ _0332_ VSS VSS VDD VDD _1425_ sky130_fd_sc_hd__a21oi_1
X_5380_ _1393_ _1425_ _0379_ VSS VSS VDD VDD _1426_ sky130_fd_sc_hd__o21bai_1
X_5381_ _0454_ _1426_ _0327_ _0456_ VSS VSS VDD VDD _1427_
+ sky130_fd_sc_hd__a211oi_1
X_5382_ _0138_ _1056_ VSS VSS VDD VDD _1428_ sky130_fd_sc_hd__xnor2_1
X_5383_ net739 _1428_ VSS VSS VDD VDD _1429_ sky130_fd_sc_hd__nand2_1
X_5384_ net739 _1405_ _1427_ _1429_ net679 VSS VSS VDD VDD
+ _1430_ sky130_fd_sc_hd__o311a_1
X_5385_ net675 _1423_ _1430_ VSS VSS VDD VDD alu_out\[8\]
+ sky130_fd_sc_hd__a21oi_1
X_5386_ _0377_ _0331_ VSS VSS VDD VDD _1431_ sky130_fd_sc_hd__nand2_1
X_5387_ _1431_ _1197_ _1194_ VSS VSS VDD VDD _1432_ sky130_fd_sc_hd__o21ai_0
X_5388_ _1392_ _1394_ net739 VSS VSS VDD VDD _1433_ sky130_fd_sc_hd__a21boi_0
X_5389_ net739 _1432_ _1433_ VSS VSS VDD VDD _1434_ sky130_fd_sc_hd__o21bai_1
X_5390_ _0454_ _1434_ VSS VSS VDD VDD _1435_ sky130_fd_sc_hd__xor2_1
X_5391_ _0453_ net694 VSS VSS VDD VDD _1436_ sky130_fd_sc_hd__nor2_1
X_5392_ _0454_ _1013_ _1016_ _0456_ _1436_ VSS VSS VDD VDD
+ _1437_ sky130_fd_sc_hd__a221oi_1
X_5393_ net675 _1435_ _1437_ VSS VSS VDD VDD alu_out\[7\]
+ sky130_fd_sc_hd__o21ai_0
X_5394_ _1046_ _0466_ _1045_ _1052_ net739 VSS VSS VDD VDD
+ _1438_ sky130_fd_sc_hd__o311ai_0
X_5395_ net739 _1425_ _1438_ VSS VSS VDD VDD _1439_ sky130_fd_sc_hd__o21ai_0
X_5396_ net679 _1439_ VSS VSS VDD VDD _1440_ sky130_fd_sc_hd__nand2_1
X_5397_ net675 _1439_ VSS VSS VDD VDD _1441_ sky130_fd_sc_hd__nor2_1
X_5398_ _1013_ _1441_ _0377_ VSS VSS VDD VDD _1442_ sky130_fd_sc_hd__o21ai_0
X_5399_ _0376_ net694 VSS VSS VDD VDD _1443_ sky130_fd_sc_hd__nor2_1
X_5400_ _0379_ _1016_ _1443_ VSS VSS VDD VDD _1444_ sky130_fd_sc_hd__a21oi_1
X_5401_ _0377_ _1440_ _1442_ _1444_ VSS VSS VDD VDD alu_out\[6\]
+ sky130_fd_sc_hd__o211ai_1
X_5402_ _0330_ net694 VSS VSS VDD VDD _1445_ sky130_fd_sc_hd__nor2_1
X_5403_ _0331_ _1013_ _1016_ _0332_ _1445_ VSS VSS VDD VDD
+ _1446_ sky130_fd_sc_hd__a221oi_1
X_5404_ _0473_ _1155_ VSS VSS VDD VDD _1447_ sky130_fd_sc_hd__nor2_1
X_5405_ _0466_ _1447_ VSS VSS VDD VDD _1448_ sky130_fd_sc_hd__nor2_1
X_5406_ _0467_ _1448_ VSS VSS VDD VDD _1449_ sky130_fd_sc_hd__nor2_1
X_5407_ _0236_ _1449_ VSS VSS VDD VDD _1450_ sky130_fd_sc_hd__xnor2_1
X_5408_ _0331_ _1197_ VSS VSS VDD VDD _1451_ sky130_fd_sc_hd__xor2_1
X_5409_ net739 _1451_ VSS VSS VDD VDD _1452_ sky130_fd_sc_hd__nor2_1
X_5410_ net739 _1450_ _1452_ net675 VSS VSS VDD VDD _1453_
+ sky130_fd_sc_hd__a211oi_1
X_5411_ net675 _1446_ _1453_ VSS VSS VDD VDD alu_out\[5\]
+ sky130_fd_sc_hd__a21oi_1
X_5412_ _0472_ _1111_ _0474_ VSS VSS VDD VDD _1454_ sky130_fd_sc_hd__a21oi_1
X_5413_ net739 _1454_ VSS VSS VDD VDD _1455_ sky130_fd_sc_hd__nor2_1
X_5414_ net739 _1045_ _1455_ VSS VSS VDD VDD _1456_ sky130_fd_sc_hd__a21oi_1
X_5415_ net679 _1456_ _1013_ VSS VSS VDD VDD _1457_ sky130_fd_sc_hd__a21o_1
X_5416_ _0466_ _1457_ VSS VSS VDD VDD _1458_ sky130_fd_sc_hd__nand2_1
X_5417_ _0465_ net694 VSS VSS VDD VDD _1459_ sky130_fd_sc_hd__nor2_1
X_5418_ _0468_ _1016_ _1459_ VSS VSS VDD VDD _1460_ sky130_fd_sc_hd__a21oi_1
X_5419_ _0466_ net675 _1456_ _1458_ _1460_ VSS VSS VDD VDD
+ alu_out\[4\] sky130_fd_sc_hd__o311ai_0
X_5420_ _0471_ net694 VSS VSS VDD VDD _1461_ sky130_fd_sc_hd__nor2_1
X_5421_ _0472_ _1013_ _1016_ _0474_ _1461_ VSS VSS VDD VDD
+ _1462_ sky130_fd_sc_hd__a221oi_1
X_5422_ _0492_ _1153_ _0280_ VSS VSS VDD VDD _1463_ sky130_fd_sc_hd__o21ai_0
X_5423_ _0102_ _0060_ _0493_ VSS VSS VDD VDD _1464_ sky130_fd_sc_hd__a21o_1
X_5424_ _0335_ _1464_ _0336_ VSS VSS VDD VDD _1465_ sky130_fd_sc_hd__a21oi_1
X_5425_ net739 _1465_ VSS VSS VDD VDD _1466_ sky130_fd_sc_hd__nor2_1
X_5426_ net739 _1041_ _1463_ _1466_ VSS VSS VDD VDD _1467_
+ sky130_fd_sc_hd__a31oi_1
X_5427_ _0472_ _1467_ VSS VSS VDD VDD _1468_ sky130_fd_sc_hd__xnor2_1
X_5428_ net675 _1468_ VSS VSS VDD VDD _1469_ sky130_fd_sc_hd__nor2_1
X_5429_ net675 _1462_ _1469_ VSS VSS VDD VDD alu_out\[3\]
+ sky130_fd_sc_hd__a21oi_1
X_5430_ _0334_ net694 VSS VSS VDD VDD _1470_ sky130_fd_sc_hd__nor2_1
X_5431_ _0335_ _1013_ _1016_ _0336_ _1470_ VSS VSS VDD VDD
+ _1471_ sky130_fd_sc_hd__a221oi_1
X_5432_ _0280_ _0057_ VSS VSS VDD VDD _1472_ sky130_fd_sc_hd__nand2b_1
X_5433_ _0335_ _0061_ VSS VSS VDD VDD _1473_ sky130_fd_sc_hd__xnor2_1
X_5434_ net739 _1473_ VSS VSS VDD VDD _1474_ sky130_fd_sc_hd__nor2_1
X_5435_ net739 _1042_ _1472_ _1474_ net675 VSS VSS VDD VDD
+ _1475_ sky130_fd_sc_hd__a311oi_1
X_5436_ net675 _1471_ _1475_ VSS VSS VDD VDD alu_out\[2\]
+ sky130_fd_sc_hd__a21oi_1
X_5437_ net739 _0058_ VSS VSS VDD VDD _1476_ sky130_fd_sc_hd__nand2_1
X_5438_ net739 _0062_ _1476_ VSS VSS VDD VDD _1477_ sky130_fd_sc_hd__o21ai_0
X_5439_ _0491_ net694 VSS VSS VDD VDD _1478_ sky130_fd_sc_hd__nor2_1
X_5440_ _0102_ _1013_ _1016_ _0493_ _1478_ VSS VSS VDD VDD
+ _1479_ sky130_fd_sc_hd__a221oi_1
X_5441_ net675 _1477_ _1479_ VSS VSS VDD VDD alu_out\[1\]
+ sky130_fd_sc_hd__o21ai_0
X_5442_ _0483_ _0147_ _1178_ VSS VSS VDD VDD _1480_ sky130_fd_sc_hd__nand3_1
X_5443_ _1039_ _1480_ VSS VSS VDD VDD _1481_ sky130_fd_sc_hd__nor2_1
X_5444_ _1085_ _1481_ VSS VSS VDD VDD _1482_ sky130_fd_sc_hd__and2_1
X_5445_ _0472_ _0102_ alu_add_sub\[0\] _0280_ VSS VSS VDD
+ VDD _1483_ sky130_fd_sc_hd__or4b_2
X_5446_ _1058_ _1051_ _1483_ VSS VSS VDD VDD _1484_ sky130_fd_sc_hd__nor3_1
X_5447_ _1347_ _1482_ _1484_ VSS VSS VDD VDD _1485_ sky130_fd_sc_hd__nand3_1
X_5448_ is_slti_blt_slt is_sltiu_bltu_sltu VSS VSS VDD VDD
+ _1486_ sky130_fd_sc_hd__nor2_1
X_5449_ instr_bne instr_bge instr_bgeu VSS VSS VDD VDD _1487_
+ sky130_fd_sc_hd__nor3_1
X_5450_ _1486_ _1487_ VSS VSS VDD VDD _1488_ sky130_fd_sc_hd__nand2_1
X_5451_ _0193_ _1094_ _1096_ _0147_ _0483_ VSS VSS VDD VDD
+ _1489_ sky130_fd_sc_hd__o311a_1
X_5452_ _1090_ _1481_ _1489_ _0482_ VSS VSS VDD VDD _1490_
+ sky130_fd_sc_hd__a211o_1
X_5453_ net609 _1482_ _1490_ VSS VSS VDD VDD _1491_ sky130_fd_sc_hd__a21oi_1
X_5454_ _0483_ _0146_ VSS VSS VDD VDD _1492_ sky130_fd_sc_hd__nand2_1
X_5455_ _1491_ _1492_ VSS VSS VDD VDD _1493_ sky130_fd_sc_hd__nand2_1
X_5456_ is_sltiu_bltu_sltu instr_bgeu _1493_ VSS VSS VDD VDD
+ _1494_ sky130_fd_sc_hd__mux2i_1
X_5457_ _0483_ VSS VSS VDD VDD _1495_ sky130_fd_sc_hd__inv_1
X_5458_ net609 _1482_ _1490_ _0146_ _1495_ VSS VSS VDD VDD
+ _1496_ sky130_fd_sc_hd__a2111oi_0
X_5459_ _1495_ _0482_ _1496_ VSS VSS VDD VDD _1497_ sky130_fd_sc_hd__a21oi_1
X_5460_ is_slti_blt_slt instr_bge _1497_ VSS VSS VDD VDD _1498_
+ sky130_fd_sc_hd__mux2i_1
X_5461_ instr_bne _1485_ VSS VSS VDD VDD _1499_ sky130_fd_sc_hd__nand2_1
X_5462_ _1485_ _1488_ _1494_ _1498_ _1499_ VSS VSS VDD VDD
+ _1500_ sky130_fd_sc_hd__o2111a_1
X_5463_ _0486_ net694 VSS VSS VDD VDD _1501_ sky130_fd_sc_hd__nor2_1
X_5464_ _0060_ _1016_ _1501_ VSS VSS VDD VDD _1502_ sky130_fd_sc_hd__a21oi_1
X_5465_ _1013_ net679 alu_add_sub\[0\] VSS VSS VDD VDD _1503_
+ sky130_fd_sc_hd__o21ai_0
X_5466_ _1012_ _1500_ _1502_ _1503_ VSS VSS VDD VDD alu_out\[0\]
+ sky130_fd_sc_hd__o211ai_1
X_5467_ net738 net736 VSS VSS VDD VDD _1504_ sky130_fd_sc_hd__or2b_1
Xclkbuf_leaf_24_clk clknet_4_3_0_clk VSS VSS VDD VDD clknet_leaf_24_clk
+ sky130_fd_sc_hd__clkbuf_16
Xclkbuf_leaf_23_clk clknet_4_3_0_clk VSS VSS VDD VDD clknet_leaf_23_clk
+ sky130_fd_sc_hd__clkbuf_16
Xclkbuf_leaf_22_clk clknet_4_3_0_clk VSS VSS VDD VDD clknet_leaf_22_clk
+ sky130_fd_sc_hd__clkbuf_16
Xclkbuf_leaf_21_clk clknet_4_3_0_clk VSS VSS VDD VDD clknet_leaf_21_clk
+ sky130_fd_sc_hd__clkbuf_16
X_5472_ reg_pc\[4\] reg_pc\[5\] reg_pc\[6\] VSS VSS VDD VDD
+ _1509_ sky130_fd_sc_hd__and3_1
X_5473_ reg_pc\[7\] _0161_ _1509_ VSS VSS VDD VDD _1510_ sky130_fd_sc_hd__nand3_1
X_5474_ reg_pc\[8\] reg_pc\[9\] reg_pc\[10\] VSS VSS VDD VDD
+ _1511_ sky130_fd_sc_hd__and3_1
X_5475_ reg_pc\[11\] reg_pc\[12\] _1511_ VSS VSS VDD VDD _1512_
+ sky130_fd_sc_hd__and3_1
X_5476_ reg_pc\[13\] _1512_ VSS VSS VDD VDD _1513_ sky130_fd_sc_hd__nand2_1
X_5477_ _1510_ _1513_ VSS VSS VDD VDD _1514_ sky130_fd_sc_hd__nor2_1
Xclkbuf_leaf_20_clk clknet_4_3_0_clk VSS VSS VDD VDD clknet_leaf_20_clk
+ sky130_fd_sc_hd__clkbuf_16
X_5479_ reg_pc\[14\] reg_pc\[15\] reg_pc\[16\] reg_pc\[17\]
+ VSS VSS VDD VDD _1516_ sky130_fd_sc_hd__nand4_1
X_5480_ _1516_ VSS VSS VDD VDD _1517_ sky130_fd_sc_hd__inv_1
X_5481_ _1514_ _1517_ VSS VSS VDD VDD _1518_ sky130_fd_sc_hd__nand2_1
X_5482_ reg_pc\[18\] reg_pc\[19\] reg_pc\[20\] VSS VSS VDD
+ VDD _1519_ sky130_fd_sc_hd__and3_1
X_5483_ reg_pc\[21\] reg_pc\[22\] _1519_ VSS VSS VDD VDD _1520_
+ sky130_fd_sc_hd__nand3_1
X_5484_ reg_pc\[23\] reg_pc\[24\] reg_pc\[25\] VSS VSS VDD
+ VDD _1521_ sky130_fd_sc_hd__and3_1
X_5485_ reg_pc\[26\] _1521_ VSS VSS VDD VDD _1522_ sky130_fd_sc_hd__nand2_1
X_5486_ _1518_ _1520_ _1522_ VSS VSS VDD VDD _1523_ sky130_fd_sc_hd__nor3_1
X_5487_ reg_pc\[27\] reg_pc\[28\] reg_pc\[29\] _1523_ VSS
+ VSS VDD VDD _1524_ sky130_fd_sc_hd__nand4_1
X_5488_ reg_pc\[30\] _1524_ VSS VSS VDD VDD _1525_ sky130_fd_sc_hd__xnor2_1
X_5489_ net693 _1525_ VSS VSS VDD VDD _1526_ sky130_fd_sc_hd__nand2_1
X_5490_ _0956_ net693 _1526_ VSS VSS VDD VDD cpuregs_wrdata\[30\]
+ sky130_fd_sc_hd__o21ai_4
X_5491_ reg_pc\[27\] reg_pc\[28\] VSS VSS VDD VDD _1527_ sky130_fd_sc_hd__nand2_1
X_5492_ reg_pc\[2\] reg_pc\[3\] _1509_ VSS VSS VDD VDD _1528_
+ sky130_fd_sc_hd__and3_1
X_5493_ reg_pc\[7\] _1528_ VSS VSS VDD VDD _1529_ sky130_fd_sc_hd__and2_1
X_5494_ _1513_ _1529_ VSS VSS VDD VDD _1530_ sky130_fd_sc_hd__nor2b_1
X_5495_ _1517_ _1530_ VSS VSS VDD VDD _1531_ sky130_fd_sc_hd__and2_1
X_5496_ _1520_ _1531_ VSS VSS VDD VDD _1532_ sky130_fd_sc_hd__nor2b_1
X_5497_ reg_pc\[26\] _1521_ _1532_ VSS VSS VDD VDD _1533_
+ sky130_fd_sc_hd__nand3_1
X_5498_ _1527_ _1533_ VSS VSS VDD VDD _1534_ sky130_fd_sc_hd__nor2_1
X_5499_ reg_pc\[29\] _1534_ VSS VSS VDD VDD _1535_ sky130_fd_sc_hd__xnor2_1
X_5500_ _0953_ _1535_ net693 VSS VSS VDD VDD cpuregs_wrdata\[29\]
+ sky130_fd_sc_hd__mux2i_4
X_5501_ reg_pc\[27\] _1523_ VSS VSS VDD VDD _1536_ sky130_fd_sc_hd__nand2_1
X_5502_ reg_pc\[28\] _1536_ VSS VSS VDD VDD _1537_ sky130_fd_sc_hd__xnor2_1
X_5503_ net693 _1537_ VSS VSS VDD VDD _1538_ sky130_fd_sc_hd__nand2_1
X_5504_ _0950_ net693 _1538_ VSS VSS VDD VDD cpuregs_wrdata\[28\]
+ sky130_fd_sc_hd__o21ai_2
X_5505_ reg_pc\[27\] _1533_ VSS VSS VDD VDD _1539_ sky130_fd_sc_hd__xnor2_1
X_5506_ net693 _1539_ VSS VSS VDD VDD _1540_ sky130_fd_sc_hd__nand2_1
X_5507_ _0948_ net693 _1540_ VSS VSS VDD VDD cpuregs_wrdata\[27\]
+ sky130_fd_sc_hd__o21ai_2
X_5508_ net738 net736 VSS VSS VDD VDD _1541_ sky130_fd_sc_hd__nor2b_4
Xclkbuf_leaf_19_clk clknet_4_3_0_clk VSS VSS VDD VDD clknet_leaf_19_clk
+ sky130_fd_sc_hd__clkbuf_16
X_5510_ _1518_ _1520_ VSS VSS VDD VDD _1543_ sky130_fd_sc_hd__nor2_1
X_5511_ _1543_ _1521_ VSS VSS VDD VDD _1544_ sky130_fd_sc_hd__nand2_1
X_5512_ reg_pc\[26\] _1544_ VSS VSS VDD VDD _1545_ sky130_fd_sc_hd__xor2_1
Xclkbuf_leaf_18_clk clknet_4_3_0_clk VSS VSS VDD VDD clknet_leaf_18_clk
+ sky130_fd_sc_hd__clkbuf_16
X_5514_ _0946_ net692 VSS VSS VDD VDD _1547_ sky130_fd_sc_hd__nand2_1
X_5515_ net692 _1545_ _1547_ VSS VSS VDD VDD cpuregs_wrdata\[26\]
+ sky130_fd_sc_hd__o21ai_2
X_5516_ reg_pc\[23\] reg_pc\[24\] _1532_ VSS VSS VDD VDD _1548_
+ sky130_fd_sc_hd__nand3_1
X_5517_ reg_pc\[25\] _1548_ VSS VSS VDD VDD _1549_ sky130_fd_sc_hd__xor2_1
X_5518_ _0943_ net692 VSS VSS VDD VDD _1550_ sky130_fd_sc_hd__nand2_1
X_5519_ net692 _1549_ _1550_ VSS VSS VDD VDD cpuregs_wrdata\[25\]
+ sky130_fd_sc_hd__o21ai_2
X_5520_ reg_pc\[23\] _1543_ VSS VSS VDD VDD _1551_ sky130_fd_sc_hd__nand2_1
X_5521_ reg_pc\[24\] _1551_ VSS VSS VDD VDD _1552_ sky130_fd_sc_hd__xnor2_1
X_5522_ net693 _1552_ VSS VSS VDD VDD _1553_ sky130_fd_sc_hd__nand2_1
X_5523_ _0941_ net693 _1553_ VSS VSS VDD VDD cpuregs_wrdata\[24\]
+ sky130_fd_sc_hd__o21ai_2
X_5524_ reg_pc\[23\] _1532_ VSS VSS VDD VDD _1554_ sky130_fd_sc_hd__xor2_1
X_5525_ net693 _1554_ VSS VSS VDD VDD _1555_ sky130_fd_sc_hd__nand2_1
X_5526_ _0939_ net693 _1555_ VSS VSS VDD VDD cpuregs_wrdata\[23\]
+ sky130_fd_sc_hd__o21ai_2
X_5527_ _1510_ _1513_ _1516_ VSS VSS VDD VDD _1556_ sky130_fd_sc_hd__nor3_1
X_5528_ reg_pc\[21\] _1556_ _1519_ VSS VSS VDD VDD _1557_
+ sky130_fd_sc_hd__nand3_1
X_5529_ reg_pc\[22\] _1557_ VSS VSS VDD VDD _1558_ sky130_fd_sc_hd__xnor2_1
X_5530_ net693 _1558_ VSS VSS VDD VDD _1559_ sky130_fd_sc_hd__nand2_1
X_5531_ _0937_ net693 _1559_ VSS VSS VDD VDD cpuregs_wrdata\[22\]
+ sky130_fd_sc_hd__o21ai_2
X_5532_ _1519_ _1531_ VSS VSS VDD VDD _1560_ sky130_fd_sc_hd__nand2_1
X_5533_ reg_pc\[21\] _1560_ VSS VSS VDD VDD _1561_ sky130_fd_sc_hd__xor2_1
X_5534_ _0935_ _1561_ net693 VSS VSS VDD VDD cpuregs_wrdata\[21\]
+ sky130_fd_sc_hd__mux2i_2
X_5535_ reg_pc\[18\] reg_pc\[19\] _1556_ VSS VSS VDD VDD _1562_
+ sky130_fd_sc_hd__nand3_1
X_5536_ reg_pc\[20\] _1562_ VSS VSS VDD VDD _1563_ sky130_fd_sc_hd__xor2_1
X_5537_ _0933_ net692 VSS VSS VDD VDD _1564_ sky130_fd_sc_hd__nand2_1
X_5538_ net692 _1563_ _1564_ VSS VSS VDD VDD cpuregs_wrdata\[20\]
+ sky130_fd_sc_hd__o21ai_2
Xclkbuf_leaf_17_clk clknet_4_2_0_clk VSS VSS VDD VDD clknet_leaf_17_clk
+ sky130_fd_sc_hd__clkbuf_16
X_5540_ reg_pc\[18\] _1531_ VSS VSS VDD VDD _1566_ sky130_fd_sc_hd__nand2_1
X_5541_ reg_pc\[19\] _1566_ VSS VSS VDD VDD _1567_ sky130_fd_sc_hd__xor2_1
X_5542_ _0931_ net692 VSS VSS VDD VDD _1568_ sky130_fd_sc_hd__nand2_1
X_5543_ net692 _1567_ _1568_ VSS VSS VDD VDD cpuregs_wrdata\[19\]
+ sky130_fd_sc_hd__o21ai_2
X_5544_ reg_pc\[18\] _1556_ VSS VSS VDD VDD _1569_ sky130_fd_sc_hd__xnor2_1
Xclkbuf_leaf_16_clk clknet_4_2_0_clk VSS VSS VDD VDD clknet_leaf_16_clk
+ sky130_fd_sc_hd__clkbuf_16
X_5546_ _0927_ net692 VSS VSS VDD VDD _1571_ sky130_fd_sc_hd__nand2_1
X_5547_ net692 _1569_ _1571_ VSS VSS VDD VDD cpuregs_wrdata\[18\]
+ sky130_fd_sc_hd__o21ai_2
X_5548_ reg_pc\[14\] reg_pc\[15\] reg_pc\[16\] _1530_ VSS
+ VSS VDD VDD _1572_ sky130_fd_sc_hd__nand4_1
X_5549_ reg_pc\[17\] _1572_ VSS VSS VDD VDD _1573_ sky130_fd_sc_hd__xor2_1
X_5550_ _0924_ net692 VSS VSS VDD VDD _1574_ sky130_fd_sc_hd__nand2_1
X_5551_ net692 _1573_ _1574_ VSS VSS VDD VDD cpuregs_wrdata\[17\]
+ sky130_fd_sc_hd__o21ai_2
X_5552_ reg_pc\[14\] reg_pc\[15\] _1514_ VSS VSS VDD VDD _1575_
+ sky130_fd_sc_hd__nand3_1
X_5553_ reg_pc\[16\] _1575_ VSS VSS VDD VDD _1576_ sky130_fd_sc_hd__xor2_1
X_5554_ _0920_ net692 VSS VSS VDD VDD _1577_ sky130_fd_sc_hd__nand2_1
X_5555_ net692 _1576_ _1577_ VSS VSS VDD VDD cpuregs_wrdata\[16\]
+ sky130_fd_sc_hd__o21ai_2
X_5556_ reg_pc\[14\] _1530_ VSS VSS VDD VDD _1578_ sky130_fd_sc_hd__nand2_1
X_5557_ reg_pc\[15\] _1578_ VSS VSS VDD VDD _1579_ sky130_fd_sc_hd__xor2_1
X_5558_ _0917_ net692 VSS VSS VDD VDD _1580_ sky130_fd_sc_hd__nand2_1
X_5559_ net692 _1579_ _1580_ VSS VSS VDD VDD cpuregs_wrdata\[15\]
+ sky130_fd_sc_hd__o21ai_2
X_5560_ reg_pc\[14\] _1514_ VSS VSS VDD VDD _1581_ sky130_fd_sc_hd__xnor2_1
X_5561_ _0913_ net692 VSS VSS VDD VDD _1582_ sky130_fd_sc_hd__nand2_1
X_5562_ net692 _1581_ _1582_ VSS VSS VDD VDD cpuregs_wrdata\[14\]
+ sky130_fd_sc_hd__o21ai_2
X_5563_ _1512_ _1529_ VSS VSS VDD VDD _1583_ sky130_fd_sc_hd__nand2_1
X_5564_ reg_pc\[13\] _1583_ VSS VSS VDD VDD _1584_ sky130_fd_sc_hd__xor2_1
X_5565_ _0910_ net692 VSS VSS VDD VDD _1585_ sky130_fd_sc_hd__nand2_1
X_5566_ net692 _1584_ _1585_ VSS VSS VDD VDD cpuregs_wrdata\[13\]
+ sky130_fd_sc_hd__o21ai_2
X_5567_ reg_pc\[8\] reg_pc\[9\] VSS VSS VDD VDD _1586_ sky130_fd_sc_hd__nand2_1
X_5568_ reg_pc\[10\] reg_pc\[11\] VSS VSS VDD VDD _1587_ sky130_fd_sc_hd__nand2_1
X_5569_ _1510_ _1586_ _1587_ VSS VSS VDD VDD _1588_ sky130_fd_sc_hd__nor3_1
X_5570_ reg_pc\[12\] _1588_ VSS VSS VDD VDD _1589_ sky130_fd_sc_hd__xnor2_1
X_5571_ _0908_ net692 VSS VSS VDD VDD _1590_ sky130_fd_sc_hd__nand2_1
X_5572_ net692 _1589_ _1590_ VSS VSS VDD VDD cpuregs_wrdata\[12\]
+ sky130_fd_sc_hd__o21ai_2
X_5573_ _1511_ _1529_ VSS VSS VDD VDD _1591_ sky130_fd_sc_hd__nand2_1
X_5574_ reg_pc\[11\] _1591_ VSS VSS VDD VDD _1592_ sky130_fd_sc_hd__xor2_1
X_5575_ _0906_ net692 VSS VSS VDD VDD _1593_ sky130_fd_sc_hd__nand2_1
X_5576_ net692 _1592_ _1593_ VSS VSS VDD VDD cpuregs_wrdata\[11\]
+ sky130_fd_sc_hd__o21ai_2
X_5577_ _1510_ _1586_ VSS VSS VDD VDD _1594_ sky130_fd_sc_hd__nor2_1
X_5578_ reg_pc\[10\] _1594_ VSS VSS VDD VDD _1595_ sky130_fd_sc_hd__xnor2_1
X_5579_ _0904_ net692 VSS VSS VDD VDD _1596_ sky130_fd_sc_hd__nand2_1
X_5580_ net692 _1595_ _1596_ VSS VSS VDD VDD cpuregs_wrdata\[10\]
+ sky130_fd_sc_hd__o21ai_2
X_5581_ reg_pc\[8\] _1529_ VSS VSS VDD VDD _1597_ sky130_fd_sc_hd__nand2_1
X_5582_ reg_pc\[9\] _1597_ VSS VSS VDD VDD _1598_ sky130_fd_sc_hd__xor2_1
X_5583_ _0902_ net692 VSS VSS VDD VDD _1599_ sky130_fd_sc_hd__nand2_1
X_5584_ net692 _1598_ _1599_ VSS VSS VDD VDD cpuregs_wrdata\[9\]
+ sky130_fd_sc_hd__o21ai_2
X_5585_ reg_pc\[8\] _1510_ VSS VSS VDD VDD _1600_ sky130_fd_sc_hd__xor2_1
X_5586_ _0900_ net692 VSS VSS VDD VDD _1601_ sky130_fd_sc_hd__nand2_1
X_5587_ net692 _1600_ _1601_ VSS VSS VDD VDD cpuregs_wrdata\[8\]
+ sky130_fd_sc_hd__o21ai_2
X_5588_ reg_pc\[7\] _1528_ VSS VSS VDD VDD _1602_ sky130_fd_sc_hd__xnor2_1
X_5589_ _0898_ net692 VSS VSS VDD VDD _1603_ sky130_fd_sc_hd__nand2_1
X_5590_ net692 _1602_ _1603_ VSS VSS VDD VDD cpuregs_wrdata\[7\]
+ sky130_fd_sc_hd__o21ai_4
X_5591_ reg_pc\[4\] reg_pc\[5\] _0161_ VSS VSS VDD VDD _1604_
+ sky130_fd_sc_hd__nand3_1
X_5592_ reg_pc\[6\] _1604_ VSS VSS VDD VDD _1605_ sky130_fd_sc_hd__xor2_1
X_5593_ _0896_ net692 VSS VSS VDD VDD _1606_ sky130_fd_sc_hd__nand2_1
X_5594_ net692 _1605_ _1606_ VSS VSS VDD VDD cpuregs_wrdata\[6\]
+ sky130_fd_sc_hd__o21ai_4
X_5595_ reg_pc\[2\] reg_pc\[3\] reg_pc\[4\] VSS VSS VDD VDD
+ _1607_ sky130_fd_sc_hd__nand3_1
X_5596_ reg_pc\[5\] _1607_ VSS VSS VDD VDD _1608_ sky130_fd_sc_hd__xor2_1
X_5597_ _0894_ net692 VSS VSS VDD VDD _1609_ sky130_fd_sc_hd__nand2_1
X_5598_ net692 _1608_ _1609_ VSS VSS VDD VDD cpuregs_wrdata\[5\]
+ sky130_fd_sc_hd__o21ai_2
X_5599_ reg_pc\[4\] _0161_ VSS VSS VDD VDD _1610_ sky130_fd_sc_hd__xor2_1
X_5600_ _1504_ _1610_ VSS VSS VDD VDD _1611_ sky130_fd_sc_hd__nand2_1
X_5601_ _0892_ _1504_ _1611_ VSS VSS VDD VDD cpuregs_wrdata\[4\]
+ sky130_fd_sc_hd__o21ai_2
X_5602_ _0162_ _1504_ VSS VSS VDD VDD _1612_ sky130_fd_sc_hd__nand2_1
X_5603_ _0890_ _1504_ _1612_ VSS VSS VDD VDD cpuregs_wrdata\[3\]
+ sky130_fd_sc_hd__o21ai_2
X_5604_ _0885_ _1504_ VSS VSS VDD VDD _1613_ sky130_fd_sc_hd__nor2_1
X_5605_ reg_pc\[2\] _1504_ _1613_ VSS VSS VDD VDD cpuregs_wrdata\[2\]
+ sky130_fd_sc_hd__a21oi_2
X_5606_ reg_pc\[1\] _1504_ VSS VSS VDD VDD _1614_ sky130_fd_sc_hd__nand2_1
X_5607_ _0882_ _1504_ _1614_ VSS VSS VDD VDD cpuregs_wrdata\[1\]
+ sky130_fd_sc_hd__o21ai_2
X_5608_ reg_out\[0\] alu_out_q\[0\] latched_stalu VSS VSS
+ VDD VDD _1615_ sky130_fd_sc_hd__mux2i_1
X_5609_ _1504_ _1615_ VSS VSS VDD VDD cpuregs_wrdata\[0\]
+ sky130_fd_sc_hd__nor2_2
X_5610_ net350 VSS VSS VDD VDD _0109_ sky130_fd_sc_hd__inv_1
Xclkbuf_leaf_15_clk clknet_4_0_0_clk VSS VSS VDD VDD clknet_leaf_15_clk
+ sky130_fd_sc_hd__clkbuf_16
X_5612_ cpu_state\[5\] cpu_state\[6\] VSS VSS VDD VDD _1617_
+ sky130_fd_sc_hd__nor2_2
X_5613_ _0169_ _0171_ _0173_ VSS VSS VDD VDD _1618_ sky130_fd_sc_hd__and3_1
X_5614_ _0175_ _0177_ _0179_ VSS VSS VDD VDD _1619_ sky130_fd_sc_hd__and3_1
X_5615_ _1618_ _1619_ VSS VSS VDD VDD _1620_ sky130_fd_sc_hd__nand2_1
X_5616_ _0227_ _0064_ _0224_ _0226_ VSS VSS VDD VDD _1621_
+ sky130_fd_sc_hd__a211oi_1
X_5617_ _0224_ _0225_ _0223_ VSS VSS VDD VDD _1622_ sky130_fd_sc_hd__o21ai_0
X_5618_ _1621_ _1622_ VSS VSS VDD VDD _1623_ sky130_fd_sc_hd__nor2_1
X_5619_ _0221_ _0191_ _0242_ VSS VSS VDD VDD _1624_ sky130_fd_sc_hd__nand3_1
X_5620_ _0243_ _0244_ VSS VSS VDD VDD _1625_ sky130_fd_sc_hd__nor2_1
X_5621_ _1624_ _1625_ VSS VSS VDD VDD _1626_ sky130_fd_sc_hd__nor2_1
X_5622_ _0243_ _0222_ _1623_ _1626_ VSS VSS VDD VDD _1627_
+ sky130_fd_sc_hd__o31ai_1
X_5623_ _0191_ _0241_ _0190_ VSS VSS VDD VDD _1628_ sky130_fd_sc_hd__a21o_1
X_5624_ _0221_ _1628_ _0220_ VSS VSS VDD VDD _1629_ sky130_fd_sc_hd__a21oi_1
X_5625_ _0189_ _0237_ _0188_ VSS VSS VDD VDD _1630_ sky130_fd_sc_hd__a21o_1
X_5626_ _0239_ _1630_ VSS VSS VDD VDD _1631_ sky130_fd_sc_hd__nor2_1
X_5627_ _0239_ _0240_ VSS VSS VDD VDD _1632_ sky130_fd_sc_hd__or2_2
X_5628_ _0189_ _0238_ _1632_ _1630_ VSS VSS VDD VDD _1633_
+ sky130_fd_sc_hd__a31oi_1
X_5629_ _0185_ _0187_ VSS VSS VDD VDD _1634_ sky130_fd_sc_hd__nand2_1
X_5630_ _1627_ _1629_ _1631_ _1633_ _1634_ VSS VSS VDD VDD
+ _1635_ sky130_fd_sc_hd__a311oi_1
X_5631_ _0185_ _0186_ _1635_ _0184_ VSS VSS VDD VDD _1636_
+ sky130_fd_sc_hd__a211oi_1
X_5632_ _0181_ _0183_ VSS VSS VDD VDD _1637_ sky130_fd_sc_hd__nand2_1
X_5633_ _1636_ _1637_ VSS VSS VDD VDD _1638_ sky130_fd_sc_hd__or2_1
X_5634_ _0093_ _0101_ VSS VSS VDD VDD _1639_ sky130_fd_sc_hd__nand2_1
X_5635_ _0181_ _0182_ _0180_ VSS VSS VDD VDD _1640_ sky130_fd_sc_hd__a21o_1
X_5636_ _0179_ _1640_ _0178_ VSS VSS VDD VDD _1641_ sky130_fd_sc_hd__a21o_1
X_5637_ _0177_ _1641_ _0176_ VSS VSS VDD VDD _1642_ sky130_fd_sc_hd__a21oi_1
X_5638_ _0175_ _1618_ VSS VSS VDD VDD _1643_ sky130_fd_sc_hd__nand2_1
X_5639_ _0173_ _0174_ _0172_ VSS VSS VDD VDD _1644_ sky130_fd_sc_hd__a21o_1
X_5640_ _0171_ _1644_ _0170_ VSS VSS VDD VDD _1645_ sky130_fd_sc_hd__a21o_1
X_5641_ _0169_ _1645_ _0168_ VSS VSS VDD VDD _1646_ sky130_fd_sc_hd__a21oi_1
X_5642_ _1642_ _1643_ _1646_ VSS VSS VDD VDD _1647_ sky130_fd_sc_hd__o21ai_0
X_5643_ _0101_ _1647_ _0100_ VSS VSS VDD VDD _1648_ sky130_fd_sc_hd__a21o_1
X_5644_ _0093_ _1648_ _0092_ VSS VSS VDD VDD _1649_ sky130_fd_sc_hd__a21oi_1
X_5645_ _1620_ _1638_ _1639_ _1649_ VSS VSS VDD VDD _1650_
+ sky130_fd_sc_hd__o31a_1
X_5646_ _0089_ _0091_ VSS VSS VDD VDD _1651_ sky130_fd_sc_hd__nand2_1
X_5647_ _0089_ _0090_ _0088_ VSS VSS VDD VDD _1652_ sky130_fd_sc_hd__a21oi_1
X_5648_ _1650_ _1651_ _1652_ VSS VSS VDD VDD _1653_ sky130_fd_sc_hd__o21a_1
X_5649_ _0081_ _0083_ _0085_ _0087_ VSS VSS VDD VDD _1654_
+ sky130_fd_sc_hd__nand4_1
X_5650_ _0079_ net691 _1653_ _1654_ VSS VSS VDD VDD _1655_
+ sky130_fd_sc_hd__or4_1
X_5651_ cpu_state\[5\] cpu_state\[6\] VSS VSS VDD VDD _1656_
+ sky130_fd_sc_hd__or2_2
Xclkbuf_leaf_14_clk clknet_4_1_0_clk VSS VSS VDD VDD clknet_leaf_14_clk
+ sky130_fd_sc_hd__clkbuf_16
Xclkbuf_leaf_13_clk clknet_4_1_0_clk VSS VSS VDD VDD clknet_leaf_13_clk
+ sky130_fd_sc_hd__clkbuf_16
X_5654_ _0083_ VSS VSS VDD VDD _1659_ sky130_fd_sc_hd__inv_1
X_5655_ _0085_ _0086_ _0084_ VSS VSS VDD VDD _1660_ sky130_fd_sc_hd__a21oi_1
X_5656_ _1659_ _1660_ _0082_ VSS VSS VDD VDD _1661_ sky130_fd_sc_hd__o21bai_1
X_5657_ _0081_ _1661_ _0080_ VSS VSS VDD VDD _1662_ sky130_fd_sc_hd__a21oi_1
X_5658_ _0079_ net690 _1653_ _1662_ VSS VSS VDD VDD _1663_
+ sky130_fd_sc_hd__nand4_1
X_5659_ _0079_ _1662_ _1654_ VSS VSS VDD VDD _1664_ sky130_fd_sc_hd__nand3_1
X_5660_ _0079_ _1662_ _1664_ VSS VSS VDD VDD _1665_ sky130_fd_sc_hd__o21ai_0
Xclkbuf_leaf_12_clk clknet_4_1_0_clk VSS VSS VDD VDD clknet_leaf_12_clk
+ sky130_fd_sc_hd__clkbuf_16
X_5662_ net747 VSS VSS VDD VDD _1667_ sky130_fd_sc_hd__inv_1
Xclkbuf_leaf_11_clk clknet_4_1_0_clk VSS VSS VDD VDD clknet_leaf_11_clk
+ sky130_fd_sc_hd__clkbuf_16
X_5664_ instr_srai instr_sra VSS VSS VDD VDD _1669_ sky130_fd_sc_hd__nor2_1
X_5665_ _1669_ VSS VSS VDD VDD _1670_ sky130_fd_sc_hd__inv_1
X_5666_ instr_srli instr_srl _1670_ VSS VSS VDD VDD _1671_
+ sky130_fd_sc_hd__nor3_2
Xclkbuf_leaf_10_clk clknet_4_1_0_clk VSS VSS VDD VDD clknet_leaf_10_clk
+ sky130_fd_sc_hd__clkbuf_16
Xclkbuf_leaf_9_clk clknet_4_1_0_clk VSS VSS VDD VDD clknet_leaf_9_clk
+ sky130_fd_sc_hd__clkbuf_16
X_5669_ net714 VSS VSS VDD VDD _0301_ sky130_fd_sc_hd__inv_1
X_5670_ _0167_ _0160_ reg_sh\[4\] reg_sh\[3\] VSS VSS VDD
+ VDD _1674_ sky130_fd_sc_hd__a211o_1
X_5671_ reg_sh\[2\] _1674_ VSS VSS VDD VDD _1675_ sky130_fd_sc_hd__nor2_4
Xclkbuf_leaf_8_clk clknet_4_0_0_clk VSS VSS VDD VDD clknet_leaf_8_clk
+ sky130_fd_sc_hd__clkbuf_16
X_5673_ net329 net658 VSS VSS VDD VDD _1677_ sky130_fd_sc_hd__nand2_1
X_5674_ _0301_ net658 _1677_ VSS VSS VDD VDD _1678_ sky130_fd_sc_hd__o21ai_0
X_5675_ instr_srli instr_srl VSS VSS VDD VDD _1679_ sky130_fd_sc_hd__nor2_1
X_5676_ _1674_ _0155_ VSS VSS VDD VDD _1680_ sky130_fd_sc_hd__nand2b_2
Xclkbuf_leaf_7_clk clknet_4_0_0_clk VSS VSS VDD VDD clknet_leaf_7_clk
+ sky130_fd_sc_hd__clkbuf_16
X_5678_ _1679_ net657 _1669_ VSS VSS VDD VDD _1682_ sky130_fd_sc_hd__o21ai_0
X_5679_ net671 _1678_ _1682_ net709 VSS VSS VDD VDD _1683_
+ sky130_fd_sc_hd__a22oi_1
X_5680_ net689 _1683_ VSS VSS VDD VDD _1684_ sky130_fd_sc_hd__nor2_1
X_5681_ net690 _1665_ _1684_ VSS VSS VDD VDD _1685_ sky130_fd_sc_hd__a21oi_1
X_5682_ decoded_imm_j\[18\] decoded_imm_j\[17\] decoded_imm_j\[16\]
+ decoded_imm_j\[15\] VSS VSS VDD VDD _1686_ sky130_fd_sc_hd__or4_1
X_5683_ decoded_imm_j\[19\] _1686_ is_lui_auipc_jal VSS VSS
+ VDD VDD _1687_ sky130_fd_sc_hd__o21bai_4
Xclkbuf_leaf_6_clk clknet_4_0_0_clk VSS VSS VDD VDD clknet_leaf_6_clk
+ sky130_fd_sc_hd__clkbuf_16
Xclkbuf_leaf_5_clk clknet_4_0_0_clk VSS VSS VDD VDD clknet_leaf_5_clk
+ sky130_fd_sc_hd__clkbuf_16
Xclkbuf_leaf_4_clk clknet_4_0_0_clk VSS VSS VDD VDD clknet_leaf_4_clk
+ sky130_fd_sc_hd__clkbuf_16
Xclkbuf_leaf_3_clk clknet_4_0_0_clk VSS VSS VDD VDD clknet_leaf_3_clk
+ sky130_fd_sc_hd__clkbuf_16
Xplace783 _0041_ VSS VSS VDD VDD net774 sky130_fd_sc_hd__buf_4
Xplace782 net774 VSS VSS VDD VDD net773 sky130_fd_sc_hd__buf_4
X_5690_ cpuregs\[0\]\[30\] cpuregs\[1\]\[30\] cpuregs\[2\]\[30\]
+ cpuregs\[3\]\[30\] _0041_ _0042_ VSS VSS VDD VDD _1694_ sky130_fd_sc_hd__mux4_2
Xplace781 net773 VSS VSS VDD VDD net772 sky130_fd_sc_hd__buf_4
Xplace780 _0041_ VSS VSS VDD VDD net771 sky130_fd_sc_hd__buf_4
X_5693_ cpuregs\[4\]\[30\] cpuregs\[5\]\[30\] cpuregs\[6\]\[30\]
+ cpuregs\[7\]\[30\] _0041_ _0042_ VSS VSS VDD VDD _1697_ sky130_fd_sc_hd__mux4_2
X_5694_ cpuregs\[16\]\[30\] cpuregs\[17\]\[30\] cpuregs\[18\]\[30\]
+ cpuregs\[19\]\[30\] net771 _0042_ VSS VSS VDD VDD _1698_ sky130_fd_sc_hd__mux4_2
Xplace771 _0046_ VSS VSS VDD VDD net762 sky130_fd_sc_hd__buf_4
Xplace770 net762 VSS VSS VDD VDD net761 sky130_fd_sc_hd__buf_12
Xplace769 _0046_ VSS VSS VDD VDD net760 sky130_fd_sc_hd__buf_4
Xplace768 net760 VSS VSS VDD VDD net759 sky130_fd_sc_hd__buf_4
X_5699_ cpuregs\[20\]\[30\] cpuregs\[21\]\[30\] cpuregs\[22\]\[30\]
+ cpuregs\[23\]\[30\] net771 _0042_ VSS VSS VDD VDD _1703_ sky130_fd_sc_hd__mux4_2
Xplace766 _0047_ VSS VSS VDD VDD net757 sky130_fd_sc_hd__buf_12
Xplace765 net757 VSS VSS VDD VDD net756 sky130_fd_sc_hd__buf_4
Xplace763 _0048_ VSS VSS VDD VDD net754 sky130_fd_sc_hd__buf_4
Xplace756 cpu_state\[4\] VSS VSS VDD VDD net747 sky130_fd_sc_hd__buf_4
X_5704_ _1694_ _1697_ _1698_ _1703_ _0043_ _0045_ VSS VSS
+ VDD VDD _1708_ sky130_fd_sc_hd__mux4_2
Xplace755 net747 VSS VSS VDD VDD net746 sky130_fd_sc_hd__buf_4
Xplace754 decoded_imm_j\[20\] VSS VSS VDD VDD net745 sky130_fd_sc_hd__buf_4
X_5707_ cpuregs\[8\]\[30\] cpuregs\[9\]\[30\] cpuregs\[10\]\[30\]
+ cpuregs\[11\]\[30\] _0041_ _0042_ VSS VSS VDD VDD _1711_ sky130_fd_sc_hd__mux4_2
Xplace752 instr_jal VSS VSS VDD VDD net743 sky130_fd_sc_hd__buf_4
Xplace751 instr_rdcycleh VSS VSS VDD VDD net742 sky130_fd_sc_hd__buf_4
Xplace750 instr_rdinstr VSS VSS VDD VDD net741 sky130_fd_sc_hd__buf_4
X_5711_ cpuregs\[12\]\[30\] cpuregs\[13\]\[30\] cpuregs\[14\]\[30\]
+ cpuregs\[15\]\[30\] _0041_ _0042_ VSS VSS VDD VDD _1715_ sky130_fd_sc_hd__mux4_2
X_5712_ cpuregs\[24\]\[30\] cpuregs\[25\]\[30\] cpuregs\[26\]\[30\]
+ cpuregs\[27\]\[30\] net771 _0042_ VSS VSS VDD VDD _1716_ sky130_fd_sc_hd__mux4_2
Xplace748 instr_sub VSS VSS VDD VDD net739 sky130_fd_sc_hd__buf_4
Xplace747 latched_branch VSS VSS VDD VDD net738 sky130_fd_sc_hd__buf_4
X_5715_ cpuregs\[28\]\[30\] cpuregs\[29\]\[30\] cpuregs\[30\]\[30\]
+ cpuregs\[31\]\[30\] net771 _0042_ VSS VSS VDD VDD _1719_ sky130_fd_sc_hd__mux4_2
X_5716_ _1711_ _1715_ _1716_ _1719_ _0043_ _0045_ VSS VSS
+ VDD VDD _1720_ sky130_fd_sc_hd__mux4_2
Xplace746 latched_stalu VSS VSS VDD VDD net737 sky130_fd_sc_hd__buf_4
Xplace745 latched_store VSS VSS VDD VDD net736 sky130_fd_sc_hd__buf_4
X_5719_ _1708_ _1720_ _0044_ VSS VSS VDD VDD _1723_ sky130_fd_sc_hd__mux2i_2
X_5720_ instr_lui is_lui_auipc_jal VSS VSS VDD VDD _1724_
+ sky130_fd_sc_hd__nor2b_2
Xplace742 mem_wordsize\[2\] VSS VSS VDD VDD net733 sky130_fd_sc_hd__buf_4
X_5722_ reg_pc\[30\] net688 VSS VSS VDD VDD _1726_ sky130_fd_sc_hd__nand2_1
X_5723_ _1687_ _1723_ _1726_ VSS VSS VDD VDD _1727_ sky130_fd_sc_hd__o21ai_0
X_5724_ net747 _1656_ VSS VSS VDD VDD _1728_ sky130_fd_sc_hd__nor2_4
Xplace711 net339 VSS VSS VDD VDD net702 sky130_fd_sc_hd__buf_4
X_5726_ _1727_ _1728_ VSS VSS VDD VDD _1730_ sky130_fd_sc_hd__nand2_1
X_5727_ _1655_ _1663_ _1685_ _1730_ VSS VSS VDD VDD _4619_
+ sky130_fd_sc_hd__nand4_1
Xplace710 net360 VSS VSS VDD VDD net701 sky130_fd_sc_hd__buf_4
Xplace706 _0875_ VSS VSS VDD VDD net697 sky130_fd_sc_hd__buf_4
Xplace700 _1617_ VSS VSS VDD VDD net691 sky130_fd_sc_hd__buf_4
Xplace699 _1656_ VSS VSS VDD VDD net690 sky130_fd_sc_hd__buf_4
X_5732_ cpuregs\[0\]\[29\] cpuregs\[1\]\[29\] cpuregs\[2\]\[29\]
+ cpuregs\[3\]\[29\] net774 net768 VSS VSS VDD VDD _1735_ sky130_fd_sc_hd__mux4_2
X_5733_ cpuregs\[4\]\[29\] cpuregs\[5\]\[29\] cpuregs\[6\]\[29\]
+ cpuregs\[7\]\[29\] net774 net768 VSS VSS VDD VDD _1736_ sky130_fd_sc_hd__mux4_2
X_5734_ cpuregs\[16\]\[29\] cpuregs\[17\]\[29\] cpuregs\[18\]\[29\]
+ cpuregs\[19\]\[29\] net774 net768 VSS VSS VDD VDD _1737_ sky130_fd_sc_hd__mux4_2
X_5735_ cpuregs\[20\]\[29\] cpuregs\[21\]\[29\] cpuregs\[22\]\[29\]
+ cpuregs\[23\]\[29\] net772 net767 VSS VSS VDD VDD _1738_ sky130_fd_sc_hd__mux4_2
Xplace694 _2936_ VSS VSS VDD VDD net685 sky130_fd_sc_hd__buf_4
Xplace693 _3652_ VSS VSS VDD VDD net684 sky130_fd_sc_hd__buf_4
X_5738_ _1735_ _1736_ _1737_ _1738_ net766 _0045_ VSS VSS
+ VDD VDD _1741_ sky130_fd_sc_hd__mux4_2
X_5739_ cpuregs\[8\]\[29\] cpuregs\[9\]\[29\] cpuregs\[10\]\[29\]
+ cpuregs\[11\]\[29\] net774 net768 VSS VSS VDD VDD _1742_ sky130_fd_sc_hd__mux4_2
X_5740_ cpuregs\[12\]\[29\] cpuregs\[13\]\[29\] cpuregs\[14\]\[29\]
+ cpuregs\[15\]\[29\] net774 net768 VSS VSS VDD VDD _1743_ sky130_fd_sc_hd__mux4_2
X_5741_ cpuregs\[24\]\[29\] cpuregs\[25\]\[29\] cpuregs\[26\]\[29\]
+ cpuregs\[27\]\[29\] net772 net767 VSS VSS VDD VDD _1744_ sky130_fd_sc_hd__mux4_2
X_5742_ cpuregs\[28\]\[29\] cpuregs\[29\]\[29\] cpuregs\[30\]\[29\]
+ cpuregs\[31\]\[29\] net773 net767 VSS VSS VDD VDD _1745_ sky130_fd_sc_hd__mux4_2
X_5743_ _1742_ _1743_ _1744_ _1745_ net766 _0045_ VSS VSS
+ VDD VDD _1746_ sky130_fd_sc_hd__mux4_2
Xplace692 _3721_ VSS VSS VDD VDD net683 sky130_fd_sc_hd__buf_4
X_5745_ _1741_ _1746_ net764 VSS VSS VDD VDD _1748_ sky130_fd_sc_hd__mux2i_1
X_5746_ reg_pc\[29\] net688 VSS VSS VDD VDD _1749_ sky130_fd_sc_hd__nand2_1
X_5747_ _1687_ _1748_ _1749_ VSS VSS VDD VDD _1750_ sky130_fd_sc_hd__o21ai_0
X_5748_ _0085_ _0087_ VSS VSS VDD VDD _1751_ sky130_fd_sc_hd__nand2_1
X_5749_ _0175_ _0177_ VSS VSS VDD VDD _1752_ sky130_fd_sc_hd__nand2_1
X_5750_ _0181_ _0182_ VSS VSS VDD VDD _1753_ sky130_fd_sc_hd__nand2_1
X_5751_ _0181_ _0183_ _0184_ VSS VSS VDD VDD _1754_ sky130_fd_sc_hd__nand3_1
X_5752_ _0180_ _1753_ _1754_ VSS VSS VDD VDD _1755_ sky130_fd_sc_hd__nand3b_1
X_5753_ _0179_ _1755_ _0178_ VSS VSS VDD VDD _1756_ sky130_fd_sc_hd__a21oi_1
X_5754_ _1752_ _1756_ VSS VSS VDD VDD _1757_ sky130_fd_sc_hd__nor2_1
X_5755_ _0181_ _0183_ _0185_ _1619_ VSS VSS VDD VDD _1758_
+ sky130_fd_sc_hd__nand4_1
X_5756_ _0187_ _0188_ _0186_ VSS VSS VDD VDD _1759_ sky130_fd_sc_hd__a21oi_1
X_5757_ _0175_ _0176_ _0174_ VSS VSS VDD VDD _1760_ sky130_fd_sc_hd__a21oi_1
X_5758_ _1758_ _1759_ _1760_ VSS VSS VDD VDD _1761_ sky130_fd_sc_hd__o21ai_0
X_5759_ _0219_ _0063_ _0226_ _0245_ VSS VSS VDD VDD _1762_
+ sky130_fd_sc_hd__a211oi_1
X_5760_ _0226_ _0227_ _0225_ VSS VSS VDD VDD _1763_ sky130_fd_sc_hd__o21ai_0
X_5761_ _0222_ _0224_ VSS VSS VDD VDD _1764_ sky130_fd_sc_hd__nor2_1
X_5762_ _1762_ _1763_ _1764_ VSS VSS VDD VDD _1765_ sky130_fd_sc_hd__o21ai_0
X_5763_ _0238_ _0240_ VSS VSS VDD VDD _1766_ sky130_fd_sc_hd__nand2_1
X_5764_ _1624_ _1766_ VSS VSS VDD VDD _1767_ sky130_fd_sc_hd__nor2_1
X_5765_ _0222_ _0223_ _1765_ _1767_ _0244_ VSS VSS VDD VDD
+ _1768_ sky130_fd_sc_hd__o2111ai_1
X_5766_ _0221_ _0191_ VSS VSS VDD VDD _1769_ sky130_fd_sc_hd__nand2_1
X_5767_ _0242_ _0243_ _0241_ VSS VSS VDD VDD _1770_ sky130_fd_sc_hd__a21oi_1
X_5768_ _0221_ _0190_ VSS VSS VDD VDD _1771_ sky130_fd_sc_hd__nand2_1
X_5769_ _1769_ _1770_ _1771_ VSS VSS VDD VDD _1772_ sky130_fd_sc_hd__o21ai_0
X_5770_ _0237_ _0239_ _0240_ VSS VSS VDD VDD _1773_ sky130_fd_sc_hd__nor3_1
X_5771_ _0237_ _0238_ VSS VSS VDD VDD _1774_ sky130_fd_sc_hd__nor2_1
X_5772_ _1773_ _1774_ VSS VSS VDD VDD _1775_ sky130_fd_sc_hd__nor2_1
X_5773_ _0237_ _0239_ _0220_ _1772_ _1775_ VSS VSS VDD VDD
+ _1776_ sky130_fd_sc_hd__o41ai_1
X_5774_ _0187_ _0189_ VSS VSS VDD VDD _1777_ sky130_fd_sc_hd__nand2_1
X_5775_ _1768_ _1776_ _1758_ _1777_ VSS VSS VDD VDD _1778_
+ sky130_fd_sc_hd__a211oi_1
X_5776_ _0093_ _0101_ _1618_ VSS VSS VDD VDD _1779_ sky130_fd_sc_hd__nand3_1
X_5777_ _1651_ _1779_ VSS VSS VDD VDD _1780_ sky130_fd_sc_hd__nor2_1
X_5778_ _1757_ _1761_ _1778_ _1780_ VSS VSS VDD VDD _1781_
+ sky130_fd_sc_hd__o31a_1
X_5779_ _0171_ _0172_ _0170_ VSS VSS VDD VDD _1782_ sky130_fd_sc_hd__a21o_1
X_5780_ _0169_ _1782_ _0168_ VSS VSS VDD VDD _1783_ sky130_fd_sc_hd__a21o_1
X_5781_ _0101_ _1783_ _0100_ VSS VSS VDD VDD _1784_ sky130_fd_sc_hd__a21o_1
X_5782_ _0093_ _1784_ _0092_ VSS VSS VDD VDD _1785_ sky130_fd_sc_hd__a21oi_1
X_5783_ _0089_ _0090_ VSS VSS VDD VDD _1786_ sky130_fd_sc_hd__nand2_1
X_5784_ _1651_ _1785_ _1786_ VSS VSS VDD VDD _1787_ sky130_fd_sc_hd__o21ai_0
X_5785_ _1781_ _1787_ VSS VSS VDD VDD _1788_ sky130_fd_sc_hd__nor2_1
X_5786_ _0084_ _0086_ _0088_ VSS VSS VDD VDD _1789_ sky130_fd_sc_hd__nor3_1
X_5787_ _1660_ _1751_ _1788_ _1789_ _1659_ VSS VSS VDD VDD
+ _1790_ sky130_fd_sc_hd__a221oi_1
X_5788_ _0082_ _1790_ VSS VSS VDD VDD _1791_ sky130_fd_sc_hd__nor2_1
X_5789_ _0081_ _1791_ VSS VSS VDD VDD _1792_ sky130_fd_sc_hd__xnor2_1
Xplace691 _3771_ VSS VSS VDD VDD net682 sky130_fd_sc_hd__buf_4
X_5791_ net710 net712 net671 VSS VSS VDD VDD _1794_ sky130_fd_sc_hd__mux2i_1
Xplace687 _2864_ VSS VSS VDD VDD net678 sky130_fd_sc_hd__buf_4
X_5793_ net715 net671 VSS VSS VDD VDD _1796_ sky130_fd_sc_hd__nand2_1
X_5794_ net709 _1670_ net658 VSS VSS VDD VDD _1797_ sky130_fd_sc_hd__a21oi_1
X_5795_ net658 _1794_ _1796_ _1797_ net689 VSS VSS VDD VDD
+ _1798_ sky130_fd_sc_hd__a221oi_1
X_5796_ _1728_ _1750_ _1792_ net690 _1798_ VSS VSS VDD VDD
+ _4617_ sky130_fd_sc_hd__a221o_1
X_5797_ _0083_ net691 _1653_ _1751_ VSS VSS VDD VDD _1799_
+ sky130_fd_sc_hd__or4_1
X_5798_ _0083_ net690 _1653_ _1660_ VSS VSS VDD VDD _1800_
+ sky130_fd_sc_hd__nand4_1
X_5799_ _0083_ _1660_ _1751_ VSS VSS VDD VDD _1801_ sky130_fd_sc_hd__nand3_1
X_5800_ _0083_ _1660_ _1801_ VSS VSS VDD VDD _1802_ sky130_fd_sc_hd__o21ai_0
Xplace686 _3278_ VSS VSS VDD VDD net677 sky130_fd_sc_hd__buf_4
Xplace685 _3780_ VSS VSS VDD VDD net676 sky130_fd_sc_hd__buf_4
Xplace684 _1019_ VSS VSS VDD VDD net675 sky130_fd_sc_hd__buf_4
X_5804_ cpuregs\[0\]\[28\] cpuregs\[1\]\[28\] cpuregs\[2\]\[28\]
+ cpuregs\[3\]\[28\] net774 net768 VSS VSS VDD VDD _1806_ sky130_fd_sc_hd__mux4_2
X_5805_ cpuregs\[4\]\[28\] cpuregs\[5\]\[28\] cpuregs\[6\]\[28\]
+ cpuregs\[7\]\[28\] net774 net768 VSS VSS VDD VDD _1807_ sky130_fd_sc_hd__mux4_2
X_5806_ cpuregs\[16\]\[28\] cpuregs\[17\]\[28\] cpuregs\[18\]\[28\]
+ cpuregs\[19\]\[28\] net774 net768 VSS VSS VDD VDD _1808_ sky130_fd_sc_hd__mux4_2
X_5807_ cpuregs\[20\]\[28\] cpuregs\[21\]\[28\] cpuregs\[22\]\[28\]
+ cpuregs\[23\]\[28\] net772 net767 VSS VSS VDD VDD _1809_ sky130_fd_sc_hd__mux4_2
X_5808_ _1806_ _1807_ _1808_ _1809_ net766 _0045_ VSS VSS
+ VDD VDD _1810_ sky130_fd_sc_hd__mux4_2
X_5809_ cpuregs\[8\]\[28\] cpuregs\[9\]\[28\] cpuregs\[10\]\[28\]
+ cpuregs\[11\]\[28\] net774 net768 VSS VSS VDD VDD _1811_ sky130_fd_sc_hd__mux4_2
X_5810_ cpuregs\[12\]\[28\] cpuregs\[13\]\[28\] cpuregs\[14\]\[28\]
+ cpuregs\[15\]\[28\] net774 net768 VSS VSS VDD VDD _1812_ sky130_fd_sc_hd__mux4_2
X_5811_ cpuregs\[24\]\[28\] cpuregs\[25\]\[28\] cpuregs\[26\]\[28\]
+ cpuregs\[27\]\[28\] net772 net767 VSS VSS VDD VDD _1813_ sky130_fd_sc_hd__mux4_2
X_5812_ cpuregs\[28\]\[28\] cpuregs\[29\]\[28\] cpuregs\[30\]\[28\]
+ cpuregs\[31\]\[28\] net774 net768 VSS VSS VDD VDD _1814_ sky130_fd_sc_hd__mux4_2
X_5813_ _1811_ _1812_ _1813_ _1814_ net766 _0045_ VSS VSS
+ VDD VDD _1815_ sky130_fd_sc_hd__mux4_2
X_5814_ _1810_ _1815_ net764 VSS VSS VDD VDD _1816_ sky130_fd_sc_hd__mux2i_1
Xplace683 cpuregs_wrdata\[5\] VSS VSS VDD VDD net674 sky130_fd_sc_hd__buf_4
X_5816_ reg_pc\[28\] net688 VSS VSS VDD VDD _1818_ sky130_fd_sc_hd__nand2_1
X_5817_ _1687_ _1816_ _1818_ VSS VSS VDD VDD _1819_ sky130_fd_sc_hd__o21ai_0
X_5818_ net329 net713 net671 VSS VSS VDD VDD _1820_ sky130_fd_sc_hd__mux2i_1
Xplace679 _2257_ VSS VSS VDD VDD net670 sky130_fd_sc_hd__buf_4
X_5820_ net716 net671 VSS VSS VDD VDD _1822_ sky130_fd_sc_hd__nand2_1
X_5821_ net658 _1820_ _1822_ _1797_ net689 VSS VSS VDD VDD
+ _1823_ sky130_fd_sc_hd__a221oi_1
X_5822_ net690 _1802_ _1819_ _1728_ _1823_ VSS VSS VDD VDD
+ _1824_ sky130_fd_sc_hd__a221oi_1
X_5823_ _1799_ _1800_ _1824_ VSS VSS VDD VDD _4616_ sky130_fd_sc_hd__nand3_1
Xplace678 _2273_ VSS VSS VDD VDD net669 sky130_fd_sc_hd__buf_4
X_5825_ _0088_ _1781_ _1787_ _0087_ VSS VSS VDD VDD _1826_
+ sky130_fd_sc_hd__o31ai_1
X_5826_ _0086_ net690 _1826_ _0085_ VSS VSS VDD VDD _1827_
+ sky130_fd_sc_hd__nand4b_1
Xplace677 _2421_ VSS VSS VDD VDD net668 sky130_fd_sc_hd__buf_4
X_5828_ net709 net717 net712 net714 net671 net658 VSS VSS
+ VDD VDD _1829_ sky130_fd_sc_hd__mux4_2
X_5829_ cpuregs\[0\]\[27\] cpuregs\[1\]\[27\] cpuregs\[2\]\[27\]
+ cpuregs\[3\]\[27\] net772 net767 VSS VSS VDD VDD _1830_ sky130_fd_sc_hd__mux4_2
X_5830_ cpuregs\[4\]\[27\] cpuregs\[5\]\[27\] cpuregs\[6\]\[27\]
+ cpuregs\[7\]\[27\] net772 net767 VSS VSS VDD VDD _1831_ sky130_fd_sc_hd__mux4_2
X_5831_ cpuregs\[16\]\[27\] cpuregs\[17\]\[27\] cpuregs\[18\]\[27\]
+ cpuregs\[19\]\[27\] net772 net767 VSS VSS VDD VDD _1832_ sky130_fd_sc_hd__mux4_2
X_5832_ cpuregs\[20\]\[27\] cpuregs\[21\]\[27\] cpuregs\[22\]\[27\]
+ cpuregs\[23\]\[27\] net772 net767 VSS VSS VDD VDD _1833_ sky130_fd_sc_hd__mux4_2
X_5833_ _1830_ _1831_ _1832_ _1833_ net765 net763 VSS VSS
+ VDD VDD _1834_ sky130_fd_sc_hd__mux4_2
X_5834_ cpuregs\[8\]\[27\] cpuregs\[9\]\[27\] cpuregs\[10\]\[27\]
+ cpuregs\[11\]\[27\] net772 net767 VSS VSS VDD VDD _1835_ sky130_fd_sc_hd__mux4_2
X_5835_ cpuregs\[12\]\[27\] cpuregs\[13\]\[27\] cpuregs\[14\]\[27\]
+ cpuregs\[15\]\[27\] net772 net767 VSS VSS VDD VDD _1836_ sky130_fd_sc_hd__mux4_2
X_5836_ cpuregs\[24\]\[27\] cpuregs\[25\]\[27\] cpuregs\[26\]\[27\]
+ cpuregs\[27\]\[27\] net772 net767 VSS VSS VDD VDD _1837_ sky130_fd_sc_hd__mux4_2
X_5837_ cpuregs\[28\]\[27\] cpuregs\[29\]\[27\] cpuregs\[30\]\[27\]
+ cpuregs\[31\]\[27\] net772 net767 VSS VSS VDD VDD _1838_ sky130_fd_sc_hd__mux4_2
X_5838_ _1835_ _1836_ _1837_ _1838_ net765 net763 VSS VSS
+ VDD VDD _1839_ sky130_fd_sc_hd__mux4_2
X_5839_ _1834_ _1839_ net764 VSS VSS VDD VDD _1840_ sky130_fd_sc_hd__mux2i_1
X_5840_ reg_pc\[27\] net688 VSS VSS VDD VDD _1841_ sky130_fd_sc_hd__nand2_1
X_5841_ _1687_ _1840_ _1841_ VSS VSS VDD VDD _1842_ sky130_fd_sc_hd__o21ai_0
X_5842_ _0085_ net691 _0086_ VSS VSS VDD VDD _1843_ sky130_fd_sc_hd__nor3b_1
X_5843_ net747 _1829_ _1842_ _1728_ _1843_ VSS VSS VDD VDD
+ _1844_ sky130_fd_sc_hd__a221oi_1
X_5844_ _0085_ net691 _1826_ _1827_ _1844_ VSS VSS VDD VDD
+ _4615_ sky130_fd_sc_hd__o311ai_0
Xplace676 net206 VSS VSS VDD VDD net667 sky130_fd_sc_hd__buf_4
X_5846_ _0087_ VSS VSS VDD VDD _1846_ sky130_fd_sc_hd__inv_1
X_5847_ _1846_ _1653_ VSS VSS VDD VDD _1847_ sky130_fd_sc_hd__xnor2_1
X_5848_ net713 net715 net710 net718 net671 net657 VSS VSS
+ VDD VDD _1848_ sky130_fd_sc_hd__mux4_2
Xplace675 net205 VSS VSS VDD VDD net666 sky130_fd_sc_hd__buf_4
Xplace674 net204 VSS VSS VDD VDD net665 sky130_fd_sc_hd__buf_4
Xplace673 net230 VSS VSS VDD VDD net664 sky130_fd_sc_hd__buf_4
Xplace672 _4265_ VSS VSS VDD VDD net663 sky130_fd_sc_hd__buf_4
X_5853_ cpuregs\[0\]\[26\] cpuregs\[1\]\[26\] cpuregs\[2\]\[26\]
+ cpuregs\[3\]\[26\] net774 net768 VSS VSS VDD VDD _1853_ sky130_fd_sc_hd__mux4_2
Xplace668 cpuregs_wrdata\[4\] VSS VSS VDD VDD net659 sky130_fd_sc_hd__buf_4
Xplace666 _1680_ VSS VSS VDD VDD net657 sky130_fd_sc_hd__buf_4
X_5856_ cpuregs\[4\]\[26\] cpuregs\[5\]\[26\] cpuregs\[6\]\[26\]
+ cpuregs\[7\]\[26\] net774 net768 VSS VSS VDD VDD _1856_ sky130_fd_sc_hd__mux4_2
Xplace665 _0520_ VSS VSS VDD VDD net656 sky130_fd_sc_hd__buf_4
Xplace664 cpuregs_wrdata\[12\] VSS VSS VDD VDD net655 sky130_fd_sc_hd__buf_4
X_5859_ cpuregs\[16\]\[26\] cpuregs\[17\]\[26\] cpuregs\[18\]\[26\]
+ cpuregs\[19\]\[26\] net774 net768 VSS VSS VDD VDD _1859_ sky130_fd_sc_hd__mux4_2
Xplace663 cpuregs_wrdata\[10\] VSS VSS VDD VDD net654 sky130_fd_sc_hd__buf_4
Xplace662 _4586_ VSS VSS VDD VDD net653 sky130_fd_sc_hd__buf_4
X_5862_ cpuregs\[20\]\[26\] cpuregs\[21\]\[26\] cpuregs\[22\]\[26\]
+ cpuregs\[23\]\[26\] net774 net768 VSS VSS VDD VDD _1862_ sky130_fd_sc_hd__mux4_2
Xplace630 _0843_ VSS VSS VDD VDD net621 sky130_fd_sc_hd__buf_4
Xplace628 _0521_ VSS VSS VDD VDD net619 sky130_fd_sc_hd__buf_4
X_5865_ _1853_ _1856_ _1859_ _1862_ net766 _0045_ VSS VSS
+ VDD VDD _1865_ sky130_fd_sc_hd__mux4_2
Xplace627 _0871_ VSS VSS VDD VDD net618 sky130_fd_sc_hd__buf_4
Xplace626 cpuregs_wrdata\[18\] VSS VSS VDD VDD net617 sky130_fd_sc_hd__buf_4
X_5868_ cpuregs\[8\]\[26\] cpuregs\[9\]\[26\] cpuregs\[10\]\[26\]
+ cpuregs\[11\]\[26\] net774 net768 VSS VSS VDD VDD _1868_ sky130_fd_sc_hd__mux4_2
Xplace625 cpuregs_wrdata\[14\] VSS VSS VDD VDD net616 sky130_fd_sc_hd__buf_4
Xplace624 cpuregs_wrdata\[13\] VSS VSS VDD VDD net615 sky130_fd_sc_hd__buf_4
X_5871_ cpuregs\[12\]\[26\] cpuregs\[13\]\[26\] cpuregs\[14\]\[26\]
+ cpuregs\[15\]\[26\] net774 net768 VSS VSS VDD VDD _1871_ sky130_fd_sc_hd__mux4_2
X_5872_ cpuregs\[24\]\[26\] cpuregs\[25\]\[26\] cpuregs\[26\]\[26\]
+ cpuregs\[27\]\[26\] net772 net767 VSS VSS VDD VDD _1872_ sky130_fd_sc_hd__mux4_2
Xplace623 cpuregs_wrdata\[11\] VSS VSS VDD VDD net614 sky130_fd_sc_hd__buf_4
Xplace622 cpuregs_wrdata\[9\] VSS VSS VDD VDD net613 sky130_fd_sc_hd__buf_4
X_5875_ cpuregs\[28\]\[26\] cpuregs\[29\]\[26\] cpuregs\[30\]\[26\]
+ cpuregs\[31\]\[26\] net772 net767 VSS VSS VDD VDD _1875_ sky130_fd_sc_hd__mux4_2
Xplace620 _0830_ VSS VSS VDD VDD net611 sky130_fd_sc_hd__buf_4
Xplace619 cpuregs_wrdata\[20\] VSS VSS VDD VDD net610 sky130_fd_sc_hd__buf_4
X_5878_ _1868_ _1871_ _1872_ _1875_ net766 _0045_ VSS VSS
+ VDD VDD _1878_ sky130_fd_sc_hd__mux4_2
Xplace618 _1079_ VSS VSS VDD VDD net609 sky130_fd_sc_hd__buf_4
X_5880_ _1865_ _1878_ net764 VSS VSS VDD VDD _1880_ sky130_fd_sc_hd__mux2i_1
Xplace616 cpuregs_wrdata\[21\] VSS VSS VDD VDD net607 sky130_fd_sc_hd__buf_4
X_5882_ reg_pc\[26\] net688 VSS VSS VDD VDD _1882_ sky130_fd_sc_hd__nand2_1
X_5883_ _1687_ _1880_ _1882_ VSS VSS VDD VDD _1883_ sky130_fd_sc_hd__o21ai_0
Xplace608 _0527_ VSS VSS VDD VDD net599 sky130_fd_sc_hd__buf_4
X_5885_ net747 _1848_ _1883_ _1728_ VSS VSS VDD VDD _1885_
+ sky130_fd_sc_hd__a22oi_1
X_5886_ net691 _1847_ _1885_ VSS VSS VDD VDD _4614_ sky130_fd_sc_hd__o21ai_0
X_5887_ _1757_ _1761_ _1778_ VSS VSS VDD VDD _1886_ sky130_fd_sc_hd__or3_1
X_5888_ _1779_ _1886_ VSS VSS VDD VDD _1887_ sky130_fd_sc_hd__nand2b_1
X_5889_ _1785_ _1887_ VSS VSS VDD VDD _1888_ sky130_fd_sc_hd__nand2_1
X_5890_ _0091_ _1888_ _0089_ _0090_ VSS VSS VDD VDD _1889_
+ sky130_fd_sc_hd__a211oi_1
X_5891_ net690 _1788_ VSS VSS VDD VDD _1890_ sky130_fd_sc_hd__nand2_1
Xplace609 cpuregs_wrdata\[24\] VSS VSS VDD VDD net600 sky130_fd_sc_hd__buf_4
Xplace669 cpuregs_wrdata\[8\] VSS VSS VDD VDD net660 sky130_fd_sc_hd__buf_4
Xclkbuf_leaf_0_clk clknet_4_0_0_clk VSS VSS VDD VDD clknet_leaf_0_clk
+ sky130_fd_sc_hd__clkbuf_16
X_5895_ net329 net714 net719 net716 net658 net671 VSS VSS
+ VDD VDD _1894_ sky130_fd_sc_hd__mux4_2
X_5896_ cpuregs\[0\]\[25\] cpuregs\[1\]\[25\] cpuregs\[2\]\[25\]
+ cpuregs\[3\]\[25\] net774 net768 VSS VSS VDD VDD _1895_ sky130_fd_sc_hd__mux4_2
Xplace670 _0869_ VSS VSS VDD VDD net661 sky130_fd_sc_hd__buf_4
Xplace667 _1675_ VSS VSS VDD VDD net658 sky130_fd_sc_hd__buf_4
X_5899_ cpuregs\[4\]\[25\] cpuregs\[5\]\[25\] cpuregs\[6\]\[25\]
+ cpuregs\[7\]\[25\] net774 net768 VSS VSS VDD VDD _1898_ sky130_fd_sc_hd__mux4_2
X_5900_ cpuregs\[16\]\[25\] cpuregs\[17\]\[25\] cpuregs\[18\]\[25\]
+ cpuregs\[19\]\[25\] net774 net768 VSS VSS VDD VDD _1899_ sky130_fd_sc_hd__mux4_2
X_5901_ cpuregs\[20\]\[25\] cpuregs\[21\]\[25\] cpuregs\[22\]\[25\]
+ cpuregs\[23\]\[25\] net774 net768 VSS VSS VDD VDD _1900_ sky130_fd_sc_hd__mux4_2
X_5902_ _1895_ _1898_ _1899_ _1900_ net766 _0045_ VSS VSS
+ VDD VDD _1901_ sky130_fd_sc_hd__mux4_2
X_5903_ cpuregs\[8\]\[25\] cpuregs\[9\]\[25\] cpuregs\[10\]\[25\]
+ cpuregs\[11\]\[25\] net774 net768 VSS VSS VDD VDD _1902_ sky130_fd_sc_hd__mux4_2
X_5904_ cpuregs\[12\]\[25\] cpuregs\[13\]\[25\] cpuregs\[14\]\[25\]
+ cpuregs\[15\]\[25\] net774 net768 VSS VSS VDD VDD _1903_ sky130_fd_sc_hd__mux4_2
Xplace612 cpuregs_wrdata\[23\] VSS VSS VDD VDD net603 sky130_fd_sc_hd__buf_4
Xclkbuf_leaf_1_clk clknet_4_0_0_clk VSS VSS VDD VDD clknet_leaf_1_clk
+ sky130_fd_sc_hd__clkbuf_16
X_5907_ cpuregs\[24\]\[25\] cpuregs\[25\]\[25\] cpuregs\[26\]\[25\]
+ cpuregs\[27\]\[25\] net774 net768 VSS VSS VDD VDD _1906_ sky130_fd_sc_hd__mux4_2
X_5908_ cpuregs\[28\]\[25\] cpuregs\[29\]\[25\] cpuregs\[30\]\[25\]
+ cpuregs\[31\]\[25\] net774 net768 VSS VSS VDD VDD _1907_ sky130_fd_sc_hd__mux4_2
X_5909_ _1902_ _1903_ _1906_ _1907_ net766 _0045_ VSS VSS
+ VDD VDD _1908_ sky130_fd_sc_hd__mux4_2
X_5910_ _1901_ _1908_ net764 VSS VSS VDD VDD _1909_ sky130_fd_sc_hd__mux2i_1
X_5911_ reg_pc\[25\] net688 VSS VSS VDD VDD _1910_ sky130_fd_sc_hd__nand2_1
X_5912_ _1687_ _1909_ _1910_ VSS VSS VDD VDD _1911_ sky130_fd_sc_hd__o21ai_0
X_5913_ net747 _1894_ _1911_ _1728_ VSS VSS VDD VDD _1912_
+ sky130_fd_sc_hd__a22oi_1
X_5914_ _1889_ _1890_ _1912_ VSS VSS VDD VDD _4613_ sky130_fd_sc_hd__o21ai_0
X_5915_ _0091_ _1650_ VSS VSS VDD VDD _1913_ sky130_fd_sc_hd__xor2_1
X_5916_ net712 net715 net720 net717 net658 net671 VSS VSS
+ VDD VDD _1914_ sky130_fd_sc_hd__mux4_2
X_5917_ cpuregs\[0\]\[24\] cpuregs\[1\]\[24\] cpuregs\[2\]\[24\]
+ cpuregs\[3\]\[24\] net774 net768 VSS VSS VDD VDD _1915_ sky130_fd_sc_hd__mux4_2
X_5918_ cpuregs\[4\]\[24\] cpuregs\[5\]\[24\] cpuregs\[6\]\[24\]
+ cpuregs\[7\]\[24\] net772 net767 VSS VSS VDD VDD _1916_ sky130_fd_sc_hd__mux4_2
X_5919_ cpuregs\[16\]\[24\] cpuregs\[17\]\[24\] cpuregs\[18\]\[24\]
+ cpuregs\[19\]\[24\] net772 net767 VSS VSS VDD VDD _1917_ sky130_fd_sc_hd__mux4_2
X_5920_ cpuregs\[20\]\[24\] cpuregs\[21\]\[24\] cpuregs\[22\]\[24\]
+ cpuregs\[23\]\[24\] net772 net767 VSS VSS VDD VDD _1918_ sky130_fd_sc_hd__mux4_2
Xclkbuf_leaf_2_clk clknet_4_2_0_clk VSS VSS VDD VDD clknet_leaf_2_clk
+ sky130_fd_sc_hd__clkbuf_16
X_5922_ _1915_ _1916_ _1917_ _1918_ net766 _0045_ VSS VSS
+ VDD VDD _1920_ sky130_fd_sc_hd__mux4_2
X_5923_ cpuregs\[8\]\[24\] cpuregs\[9\]\[24\] cpuregs\[10\]\[24\]
+ cpuregs\[11\]\[24\] net772 net767 VSS VSS VDD VDD _1921_ sky130_fd_sc_hd__mux4_2
X_5924_ cpuregs\[12\]\[24\] cpuregs\[13\]\[24\] cpuregs\[14\]\[24\]
+ cpuregs\[15\]\[24\] net772 net767 VSS VSS VDD VDD _1922_ sky130_fd_sc_hd__mux4_2
X_5925_ cpuregs\[24\]\[24\] cpuregs\[25\]\[24\] cpuregs\[26\]\[24\]
+ cpuregs\[27\]\[24\] net772 net767 VSS VSS VDD VDD _1923_ sky130_fd_sc_hd__mux4_2
X_5926_ cpuregs\[28\]\[24\] cpuregs\[29\]\[24\] cpuregs\[30\]\[24\]
+ cpuregs\[31\]\[24\] net772 net767 VSS VSS VDD VDD _1924_ sky130_fd_sc_hd__mux4_2
X_5927_ _1921_ _1922_ _1923_ _1924_ net766 _0045_ VSS VSS
+ VDD VDD _1925_ sky130_fd_sc_hd__mux4_2
X_5928_ _1920_ _1925_ net764 VSS VSS VDD VDD _1926_ sky130_fd_sc_hd__mux2i_1
X_5929_ reg_pc\[24\] net688 VSS VSS VDD VDD _1927_ sky130_fd_sc_hd__nand2_1
X_5930_ _1687_ _1926_ _1927_ VSS VSS VDD VDD _1928_ sky130_fd_sc_hd__o21ai_0
X_5931_ net747 _1914_ _1928_ _1728_ VSS VSS VDD VDD _1929_
+ sky130_fd_sc_hd__a22oi_1
X_5932_ net691 _1913_ _1929_ VSS VSS VDD VDD _4612_ sky130_fd_sc_hd__o21ai_0
X_5933_ _0101_ _1618_ _1886_ _1784_ VSS VSS VDD VDD _1930_
+ sky130_fd_sc_hd__a31oi_1
X_5934_ _0093_ _1930_ VSS VSS VDD VDD _1931_ sky130_fd_sc_hd__xor2_1
Xplace785 net171 VSS VSS VDD VDD net776 sky130_fd_sc_hd__buf_4
Xplace784 net171 VSS VSS VDD VDD net775 sky130_fd_sc_hd__buf_4
X_5937_ cpuregs\[0\]\[23\] cpuregs\[1\]\[23\] cpuregs\[2\]\[23\]
+ cpuregs\[3\]\[23\] net772 net767 VSS VSS VDD VDD _1934_ sky130_fd_sc_hd__mux4_2
Xplace779 net771 VSS VSS VDD VDD net770 sky130_fd_sc_hd__buf_12
Xplace776 net768 VSS VSS VDD VDD net767 sky130_fd_sc_hd__buf_4
X_5940_ cpuregs\[4\]\[23\] cpuregs\[5\]\[23\] cpuregs\[6\]\[23\]
+ cpuregs\[7\]\[23\] net772 net767 VSS VSS VDD VDD _1937_ sky130_fd_sc_hd__mux4_2
Xplace774 net766 VSS VSS VDD VDD net765 sky130_fd_sc_hd__buf_4
Xplace611 cpuregs_wrdata\[28\] VSS VSS VDD VDD net602 sky130_fd_sc_hd__buf_4
X_5943_ cpuregs\[16\]\[23\] cpuregs\[17\]\[23\] cpuregs\[18\]\[23\]
+ cpuregs\[19\]\[23\] net772 net767 VSS VSS VDD VDD _1940_ sky130_fd_sc_hd__mux4_2
Xplace773 _0044_ VSS VSS VDD VDD net764 sky130_fd_sc_hd__buf_4
Xplace610 cpuregs_wrdata\[27\] VSS VSS VDD VDD net601 sky130_fd_sc_hd__buf_4
X_5946_ cpuregs\[20\]\[23\] cpuregs\[21\]\[23\] cpuregs\[22\]\[23\]
+ cpuregs\[23\]\[23\] net772 net767 VSS VSS VDD VDD _1943_ sky130_fd_sc_hd__mux4_2
Xplace607 cpuregs_wrdata\[31\] VSS VSS VDD VDD net598 sky130_fd_sc_hd__buf_4
X_5948_ _1934_ _1937_ _1940_ _1943_ net766 net763 VSS VSS
+ VDD VDD _1945_ sky130_fd_sc_hd__mux4_2
X_5949_ cpuregs\[8\]\[23\] cpuregs\[9\]\[23\] cpuregs\[10\]\[23\]
+ cpuregs\[11\]\[23\] net772 net767 VSS VSS VDD VDD _1946_ sky130_fd_sc_hd__mux4_2
X_5950_ cpuregs\[12\]\[23\] cpuregs\[13\]\[23\] cpuregs\[14\]\[23\]
+ cpuregs\[15\]\[23\] net772 net767 VSS VSS VDD VDD _1947_ sky130_fd_sc_hd__mux4_2
X_5951_ cpuregs\[24\]\[23\] cpuregs\[25\]\[23\] cpuregs\[26\]\[23\]
+ cpuregs\[27\]\[23\] net772 net767 VSS VSS VDD VDD _1948_ sky130_fd_sc_hd__mux4_2
X_5952_ cpuregs\[28\]\[23\] cpuregs\[29\]\[23\] cpuregs\[30\]\[23\]
+ cpuregs\[31\]\[23\] net772 net767 VSS VSS VDD VDD _1949_ sky130_fd_sc_hd__mux4_2
X_5953_ _1946_ _1947_ _1948_ _1949_ net765 net763 VSS VSS
+ VDD VDD _1950_ sky130_fd_sc_hd__mux4_2
X_5954_ _1945_ _1950_ net764 VSS VSS VDD VDD _1951_ sky130_fd_sc_hd__mux2i_1
X_5955_ reg_pc\[23\] net688 VSS VSS VDD VDD _1952_ sky130_fd_sc_hd__nand2_1
X_5956_ _1687_ _1951_ _1952_ VSS VSS VDD VDD _1953_ sky130_fd_sc_hd__o21ai_0
X_5957_ net713 net716 net722 net718 net658 net671 VSS VSS
+ VDD VDD _1954_ sky130_fd_sc_hd__mux4_2
X_5958_ _1728_ _1953_ _1954_ net747 VSS VSS VDD VDD _1955_
+ sky130_fd_sc_hd__a22oi_1
X_5959_ net691 _1931_ _1955_ VSS VSS VDD VDD _4611_ sky130_fd_sc_hd__o21ai_0
X_5960_ _1620_ _1638_ VSS VSS VDD VDD _1956_ sky130_fd_sc_hd__nor2_1
X_5961_ _1647_ _1956_ VSS VSS VDD VDD _1957_ sky130_fd_sc_hd__nor2_1
X_5962_ _0101_ _1957_ VSS VSS VDD VDD _1958_ sky130_fd_sc_hd__xor2_1
X_5963_ cpuregs\[0\]\[22\] cpuregs\[1\]\[22\] cpuregs\[2\]\[22\]
+ cpuregs\[3\]\[22\] net773 net768 VSS VSS VDD VDD _1959_ sky130_fd_sc_hd__mux4_2
X_5964_ cpuregs\[4\]\[22\] cpuregs\[5\]\[22\] cpuregs\[6\]\[22\]
+ cpuregs\[7\]\[22\] net773 net768 VSS VSS VDD VDD _1960_ sky130_fd_sc_hd__mux4_2
X_5965_ cpuregs\[16\]\[22\] cpuregs\[17\]\[22\] cpuregs\[18\]\[22\]
+ cpuregs\[19\]\[22\] net773 net768 VSS VSS VDD VDD _1961_ sky130_fd_sc_hd__mux4_2
X_5966_ cpuregs\[20\]\[22\] cpuregs\[21\]\[22\] cpuregs\[22\]\[22\]
+ cpuregs\[23\]\[22\] net773 net768 VSS VSS VDD VDD _1962_ sky130_fd_sc_hd__mux4_2
X_5967_ _1959_ _1960_ _1961_ _1962_ net765 net763 VSS VSS
+ VDD VDD _1963_ sky130_fd_sc_hd__mux4_2
X_5968_ cpuregs\[8\]\[22\] cpuregs\[9\]\[22\] cpuregs\[10\]\[22\]
+ cpuregs\[11\]\[22\] net773 net768 VSS VSS VDD VDD _1964_ sky130_fd_sc_hd__mux4_2
X_5969_ cpuregs\[12\]\[22\] cpuregs\[13\]\[22\] cpuregs\[14\]\[22\]
+ cpuregs\[15\]\[22\] net773 net768 VSS VSS VDD VDD _1965_ sky130_fd_sc_hd__mux4_2
X_5970_ cpuregs\[24\]\[22\] cpuregs\[25\]\[22\] cpuregs\[26\]\[22\]
+ cpuregs\[27\]\[22\] net773 net768 VSS VSS VDD VDD _1966_ sky130_fd_sc_hd__mux4_2
X_5971_ cpuregs\[28\]\[22\] cpuregs\[29\]\[22\] cpuregs\[30\]\[22\]
+ cpuregs\[31\]\[22\] net773 net768 VSS VSS VDD VDD _1967_ sky130_fd_sc_hd__mux4_2
X_5972_ _1964_ _1965_ _1966_ _1967_ net765 net763 VSS VSS
+ VDD VDD _1968_ sky130_fd_sc_hd__mux4_2
X_5973_ _1963_ _1968_ net764 VSS VSS VDD VDD _1969_ sky130_fd_sc_hd__mux2i_1
X_5974_ reg_pc\[22\] net688 VSS VSS VDD VDD _1970_ sky130_fd_sc_hd__nand2_1
X_5975_ _1687_ _1969_ _1970_ VSS VSS VDD VDD _1971_ sky130_fd_sc_hd__o21ai_0
X_5976_ net714 net717 net723 net719 net658 net671 VSS VSS
+ VDD VDD _1972_ sky130_fd_sc_hd__mux4_2
Xplace697 _1724_ VSS VSS VDD VDD net688 sky130_fd_sc_hd__buf_4
X_5978_ _1728_ _1971_ _1972_ net747 VSS VSS VDD VDD _1974_
+ sky130_fd_sc_hd__a22oi_1
X_5979_ net691 _1958_ _1974_ VSS VSS VDD VDD _4610_ sky130_fd_sc_hd__o21ai_0
X_5980_ _0173_ _1886_ _0172_ VSS VSS VDD VDD _1975_ sky130_fd_sc_hd__a21o_1
X_5981_ _0171_ _1975_ _0170_ VSS VSS VDD VDD _1976_ sky130_fd_sc_hd__a21oi_1
X_5982_ _0169_ _1976_ VSS VSS VDD VDD _1977_ sky130_fd_sc_hd__xor2_1
X_5983_ cpuregs\[0\]\[21\] cpuregs\[1\]\[21\] cpuregs\[2\]\[21\]
+ cpuregs\[3\]\[21\] net773 net768 VSS VSS VDD VDD _1978_ sky130_fd_sc_hd__mux4_2
X_5984_ cpuregs\[4\]\[21\] cpuregs\[5\]\[21\] cpuregs\[6\]\[21\]
+ cpuregs\[7\]\[21\] net770 net768 VSS VSS VDD VDD _1979_ sky130_fd_sc_hd__mux4_2
X_5985_ cpuregs\[16\]\[21\] cpuregs\[17\]\[21\] cpuregs\[18\]\[21\]
+ cpuregs\[19\]\[21\] net770 net768 VSS VSS VDD VDD _1980_ sky130_fd_sc_hd__mux4_2
X_5986_ cpuregs\[20\]\[21\] cpuregs\[21\]\[21\] cpuregs\[22\]\[21\]
+ cpuregs\[23\]\[21\] net770 net768 VSS VSS VDD VDD _1981_ sky130_fd_sc_hd__mux4_2
X_5987_ _1978_ _1979_ _1980_ _1981_ net765 net763 VSS VSS
+ VDD VDD _1982_ sky130_fd_sc_hd__mux4_2
X_5988_ cpuregs\[8\]\[21\] cpuregs\[9\]\[21\] cpuregs\[10\]\[21\]
+ cpuregs\[11\]\[21\] net770 net768 VSS VSS VDD VDD _1983_ sky130_fd_sc_hd__mux4_2
X_5989_ cpuregs\[12\]\[21\] cpuregs\[13\]\[21\] cpuregs\[14\]\[21\]
+ cpuregs\[15\]\[21\] net770 net768 VSS VSS VDD VDD _1984_ sky130_fd_sc_hd__mux4_2
X_5990_ cpuregs\[24\]\[21\] cpuregs\[25\]\[21\] cpuregs\[26\]\[21\]
+ cpuregs\[27\]\[21\] net770 net768 VSS VSS VDD VDD _1985_ sky130_fd_sc_hd__mux4_2
X_5991_ cpuregs\[28\]\[21\] cpuregs\[29\]\[21\] cpuregs\[30\]\[21\]
+ cpuregs\[31\]\[21\] net770 net768 VSS VSS VDD VDD _1986_ sky130_fd_sc_hd__mux4_2
X_5992_ _1983_ _1984_ _1985_ _1986_ net765 net763 VSS VSS
+ VDD VDD _1987_ sky130_fd_sc_hd__mux4_2
X_5993_ _1982_ _1987_ net764 VSS VSS VDD VDD _1988_ sky130_fd_sc_hd__mux2i_1
X_5994_ reg_pc\[21\] net688 VSS VSS VDD VDD _1989_ sky130_fd_sc_hd__nand2_1
X_5995_ _1687_ _1988_ _1989_ VSS VSS VDD VDD _1990_ sky130_fd_sc_hd__o21ai_0
X_5996_ net715 net718 net724 net720 net658 net671 VSS VSS
+ VDD VDD _1991_ sky130_fd_sc_hd__mux4_2
X_5997_ _1728_ _1990_ _1991_ net747 VSS VSS VDD VDD _1992_
+ sky130_fd_sc_hd__a22oi_1
X_5998_ net691 _1977_ _1992_ VSS VSS VDD VDD _4609_ sky130_fd_sc_hd__o21ai_0
X_5999_ _1640_ _1638_ VSS VSS VDD VDD _1993_ sky130_fd_sc_hd__nand2b_1
X_6000_ _0177_ _0178_ _0176_ VSS VSS VDD VDD _1994_ sky130_fd_sc_hd__a21o_1
X_6001_ _0175_ _1994_ _0174_ VSS VSS VDD VDD _1995_ sky130_fd_sc_hd__a21oi_1
X_6002_ _1995_ _0173_ VSS VSS VDD VDD _1996_ sky130_fd_sc_hd__nor2b_1
X_6003_ _0173_ _1619_ _1993_ _1996_ _0172_ VSS VSS VDD VDD
+ _1997_ sky130_fd_sc_hd__a311oi_1
X_6004_ _0171_ _1997_ VSS VSS VDD VDD _1998_ sky130_fd_sc_hd__xor2_1
X_6005_ cpuregs\[0\]\[20\] cpuregs\[1\]\[20\] cpuregs\[2\]\[20\]
+ cpuregs\[3\]\[20\] net772 net767 VSS VSS VDD VDD _1999_ sky130_fd_sc_hd__mux4_2
X_6006_ cpuregs\[4\]\[20\] cpuregs\[5\]\[20\] cpuregs\[6\]\[20\]
+ cpuregs\[7\]\[20\] net772 net767 VSS VSS VDD VDD _2000_ sky130_fd_sc_hd__mux4_2
X_6007_ cpuregs\[16\]\[20\] cpuregs\[17\]\[20\] cpuregs\[18\]\[20\]
+ cpuregs\[19\]\[20\] net772 net767 VSS VSS VDD VDD _2001_ sky130_fd_sc_hd__mux4_2
X_6008_ cpuregs\[20\]\[20\] cpuregs\[21\]\[20\] cpuregs\[22\]\[20\]
+ cpuregs\[23\]\[20\] net772 net767 VSS VSS VDD VDD _2002_ sky130_fd_sc_hd__mux4_2
X_6009_ _1999_ _2000_ _2001_ _2002_ net766 _0045_ VSS VSS
+ VDD VDD _2003_ sky130_fd_sc_hd__mux4_2
X_6010_ cpuregs\[8\]\[20\] cpuregs\[9\]\[20\] cpuregs\[10\]\[20\]
+ cpuregs\[11\]\[20\] net772 net767 VSS VSS VDD VDD _2004_ sky130_fd_sc_hd__mux4_2
X_6011_ cpuregs\[12\]\[20\] cpuregs\[13\]\[20\] cpuregs\[14\]\[20\]
+ cpuregs\[15\]\[20\] net772 net767 VSS VSS VDD VDD _2005_ sky130_fd_sc_hd__mux4_2
X_6012_ cpuregs\[24\]\[20\] cpuregs\[25\]\[20\] cpuregs\[26\]\[20\]
+ cpuregs\[27\]\[20\] net772 net767 VSS VSS VDD VDD _2006_ sky130_fd_sc_hd__mux4_2
X_6013_ cpuregs\[28\]\[20\] cpuregs\[29\]\[20\] cpuregs\[30\]\[20\]
+ cpuregs\[31\]\[20\] net772 net767 VSS VSS VDD VDD _2007_ sky130_fd_sc_hd__mux4_2
X_6014_ _2004_ _2005_ _2006_ _2007_ net766 _0045_ VSS VSS
+ VDD VDD _2008_ sky130_fd_sc_hd__mux4_2
X_6015_ _2003_ _2008_ net764 VSS VSS VDD VDD _2009_ sky130_fd_sc_hd__mux2i_1
X_6016_ reg_pc\[20\] net688 VSS VSS VDD VDD _2010_ sky130_fd_sc_hd__nand2_1
X_6017_ _1687_ _2009_ _2010_ VSS VSS VDD VDD _2011_ sky130_fd_sc_hd__o21ai_0
X_6018_ net719 net716 net722 net725 net657 net671 VSS VSS
+ VDD VDD _2012_ sky130_fd_sc_hd__mux4_2
X_6019_ _1728_ _2011_ _2012_ net747 VSS VSS VDD VDD _2013_
+ sky130_fd_sc_hd__a22oi_1
X_6020_ net691 _1998_ _2013_ VSS VSS VDD VDD _4608_ sky130_fd_sc_hd__o21ai_0
X_6021_ _0173_ _1886_ VSS VSS VDD VDD _2014_ sky130_fd_sc_hd__xnor2_1
Xplace680 _1671_ VSS VSS VDD VDD net671 sky130_fd_sc_hd__buf_4
X_6023_ _0108_ _0246_ _0123_ _0313_ net671 net657 VSS VSS
+ VDD VDD _2016_ sky130_fd_sc_hd__mux4_2
X_6024_ cpuregs\[0\]\[19\] cpuregs\[1\]\[19\] cpuregs\[2\]\[19\]
+ cpuregs\[3\]\[19\] net771 net768 VSS VSS VDD VDD _2017_ sky130_fd_sc_hd__mux4_2
X_6025_ cpuregs\[4\]\[19\] cpuregs\[5\]\[19\] cpuregs\[6\]\[19\]
+ cpuregs\[7\]\[19\] net771 net768 VSS VSS VDD VDD _2018_ sky130_fd_sc_hd__mux4_2
X_6026_ cpuregs\[16\]\[19\] cpuregs\[17\]\[19\] cpuregs\[18\]\[19\]
+ cpuregs\[19\]\[19\] net771 net768 VSS VSS VDD VDD _2019_ sky130_fd_sc_hd__mux4_2
X_6027_ cpuregs\[20\]\[19\] cpuregs\[21\]\[19\] cpuregs\[22\]\[19\]
+ cpuregs\[23\]\[19\] net771 net768 VSS VSS VDD VDD _2020_ sky130_fd_sc_hd__mux4_2
X_6028_ _2017_ _2018_ _2019_ _2020_ net765 net763 VSS VSS
+ VDD VDD _2021_ sky130_fd_sc_hd__mux4_2
X_6029_ cpuregs\[8\]\[19\] cpuregs\[9\]\[19\] cpuregs\[10\]\[19\]
+ cpuregs\[11\]\[19\] net771 net769 VSS VSS VDD VDD _2022_ sky130_fd_sc_hd__mux4_2
X_6030_ cpuregs\[12\]\[19\] cpuregs\[13\]\[19\] cpuregs\[14\]\[19\]
+ cpuregs\[15\]\[19\] net771 net769 VSS VSS VDD VDD _2023_ sky130_fd_sc_hd__mux4_2
X_6031_ cpuregs\[24\]\[19\] cpuregs\[25\]\[19\] cpuregs\[26\]\[19\]
+ cpuregs\[27\]\[19\] net771 net769 VSS VSS VDD VDD _2024_ sky130_fd_sc_hd__mux4_2
X_6032_ cpuregs\[28\]\[19\] cpuregs\[29\]\[19\] cpuregs\[30\]\[19\]
+ cpuregs\[31\]\[19\] net771 net769 VSS VSS VDD VDD _2025_ sky130_fd_sc_hd__mux4_2
Xplace778 _0042_ VSS VSS VDD VDD net769 sky130_fd_sc_hd__buf_4
X_6034_ _2022_ _2023_ _2024_ _2025_ net766 net763 VSS VSS
+ VDD VDD _2027_ sky130_fd_sc_hd__mux4_2
X_6035_ _2021_ _2027_ net764 VSS VSS VDD VDD _2028_ sky130_fd_sc_hd__mux2i_1
X_6036_ reg_pc\[19\] net688 VSS VSS VDD VDD _2029_ sky130_fd_sc_hd__nand2_1
X_6037_ _1687_ _2028_ _2029_ VSS VSS VDD VDD _2030_ sky130_fd_sc_hd__o21ai_0
X_6038_ _1728_ _2030_ VSS VSS VDD VDD _2031_ sky130_fd_sc_hd__nand2_1
X_6039_ net691 _2014_ _2016_ net689 _2031_ VSS VSS VDD VDD
+ _4606_ sky130_fd_sc_hd__o221ai_1
X_6040_ _0177_ _0179_ VSS VSS VDD VDD _2032_ sky130_fd_sc_hd__nand2_1
X_6041_ _1638_ _2032_ _1642_ VSS VSS VDD VDD _2033_ sky130_fd_sc_hd__o21ai_0
X_6042_ _0175_ _2033_ VSS VSS VDD VDD _2034_ sky130_fd_sc_hd__xor2_1
X_6043_ net718 net722 net727 net724 net658 net671 VSS VSS
+ VDD VDD _2035_ sky130_fd_sc_hd__mux4_2
X_6044_ net689 net691 VSS VSS VDD VDD _2036_ sky130_fd_sc_hd__nand2_1
X_6045_ cpuregs\[0\]\[18\] cpuregs\[1\]\[18\] cpuregs\[2\]\[18\]
+ cpuregs\[3\]\[18\] net771 net769 VSS VSS VDD VDD _2037_ sky130_fd_sc_hd__mux4_2
X_6046_ cpuregs\[4\]\[18\] cpuregs\[5\]\[18\] cpuregs\[6\]\[18\]
+ cpuregs\[7\]\[18\] net770 net768 VSS VSS VDD VDD _2038_ sky130_fd_sc_hd__mux4_2
X_6047_ cpuregs\[16\]\[18\] cpuregs\[17\]\[18\] cpuregs\[18\]\[18\]
+ cpuregs\[19\]\[18\] net770 net768 VSS VSS VDD VDD _2039_ sky130_fd_sc_hd__mux4_2
X_6048_ cpuregs\[20\]\[18\] cpuregs\[21\]\[18\] cpuregs\[22\]\[18\]
+ cpuregs\[23\]\[18\] net770 net768 VSS VSS VDD VDD _2040_ sky130_fd_sc_hd__mux4_2
X_6049_ _2037_ _2038_ _2039_ _2040_ net765 net763 VSS VSS
+ VDD VDD _2041_ sky130_fd_sc_hd__mux4_2
X_6050_ cpuregs\[8\]\[18\] cpuregs\[9\]\[18\] cpuregs\[10\]\[18\]
+ cpuregs\[11\]\[18\] net770 net769 VSS VSS VDD VDD _2042_ sky130_fd_sc_hd__mux4_2
X_6051_ cpuregs\[12\]\[18\] cpuregs\[13\]\[18\] cpuregs\[14\]\[18\]
+ cpuregs\[15\]\[18\] net770 net769 VSS VSS VDD VDD _2043_ sky130_fd_sc_hd__mux4_2
X_6052_ cpuregs\[24\]\[18\] cpuregs\[25\]\[18\] cpuregs\[26\]\[18\]
+ cpuregs\[27\]\[18\] net770 net769 VSS VSS VDD VDD _2044_ sky130_fd_sc_hd__mux4_2
X_6053_ cpuregs\[28\]\[18\] cpuregs\[29\]\[18\] cpuregs\[30\]\[18\]
+ cpuregs\[31\]\[18\] net770 net769 VSS VSS VDD VDD _2045_ sky130_fd_sc_hd__mux4_2
X_6054_ _2042_ _2043_ _2044_ _2045_ net765 net763 VSS VSS
+ VDD VDD _2046_ sky130_fd_sc_hd__mux4_2
X_6055_ _2041_ _2046_ net764 VSS VSS VDD VDD _2047_ sky130_fd_sc_hd__mux2i_1
X_6056_ _1687_ _2047_ VSS VSS VDD VDD _2048_ sky130_fd_sc_hd__nor2_1
X_6057_ reg_pc\[18\] net688 _2048_ VSS VSS VDD VDD _2049_
+ sky130_fd_sc_hd__a21oi_1
X_6058_ _2036_ _2049_ VSS VSS VDD VDD _2050_ sky130_fd_sc_hd__nor2_1
X_6059_ net690 _2034_ _2035_ net746 _2050_ VSS VSS VDD VDD
+ _4605_ sky130_fd_sc_hd__a221o_1
X_6060_ _0186_ _0188_ VSS VSS VDD VDD _2051_ sky130_fd_sc_hd__nor2_1
X_6061_ _0186_ _0188_ _0189_ VSS VSS VDD VDD _2052_ sky130_fd_sc_hd__or3_1
X_6062_ _0186_ _0187_ _2052_ VSS VSS VDD VDD _2053_ sky130_fd_sc_hd__o21ai_0
X_6063_ _1768_ _1776_ _2051_ _2053_ VSS VSS VDD VDD _2054_
+ sky130_fd_sc_hd__a31oi_1
X_6064_ _0185_ _2054_ _0184_ VSS VSS VDD VDD _2055_ sky130_fd_sc_hd__a21oi_1
X_6065_ _1637_ _2055_ _1753_ VSS VSS VDD VDD _2056_ sky130_fd_sc_hd__o21ai_0
X_6066_ _0180_ _2056_ _0179_ VSS VSS VDD VDD _2057_ sky130_fd_sc_hd__o21ai_0
X_6067_ _0178_ _2057_ VSS VSS VDD VDD _2058_ sky130_fd_sc_hd__nand2b_1
X_6068_ _0177_ _2058_ VSS VSS VDD VDD _2059_ sky130_fd_sc_hd__xnor2_1
X_6069_ net719 net723 net728 net725 net658 net671 VSS VSS
+ VDD VDD _2060_ sky130_fd_sc_hd__mux4_2
X_6070_ cpuregs\[0\]\[17\] cpuregs\[1\]\[17\] cpuregs\[2\]\[17\]
+ cpuregs\[3\]\[17\] net774 net768 VSS VSS VDD VDD _2061_ sky130_fd_sc_hd__mux4_2
X_6071_ cpuregs\[4\]\[17\] cpuregs\[5\]\[17\] cpuregs\[6\]\[17\]
+ cpuregs\[7\]\[17\] net774 net768 VSS VSS VDD VDD _2062_ sky130_fd_sc_hd__mux4_2
Xplace777 net769 VSS VSS VDD VDD net768 sky130_fd_sc_hd__buf_12
Xplace772 _0045_ VSS VSS VDD VDD net763 sky130_fd_sc_hd__buf_4
X_6074_ cpuregs\[16\]\[17\] cpuregs\[17\]\[17\] cpuregs\[18\]\[17\]
+ cpuregs\[19\]\[17\] net773 net767 VSS VSS VDD VDD _2065_ sky130_fd_sc_hd__mux4_2
X_6075_ cpuregs\[20\]\[17\] cpuregs\[21\]\[17\] cpuregs\[22\]\[17\]
+ cpuregs\[23\]\[17\] net773 net767 VSS VSS VDD VDD _2066_ sky130_fd_sc_hd__mux4_2
X_6076_ _2061_ _2062_ _2065_ _2066_ net766 _0045_ VSS VSS
+ VDD VDD _2067_ sky130_fd_sc_hd__mux4_2
X_6077_ cpuregs\[8\]\[17\] cpuregs\[9\]\[17\] cpuregs\[10\]\[17\]
+ cpuregs\[11\]\[17\] net774 net767 VSS VSS VDD VDD _2068_ sky130_fd_sc_hd__mux4_2
X_6078_ cpuregs\[12\]\[17\] cpuregs\[13\]\[17\] cpuregs\[14\]\[17\]
+ cpuregs\[15\]\[17\] net773 net767 VSS VSS VDD VDD _2069_ sky130_fd_sc_hd__mux4_2
X_6079_ cpuregs\[24\]\[17\] cpuregs\[25\]\[17\] cpuregs\[26\]\[17\]
+ cpuregs\[27\]\[17\] net773 net767 VSS VSS VDD VDD _2070_ sky130_fd_sc_hd__mux4_2
X_6080_ cpuregs\[28\]\[17\] cpuregs\[29\]\[17\] cpuregs\[30\]\[17\]
+ cpuregs\[31\]\[17\] net773 net767 VSS VSS VDD VDD _2071_ sky130_fd_sc_hd__mux4_2
X_6081_ _2068_ _2069_ _2070_ _2071_ net766 _0045_ VSS VSS
+ VDD VDD _2072_ sky130_fd_sc_hd__mux4_2
X_6082_ _2067_ _2072_ net764 VSS VSS VDD VDD _2073_ sky130_fd_sc_hd__mux2i_1
X_6083_ reg_pc\[17\] net688 VSS VSS VDD VDD _2074_ sky130_fd_sc_hd__nand2_1
X_6084_ _1687_ _2073_ _2074_ VSS VSS VDD VDD _2075_ sky130_fd_sc_hd__o21ai_0
X_6085_ net746 _2060_ _2075_ _1728_ VSS VSS VDD VDD _2076_
+ sky130_fd_sc_hd__a22oi_1
X_6086_ net691 _2059_ _2076_ VSS VSS VDD VDD _4604_ sky130_fd_sc_hd__o21ai_0
X_6087_ _0179_ _1993_ VSS VSS VDD VDD _2077_ sky130_fd_sc_hd__xnor2_1
X_6088_ net720 net724 net729 net726 net658 net671 VSS VSS
+ VDD VDD _2078_ sky130_fd_sc_hd__mux4_2
X_6089_ cpuregs\[0\]\[16\] cpuregs\[1\]\[16\] cpuregs\[2\]\[16\]
+ cpuregs\[3\]\[16\] net773 net767 VSS VSS VDD VDD _2079_ sky130_fd_sc_hd__mux4_2
X_6090_ cpuregs\[4\]\[16\] cpuregs\[5\]\[16\] cpuregs\[6\]\[16\]
+ cpuregs\[7\]\[16\] net773 net767 VSS VSS VDD VDD _2080_ sky130_fd_sc_hd__mux4_2
X_6091_ cpuregs\[16\]\[16\] cpuregs\[17\]\[16\] cpuregs\[18\]\[16\]
+ cpuregs\[19\]\[16\] net773 net767 VSS VSS VDD VDD _2081_ sky130_fd_sc_hd__mux4_2
Xplace775 _0043_ VSS VSS VDD VDD net766 sky130_fd_sc_hd__buf_4
Xplace767 net760 VSS VSS VDD VDD net758 sky130_fd_sc_hd__buf_4
X_6094_ cpuregs\[20\]\[16\] cpuregs\[21\]\[16\] cpuregs\[22\]\[16\]
+ cpuregs\[23\]\[16\] net773 net767 VSS VSS VDD VDD _2084_ sky130_fd_sc_hd__mux4_2
X_6095_ _2079_ _2080_ _2081_ _2084_ net765 net763 VSS VSS
+ VDD VDD _2085_ sky130_fd_sc_hd__mux4_2
X_6096_ cpuregs\[8\]\[16\] cpuregs\[9\]\[16\] cpuregs\[10\]\[16\]
+ cpuregs\[11\]\[16\] net773 net767 VSS VSS VDD VDD _2086_ sky130_fd_sc_hd__mux4_2
X_6097_ cpuregs\[12\]\[16\] cpuregs\[13\]\[16\] cpuregs\[14\]\[16\]
+ cpuregs\[15\]\[16\] net773 net767 VSS VSS VDD VDD _2087_ sky130_fd_sc_hd__mux4_2
X_6098_ cpuregs\[24\]\[16\] cpuregs\[25\]\[16\] cpuregs\[26\]\[16\]
+ cpuregs\[27\]\[16\] net773 net767 VSS VSS VDD VDD _2088_ sky130_fd_sc_hd__mux4_2
X_6099_ cpuregs\[28\]\[16\] cpuregs\[29\]\[16\] cpuregs\[30\]\[16\]
+ cpuregs\[31\]\[16\] net773 net767 VSS VSS VDD VDD _2089_ sky130_fd_sc_hd__mux4_2
X_6100_ _2086_ _2087_ _2088_ _2089_ net765 net763 VSS VSS
+ VDD VDD _2090_ sky130_fd_sc_hd__mux4_2
X_6101_ _2085_ _2090_ net764 VSS VSS VDD VDD _2091_ sky130_fd_sc_hd__mux2i_1
X_6102_ reg_pc\[16\] net688 VSS VSS VDD VDD _2092_ sky130_fd_sc_hd__nand2_1
X_6103_ _1687_ _2091_ _2092_ VSS VSS VDD VDD _2093_ sky130_fd_sc_hd__o21ai_0
X_6104_ net746 _2078_ _2093_ _1728_ VSS VSS VDD VDD _2094_
+ sky130_fd_sc_hd__a22oi_1
X_6105_ net691 _2077_ _2094_ VSS VSS VDD VDD _4603_ sky130_fd_sc_hd__o21ai_0
X_6106_ _0183_ VSS VSS VDD VDD _2095_ sky130_fd_sc_hd__inv_1
X_6107_ _2095_ _2055_ VSS VSS VDD VDD _2096_ sky130_fd_sc_hd__nor2_1
X_6108_ _0181_ _0182_ _2096_ net690 VSS VSS VDD VDD _2097_
+ sky130_fd_sc_hd__o31ai_1
X_6109_ net722 net725 net730 net727 net658 net671 VSS VSS
+ VDD VDD _2098_ sky130_fd_sc_hd__mux4_2
X_6110_ cpuregs\[0\]\[15\] cpuregs\[1\]\[15\] cpuregs\[2\]\[15\]
+ cpuregs\[3\]\[15\] net774 net768 VSS VSS VDD VDD _2099_ sky130_fd_sc_hd__mux4_2
X_6111_ cpuregs\[4\]\[15\] cpuregs\[5\]\[15\] cpuregs\[6\]\[15\]
+ cpuregs\[7\]\[15\] net774 net768 VSS VSS VDD VDD _2100_ sky130_fd_sc_hd__mux4_2
X_6112_ cpuregs\[16\]\[15\] cpuregs\[17\]\[15\] cpuregs\[18\]\[15\]
+ cpuregs\[19\]\[15\] net773 net767 VSS VSS VDD VDD _2101_ sky130_fd_sc_hd__mux4_2
X_6113_ cpuregs\[20\]\[15\] cpuregs\[21\]\[15\] cpuregs\[22\]\[15\]
+ cpuregs\[23\]\[15\] net773 net767 VSS VSS VDD VDD _2102_ sky130_fd_sc_hd__mux4_2
X_6114_ _2099_ _2100_ _2101_ _2102_ net766 _0045_ VSS VSS
+ VDD VDD _2103_ sky130_fd_sc_hd__mux4_2
X_6115_ cpuregs\[8\]\[15\] cpuregs\[9\]\[15\] cpuregs\[10\]\[15\]
+ cpuregs\[11\]\[15\] net774 net768 VSS VSS VDD VDD _2104_ sky130_fd_sc_hd__mux4_2
X_6116_ cpuregs\[12\]\[15\] cpuregs\[13\]\[15\] cpuregs\[14\]\[15\]
+ cpuregs\[15\]\[15\] net774 net768 VSS VSS VDD VDD _2105_ sky130_fd_sc_hd__mux4_2
X_6117_ cpuregs\[24\]\[15\] cpuregs\[25\]\[15\] cpuregs\[26\]\[15\]
+ cpuregs\[27\]\[15\] net773 net767 VSS VSS VDD VDD _2106_ sky130_fd_sc_hd__mux4_2
X_6118_ cpuregs\[28\]\[15\] cpuregs\[29\]\[15\] cpuregs\[30\]\[15\]
+ cpuregs\[31\]\[15\] net773 net767 VSS VSS VDD VDD _2107_ sky130_fd_sc_hd__mux4_2
X_6119_ _2104_ _2105_ _2106_ _2107_ net766 _0045_ VSS VSS
+ VDD VDD _2108_ sky130_fd_sc_hd__mux4_2
X_6120_ _2103_ _2108_ net764 VSS VSS VDD VDD _2109_ sky130_fd_sc_hd__mux2i_1
X_6121_ reg_pc\[15\] net688 VSS VSS VDD VDD _2110_ sky130_fd_sc_hd__nand2_1
X_6122_ _1687_ _2109_ _2110_ VSS VSS VDD VDD _2111_ sky130_fd_sc_hd__o21ai_0
X_6123_ net746 _2098_ _2111_ _1728_ VSS VSS VDD VDD _2112_
+ sky130_fd_sc_hd__a22oi_1
X_6124_ _2056_ _2097_ _2112_ VSS VSS VDD VDD _4602_ sky130_fd_sc_hd__o21ai_0
X_6125_ _2095_ _1636_ VSS VSS VDD VDD _2113_ sky130_fd_sc_hd__xnor2_1
X_6126_ net731 VSS VSS VDD VDD _0283_ sky130_fd_sc_hd__inv_1
X_6127_ net728 VSS VSS VDD VDD _0317_ sky130_fd_sc_hd__inv_1
X_6128_ _0246_ _0313_ _0283_ _0317_ net658 net671 VSS VSS
+ VDD VDD _2114_ sky130_fd_sc_hd__mux4_2
X_6129_ cpuregs\[0\]\[14\] cpuregs\[1\]\[14\] cpuregs\[2\]\[14\]
+ cpuregs\[3\]\[14\] net773 net768 VSS VSS VDD VDD _2115_ sky130_fd_sc_hd__mux4_2
X_6130_ cpuregs\[4\]\[14\] cpuregs\[5\]\[14\] cpuregs\[6\]\[14\]
+ cpuregs\[7\]\[14\] net773 net768 VSS VSS VDD VDD _2116_ sky130_fd_sc_hd__mux4_2
X_6131_ cpuregs\[16\]\[14\] cpuregs\[17\]\[14\] cpuregs\[18\]\[14\]
+ cpuregs\[19\]\[14\] net770 net768 VSS VSS VDD VDD _2117_ sky130_fd_sc_hd__mux4_2
X_6132_ cpuregs\[20\]\[14\] cpuregs\[21\]\[14\] cpuregs\[22\]\[14\]
+ cpuregs\[23\]\[14\] net770 net768 VSS VSS VDD VDD _2118_ sky130_fd_sc_hd__mux4_2
X_6133_ _2115_ _2116_ _2117_ _2118_ net765 net763 VSS VSS
+ VDD VDD _2119_ sky130_fd_sc_hd__mux4_2
X_6134_ cpuregs\[8\]\[14\] cpuregs\[9\]\[14\] cpuregs\[10\]\[14\]
+ cpuregs\[11\]\[14\] net770 net768 VSS VSS VDD VDD _2120_ sky130_fd_sc_hd__mux4_2
Xplace764 net756 VSS VSS VDD VDD net755 sky130_fd_sc_hd__buf_4
Xplace762 net754 VSS VSS VDD VDD net753 sky130_fd_sc_hd__buf_4
X_6137_ cpuregs\[12\]\[14\] cpuregs\[13\]\[14\] cpuregs\[14\]\[14\]
+ cpuregs\[15\]\[14\] net770 net768 VSS VSS VDD VDD _2123_ sky130_fd_sc_hd__mux4_2
X_6138_ cpuregs\[24\]\[14\] cpuregs\[25\]\[14\] cpuregs\[26\]\[14\]
+ cpuregs\[27\]\[14\] net770 net768 VSS VSS VDD VDD _2124_ sky130_fd_sc_hd__mux4_2
X_6139_ cpuregs\[28\]\[14\] cpuregs\[29\]\[14\] cpuregs\[30\]\[14\]
+ cpuregs\[31\]\[14\] net770 net768 VSS VSS VDD VDD _2125_ sky130_fd_sc_hd__mux4_2
Xplace761 _0049_ VSS VSS VDD VDD net752 sky130_fd_sc_hd__buf_4
X_6141_ _2120_ _2123_ _2124_ _2125_ net765 net763 VSS VSS
+ VDD VDD _2127_ sky130_fd_sc_hd__mux4_2
X_6142_ _2119_ _2127_ net764 VSS VSS VDD VDD _2128_ sky130_fd_sc_hd__mux2i_1
X_6143_ reg_pc\[14\] net688 VSS VSS VDD VDD _2129_ sky130_fd_sc_hd__nand2_1
X_6144_ _1687_ _2128_ _2129_ VSS VSS VDD VDD _2130_ sky130_fd_sc_hd__o21ai_0
X_6145_ _1728_ _2130_ VSS VSS VDD VDD _2131_ sky130_fd_sc_hd__nand2_1
X_6146_ net691 _2113_ _2114_ net689 _2131_ VSS VSS VDD VDD
+ _4601_ sky130_fd_sc_hd__o221ai_1
X_6147_ _0185_ _2054_ VSS VSS VDD VDD _2132_ sky130_fd_sc_hd__xnor2_1
X_6148_ _0346_ _0210_ _0250_ _0411_ net671 net657 VSS VSS
+ VDD VDD _2133_ sky130_fd_sc_hd__mux4_2
X_6149_ cpuregs\[0\]\[13\] cpuregs\[1\]\[13\] cpuregs\[2\]\[13\]
+ cpuregs\[3\]\[13\] net770 net769 VSS VSS VDD VDD _2134_ sky130_fd_sc_hd__mux4_2
X_6150_ cpuregs\[4\]\[13\] cpuregs\[5\]\[13\] cpuregs\[6\]\[13\]
+ cpuregs\[7\]\[13\] net770 net769 VSS VSS VDD VDD _2135_ sky130_fd_sc_hd__mux4_2
X_6151_ cpuregs\[16\]\[13\] cpuregs\[17\]\[13\] cpuregs\[18\]\[13\]
+ cpuregs\[19\]\[13\] net770 net769 VSS VSS VDD VDD _2136_ sky130_fd_sc_hd__mux4_2
X_6152_ cpuregs\[20\]\[13\] cpuregs\[21\]\[13\] cpuregs\[22\]\[13\]
+ cpuregs\[23\]\[13\] net770 net769 VSS VSS VDD VDD _2137_ sky130_fd_sc_hd__mux4_2
X_6153_ _2134_ _2135_ _2136_ _2137_ net765 net763 VSS VSS
+ VDD VDD _2138_ sky130_fd_sc_hd__mux4_2
X_6154_ cpuregs\[8\]\[13\] cpuregs\[9\]\[13\] cpuregs\[10\]\[13\]
+ cpuregs\[11\]\[13\] net770 net769 VSS VSS VDD VDD _2139_ sky130_fd_sc_hd__mux4_2
X_6155_ cpuregs\[12\]\[13\] cpuregs\[13\]\[13\] cpuregs\[14\]\[13\]
+ cpuregs\[15\]\[13\] net770 net769 VSS VSS VDD VDD _2140_ sky130_fd_sc_hd__mux4_2
X_6156_ cpuregs\[24\]\[13\] cpuregs\[25\]\[13\] cpuregs\[26\]\[13\]
+ cpuregs\[27\]\[13\] net770 net769 VSS VSS VDD VDD _2141_ sky130_fd_sc_hd__mux4_2
X_6157_ cpuregs\[28\]\[13\] cpuregs\[29\]\[13\] cpuregs\[30\]\[13\]
+ cpuregs\[31\]\[13\] net770 net769 VSS VSS VDD VDD _2142_ sky130_fd_sc_hd__mux4_2
X_6158_ _2139_ _2140_ _2141_ _2142_ net765 net763 VSS VSS
+ VDD VDD _2143_ sky130_fd_sc_hd__mux4_2
X_6159_ _2138_ _2143_ net764 VSS VSS VDD VDD _2144_ sky130_fd_sc_hd__mux2i_1
X_6160_ reg_pc\[13\] net688 VSS VSS VDD VDD _2145_ sky130_fd_sc_hd__nand2_1
X_6161_ _1687_ _2144_ _2145_ VSS VSS VDD VDD _2146_ sky130_fd_sc_hd__o21ai_0
X_6162_ _1728_ _2146_ VSS VSS VDD VDD _2147_ sky130_fd_sc_hd__nand2_1
X_6163_ net691 _2132_ _2133_ net689 _2147_ VSS VSS VDD VDD
+ _4600_ sky130_fd_sc_hd__o221ai_1
X_6164_ _1627_ _1629_ VSS VSS VDD VDD _2148_ sky130_fd_sc_hd__nand2_1
X_6165_ _0240_ _2148_ _0239_ VSS VSS VDD VDD _2149_ sky130_fd_sc_hd__a21o_1
X_6166_ _0189_ _0238_ _2149_ _1630_ VSS VSS VDD VDD _2150_
+ sky130_fd_sc_hd__a31oi_1
X_6167_ _0187_ _2150_ VSS VSS VDD VDD _2151_ sky130_fd_sc_hd__xor2_1
X_6168_ cpuregs\[0\]\[12\] cpuregs\[1\]\[12\] cpuregs\[2\]\[12\]
+ cpuregs\[3\]\[12\] net770 _0042_ VSS VSS VDD VDD _2152_ sky130_fd_sc_hd__mux4_2
X_6169_ cpuregs\[4\]\[12\] cpuregs\[5\]\[12\] cpuregs\[6\]\[12\]
+ cpuregs\[7\]\[12\] net770 _0042_ VSS VSS VDD VDD _2153_ sky130_fd_sc_hd__mux4_2
X_6170_ cpuregs\[16\]\[12\] cpuregs\[17\]\[12\] cpuregs\[18\]\[12\]
+ cpuregs\[19\]\[12\] net770 net769 VSS VSS VDD VDD _2154_ sky130_fd_sc_hd__mux4_2
X_6171_ cpuregs\[20\]\[12\] cpuregs\[21\]\[12\] cpuregs\[22\]\[12\]
+ cpuregs\[23\]\[12\] net770 _0042_ VSS VSS VDD VDD _2155_ sky130_fd_sc_hd__mux4_2
X_6172_ _2152_ _2153_ _2154_ _2155_ _0043_ _0045_ VSS VSS
+ VDD VDD _2156_ sky130_fd_sc_hd__mux4_2
X_6173_ cpuregs\[8\]\[12\] cpuregs\[9\]\[12\] cpuregs\[10\]\[12\]
+ cpuregs\[11\]\[12\] net770 _0042_ VSS VSS VDD VDD _2157_ sky130_fd_sc_hd__mux4_2
X_6174_ cpuregs\[12\]\[12\] cpuregs\[13\]\[12\] cpuregs\[14\]\[12\]
+ cpuregs\[15\]\[12\] net770 _0042_ VSS VSS VDD VDD _2158_ sky130_fd_sc_hd__mux4_2
X_6175_ cpuregs\[24\]\[12\] cpuregs\[25\]\[12\] cpuregs\[26\]\[12\]
+ cpuregs\[27\]\[12\] net770 net769 VSS VSS VDD VDD _2159_ sky130_fd_sc_hd__mux4_2
X_6176_ cpuregs\[28\]\[12\] cpuregs\[29\]\[12\] cpuregs\[30\]\[12\]
+ cpuregs\[31\]\[12\] net770 net769 VSS VSS VDD VDD _2160_ sky130_fd_sc_hd__mux4_2
X_6177_ _2157_ _2158_ _2159_ _2160_ _0043_ _0045_ VSS VSS
+ VDD VDD _2161_ sky130_fd_sc_hd__mux4_2
X_6178_ _2156_ _2161_ _0044_ VSS VSS VDD VDD _2162_ sky130_fd_sc_hd__mux2i_1
X_6179_ _1687_ _2162_ VSS VSS VDD VDD _2163_ sky130_fd_sc_hd__nor2_1
X_6180_ reg_pc\[12\] net688 _2163_ VSS VSS VDD VDD _2164_
+ sky130_fd_sc_hd__a21oi_1
Xplace758 cpu_state\[2\] VSS VSS VDD VDD net749 sky130_fd_sc_hd__buf_4
X_6182_ net725 net728 net703 net730 net658 net671 VSS VSS
+ VDD VDD _2166_ sky130_fd_sc_hd__mux4_2
X_6183_ net746 _2166_ VSS VSS VDD VDD _2167_ sky130_fd_sc_hd__nand2_1
X_6184_ net691 _2151_ _2164_ _2036_ _2167_ VSS VSS VDD VDD
+ _4599_ sky130_fd_sc_hd__o221ai_1
X_6185_ _1768_ _1776_ VSS VSS VDD VDD _2168_ sky130_fd_sc_hd__nand2_1
X_6186_ _0189_ _2168_ VSS VSS VDD VDD _2169_ sky130_fd_sc_hd__xnor2_1
X_6187_ net729 net726 net731 net704 net657 net671 VSS VSS
+ VDD VDD _2170_ sky130_fd_sc_hd__mux4_2
X_6188_ cpuregs\[0\]\[11\] cpuregs\[1\]\[11\] cpuregs\[2\]\[11\]
+ cpuregs\[3\]\[11\] net770 net768 VSS VSS VDD VDD _2171_ sky130_fd_sc_hd__mux4_2
X_6189_ cpuregs\[4\]\[11\] cpuregs\[5\]\[11\] cpuregs\[6\]\[11\]
+ cpuregs\[7\]\[11\] net770 net768 VSS VSS VDD VDD _2172_ sky130_fd_sc_hd__mux4_2
X_6190_ cpuregs\[16\]\[11\] cpuregs\[17\]\[11\] cpuregs\[18\]\[11\]
+ cpuregs\[19\]\[11\] net770 net768 VSS VSS VDD VDD _2173_ sky130_fd_sc_hd__mux4_2
X_6191_ cpuregs\[20\]\[11\] cpuregs\[21\]\[11\] cpuregs\[22\]\[11\]
+ cpuregs\[23\]\[11\] net770 net768 VSS VSS VDD VDD _2174_ sky130_fd_sc_hd__mux4_2
X_6192_ _2171_ _2172_ _2173_ _2174_ net765 net763 VSS VSS
+ VDD VDD _2175_ sky130_fd_sc_hd__mux4_2
X_6193_ cpuregs\[8\]\[11\] cpuregs\[9\]\[11\] cpuregs\[10\]\[11\]
+ cpuregs\[11\]\[11\] net770 net768 VSS VSS VDD VDD _2176_ sky130_fd_sc_hd__mux4_2
X_6194_ cpuregs\[12\]\[11\] cpuregs\[13\]\[11\] cpuregs\[14\]\[11\]
+ cpuregs\[15\]\[11\] net770 net769 VSS VSS VDD VDD _2177_ sky130_fd_sc_hd__mux4_2
X_6195_ cpuregs\[24\]\[11\] cpuregs\[25\]\[11\] cpuregs\[26\]\[11\]
+ cpuregs\[27\]\[11\] net770 net769 VSS VSS VDD VDD _2178_ sky130_fd_sc_hd__mux4_2
X_6196_ cpuregs\[28\]\[11\] cpuregs\[29\]\[11\] cpuregs\[30\]\[11\]
+ cpuregs\[31\]\[11\] net770 net769 VSS VSS VDD VDD _2179_ sky130_fd_sc_hd__mux4_2
X_6197_ _2176_ _2177_ _2178_ _2179_ net765 net763 VSS VSS
+ VDD VDD _2180_ sky130_fd_sc_hd__mux4_2
X_6198_ _2175_ _2180_ net764 VSS VSS VDD VDD _2181_ sky130_fd_sc_hd__mux2i_1
X_6199_ reg_pc\[11\] net688 VSS VSS VDD VDD _2182_ sky130_fd_sc_hd__nand2_1
X_6200_ _1687_ _2181_ _2182_ VSS VSS VDD VDD _2183_ sky130_fd_sc_hd__o21ai_0
X_6201_ net746 _2170_ _2183_ _1728_ VSS VSS VDD VDD _2184_
+ sky130_fd_sc_hd__a22oi_1
X_6202_ net691 _2169_ _2184_ VSS VSS VDD VDD _4598_ sky130_fd_sc_hd__o21ai_0
X_6203_ _0238_ _2149_ VSS VSS VDD VDD _2185_ sky130_fd_sc_hd__xnor2_1
X_6204_ net705 VSS VSS VDD VDD _0375_ sky130_fd_sc_hd__inv_1
X_6205_ _0346_ _0321_ _0375_ _0411_ net658 net671 VSS VSS
+ VDD VDD _2186_ sky130_fd_sc_hd__mux4_2
X_6206_ cpuregs\[0\]\[10\] cpuregs\[1\]\[10\] cpuregs\[2\]\[10\]
+ cpuregs\[3\]\[10\] net771 net769 VSS VSS VDD VDD _2187_ sky130_fd_sc_hd__mux4_2
X_6207_ cpuregs\[4\]\[10\] cpuregs\[5\]\[10\] cpuregs\[6\]\[10\]
+ cpuregs\[7\]\[10\] net771 net769 VSS VSS VDD VDD _2188_ sky130_fd_sc_hd__mux4_2
X_6208_ cpuregs\[16\]\[10\] cpuregs\[17\]\[10\] cpuregs\[18\]\[10\]
+ cpuregs\[19\]\[10\] net771 net769 VSS VSS VDD VDD _2189_ sky130_fd_sc_hd__mux4_2
X_6209_ cpuregs\[20\]\[10\] cpuregs\[21\]\[10\] cpuregs\[22\]\[10\]
+ cpuregs\[23\]\[10\] net770 net769 VSS VSS VDD VDD _2190_ sky130_fd_sc_hd__mux4_2
X_6210_ _2187_ _2188_ _2189_ _2190_ net766 net763 VSS VSS
+ VDD VDD _2191_ sky130_fd_sc_hd__mux4_2
X_6211_ cpuregs\[8\]\[10\] cpuregs\[9\]\[10\] cpuregs\[10\]\[10\]
+ cpuregs\[11\]\[10\] net771 net769 VSS VSS VDD VDD _2192_ sky130_fd_sc_hd__mux4_2
X_6212_ cpuregs\[12\]\[10\] cpuregs\[13\]\[10\] cpuregs\[14\]\[10\]
+ cpuregs\[15\]\[10\] net771 net769 VSS VSS VDD VDD _2193_ sky130_fd_sc_hd__mux4_2
X_6213_ cpuregs\[24\]\[10\] cpuregs\[25\]\[10\] cpuregs\[26\]\[10\]
+ cpuregs\[27\]\[10\] net770 net769 VSS VSS VDD VDD _2194_ sky130_fd_sc_hd__mux4_2
X_6214_ cpuregs\[28\]\[10\] cpuregs\[29\]\[10\] cpuregs\[30\]\[10\]
+ cpuregs\[31\]\[10\] net770 net769 VSS VSS VDD VDD _2195_ sky130_fd_sc_hd__mux4_2
X_6215_ _2192_ _2193_ _2194_ _2195_ net766 net763 VSS VSS
+ VDD VDD _2196_ sky130_fd_sc_hd__mux4_2
X_6216_ _2191_ _2196_ net764 VSS VSS VDD VDD _2197_ sky130_fd_sc_hd__mux2i_1
X_6217_ reg_pc\[10\] net688 VSS VSS VDD VDD _2198_ sky130_fd_sc_hd__nand2_1
X_6218_ _1687_ _2197_ _2198_ VSS VSS VDD VDD _2199_ sky130_fd_sc_hd__o21ai_0
X_6219_ _1728_ _2199_ VSS VSS VDD VDD _2200_ sky130_fd_sc_hd__nand2_1
X_6220_ net691 _2185_ _2186_ net689 _2200_ VSS VSS VDD VDD
+ _4597_ sky130_fd_sc_hd__o221ai_1
X_6221_ cpuregs\[0\]\[9\] cpuregs\[1\]\[9\] cpuregs\[2\]\[9\]
+ cpuregs\[3\]\[9\] net770 net769 VSS VSS VDD VDD _2201_ sky130_fd_sc_hd__mux4_2
X_6222_ cpuregs\[4\]\[9\] cpuregs\[5\]\[9\] cpuregs\[6\]\[9\]
+ cpuregs\[7\]\[9\] net770 net769 VSS VSS VDD VDD _2202_ sky130_fd_sc_hd__mux4_2
X_6223_ cpuregs\[16\]\[9\] cpuregs\[17\]\[9\] cpuregs\[18\]\[9\]
+ cpuregs\[19\]\[9\] net770 net769 VSS VSS VDD VDD _2203_ sky130_fd_sc_hd__mux4_2
X_6224_ cpuregs\[20\]\[9\] cpuregs\[21\]\[9\] cpuregs\[22\]\[9\]
+ cpuregs\[23\]\[9\] net770 net769 VSS VSS VDD VDD _2204_ sky130_fd_sc_hd__mux4_2
X_6225_ _2201_ _2202_ _2203_ _2204_ net765 net763 VSS VSS
+ VDD VDD _2205_ sky130_fd_sc_hd__mux4_2
X_6226_ cpuregs\[8\]\[9\] cpuregs\[9\]\[9\] cpuregs\[10\]\[9\]
+ cpuregs\[11\]\[9\] net770 net769 VSS VSS VDD VDD _2206_ sky130_fd_sc_hd__mux4_2
X_6227_ cpuregs\[12\]\[9\] cpuregs\[13\]\[9\] cpuregs\[14\]\[9\]
+ cpuregs\[15\]\[9\] net770 net769 VSS VSS VDD VDD _2207_ sky130_fd_sc_hd__mux4_2
X_6228_ cpuregs\[24\]\[9\] cpuregs\[25\]\[9\] cpuregs\[26\]\[9\]
+ cpuregs\[27\]\[9\] net770 net769 VSS VSS VDD VDD _2208_ sky130_fd_sc_hd__mux4_2
X_6229_ cpuregs\[28\]\[9\] cpuregs\[29\]\[9\] cpuregs\[30\]\[9\]
+ cpuregs\[31\]\[9\] net770 net769 VSS VSS VDD VDD _2209_ sky130_fd_sc_hd__mux4_2
X_6230_ _2206_ _2207_ _2208_ _2209_ net765 net763 VSS VSS
+ VDD VDD _2210_ sky130_fd_sc_hd__mux4_2
X_6231_ _2205_ _2210_ net764 VSS VSS VDD VDD _2211_ sky130_fd_sc_hd__mux2i_1
X_6232_ _1687_ _2211_ VSS VSS VDD VDD _2212_ sky130_fd_sc_hd__nor2_1
X_6233_ reg_pc\[9\] net688 _2212_ VSS VSS VDD VDD _2213_ sky130_fd_sc_hd__a21oi_1
X_6234_ _1762_ _1763_ VSS VSS VDD VDD _2214_ sky130_fd_sc_hd__nor2_1
X_6235_ _0224_ _2214_ _0223_ VSS VSS VDD VDD _2215_ sky130_fd_sc_hd__o21a_1
X_6236_ _0222_ _2215_ _0244_ VSS VSS VDD VDD _2216_ sky130_fd_sc_hd__o21ai_0
X_6237_ _0220_ _1772_ VSS VSS VDD VDD _2217_ sky130_fd_sc_hd__nor2_1
X_6238_ _1624_ _2216_ _2217_ VSS VSS VDD VDD _2218_ sky130_fd_sc_hd__o21ai_0
X_6239_ _0240_ _2218_ VSS VSS VDD VDD _2219_ sky130_fd_sc_hd__xor2_1
X_6240_ net728 net731 net706 net703 net658 net671 VSS VSS
+ VDD VDD _2220_ sky130_fd_sc_hd__mux4_2
X_6241_ net690 _2219_ _2220_ net746 VSS VSS VDD VDD _2221_
+ sky130_fd_sc_hd__a22oi_1
X_6242_ _2036_ _2213_ _2221_ VSS VSS VDD VDD _4627_ sky130_fd_sc_hd__o21ai_0
X_6243_ _0242_ VSS VSS VDD VDD _2222_ sky130_fd_sc_hd__inv_1
X_6244_ _0222_ _1623_ _0244_ VSS VSS VDD VDD _2223_ sky130_fd_sc_hd__o21a_1
X_6245_ _0243_ _2223_ VSS VSS VDD VDD _2224_ sky130_fd_sc_hd__nor2_1
X_6246_ _2222_ _2224_ _0241_ VSS VSS VDD VDD _2225_ sky130_fd_sc_hd__o21bai_1
X_6247_ _0191_ _2225_ _0190_ VSS VSS VDD VDD _2226_ sky130_fd_sc_hd__a21oi_1
X_6248_ _0221_ _2226_ VSS VSS VDD VDD _2227_ sky130_fd_sc_hd__xor2_1
X_6249_ net729 net702 net707 net704 net658 net671 VSS VSS
+ VDD VDD _2228_ sky130_fd_sc_hd__mux4_2
X_6250_ cpuregs\[0\]\[8\] cpuregs\[1\]\[8\] cpuregs\[2\]\[8\]
+ cpuregs\[3\]\[8\] net771 net768 VSS VSS VDD VDD _2229_ sky130_fd_sc_hd__mux4_2
X_6251_ cpuregs\[4\]\[8\] cpuregs\[5\]\[8\] cpuregs\[6\]\[8\]
+ cpuregs\[7\]\[8\] net771 net768 VSS VSS VDD VDD _2230_ sky130_fd_sc_hd__mux4_2
X_6252_ cpuregs\[16\]\[8\] cpuregs\[17\]\[8\] cpuregs\[18\]\[8\]
+ cpuregs\[19\]\[8\] net771 net768 VSS VSS VDD VDD _2231_ sky130_fd_sc_hd__mux4_2
X_6253_ cpuregs\[20\]\[8\] cpuregs\[21\]\[8\] cpuregs\[22\]\[8\]
+ cpuregs\[23\]\[8\] net771 net768 VSS VSS VDD VDD _2232_ sky130_fd_sc_hd__mux4_2
X_6254_ _2229_ _2230_ _2231_ _2232_ net765 net763 VSS VSS
+ VDD VDD _2233_ sky130_fd_sc_hd__mux4_2
X_6255_ cpuregs\[8\]\[8\] cpuregs\[9\]\[8\] cpuregs\[10\]\[8\]
+ cpuregs\[11\]\[8\] net771 net768 VSS VSS VDD VDD _2234_ sky130_fd_sc_hd__mux4_2
X_6256_ cpuregs\[12\]\[8\] cpuregs\[13\]\[8\] cpuregs\[14\]\[8\]
+ cpuregs\[15\]\[8\] net771 net768 VSS VSS VDD VDD _2235_ sky130_fd_sc_hd__mux4_2
X_6257_ cpuregs\[24\]\[8\] cpuregs\[25\]\[8\] cpuregs\[26\]\[8\]
+ cpuregs\[27\]\[8\] net770 net768 VSS VSS VDD VDD _2236_ sky130_fd_sc_hd__mux4_2
X_6258_ cpuregs\[28\]\[8\] cpuregs\[29\]\[8\] cpuregs\[30\]\[8\]
+ cpuregs\[31\]\[8\] net770 net768 VSS VSS VDD VDD _2237_ sky130_fd_sc_hd__mux4_2
X_6259_ _2234_ _2235_ _2236_ _2237_ net765 net763 VSS VSS
+ VDD VDD _2238_ sky130_fd_sc_hd__mux4_2
X_6260_ _2233_ _2238_ net764 VSS VSS VDD VDD _2239_ sky130_fd_sc_hd__mux2i_1
X_6261_ reg_pc\[8\] net688 VSS VSS VDD VDD _2240_ sky130_fd_sc_hd__nand2_1
X_6262_ _1687_ _2239_ _2240_ VSS VSS VDD VDD _2241_ sky130_fd_sc_hd__o21ai_0
X_6263_ net746 _2228_ _2241_ _1728_ VSS VSS VDD VDD _2242_
+ sky130_fd_sc_hd__a22oi_1
X_6264_ net691 _2227_ _2242_ VSS VSS VDD VDD _4626_ sky130_fd_sc_hd__o21ai_0
X_6265_ _0243_ _2216_ VSS VSS VDD VDD _2243_ sky130_fd_sc_hd__nand2b_1
X_6266_ _0242_ _2243_ _0241_ VSS VSS VDD VDD _2244_ sky130_fd_sc_hd__a21oi_1
X_6267_ _0191_ _2244_ VSS VSS VDD VDD _2245_ sky130_fd_sc_hd__xor2_1
X_6268_ net703 net730 net705 net708 net657 net671 VSS VSS
+ VDD VDD _2246_ sky130_fd_sc_hd__mux4_2
X_6269_ cpuregs\[0\]\[7\] cpuregs\[1\]\[7\] cpuregs\[2\]\[7\]
+ cpuregs\[3\]\[7\] net770 net768 VSS VSS VDD VDD _2247_ sky130_fd_sc_hd__mux4_2
X_6270_ cpuregs\[4\]\[7\] cpuregs\[5\]\[7\] cpuregs\[6\]\[7\]
+ cpuregs\[7\]\[7\] net770 net768 VSS VSS VDD VDD _2248_ sky130_fd_sc_hd__mux4_2
X_6271_ cpuregs\[16\]\[7\] cpuregs\[17\]\[7\] cpuregs\[18\]\[7\]
+ cpuregs\[19\]\[7\] net770 net768 VSS VSS VDD VDD _2249_ sky130_fd_sc_hd__mux4_2
X_6272_ cpuregs\[20\]\[7\] cpuregs\[21\]\[7\] cpuregs\[22\]\[7\]
+ cpuregs\[23\]\[7\] net770 net768 VSS VSS VDD VDD _2250_ sky130_fd_sc_hd__mux4_2
X_6273_ _2247_ _2248_ _2249_ _2250_ net765 net763 VSS VSS
+ VDD VDD _2251_ sky130_fd_sc_hd__mux4_2
X_6274_ cpuregs\[8\]\[7\] cpuregs\[9\]\[7\] cpuregs\[10\]\[7\]
+ cpuregs\[11\]\[7\] net770 net768 VSS VSS VDD VDD _2252_ sky130_fd_sc_hd__mux4_2
X_6275_ cpuregs\[12\]\[7\] cpuregs\[13\]\[7\] cpuregs\[14\]\[7\]
+ cpuregs\[15\]\[7\] net770 net768 VSS VSS VDD VDD _2253_ sky130_fd_sc_hd__mux4_2
X_6276_ cpuregs\[24\]\[7\] cpuregs\[25\]\[7\] cpuregs\[26\]\[7\]
+ cpuregs\[27\]\[7\] net770 net768 VSS VSS VDD VDD _2254_ sky130_fd_sc_hd__mux4_2
X_6277_ cpuregs\[28\]\[7\] cpuregs\[29\]\[7\] cpuregs\[30\]\[7\]
+ cpuregs\[31\]\[7\] net770 net768 VSS VSS VDD VDD _2255_ sky130_fd_sc_hd__mux4_2
X_6278_ _2252_ _2253_ _2254_ _2255_ net765 net763 VSS VSS
+ VDD VDD _2256_ sky130_fd_sc_hd__mux4_2
X_6279_ _2251_ _2256_ net764 VSS VSS VDD VDD _2257_ sky130_fd_sc_hd__mux2i_1
X_6280_ reg_pc\[7\] net688 VSS VSS VDD VDD _2258_ sky130_fd_sc_hd__nand2_1
X_6281_ _1687_ net670 _2258_ VSS VSS VDD VDD _2259_ sky130_fd_sc_hd__o21ai_0
X_6282_ net746 _2246_ _2259_ _1728_ VSS VSS VDD VDD _2260_
+ sky130_fd_sc_hd__a22oi_1
X_6283_ net691 _2245_ _2260_ VSS VSS VDD VDD _4625_ sky130_fd_sc_hd__o21ai_0
X_6284_ net706 VSS VSS VDD VDD _0329_ sky130_fd_sc_hd__inv_1
X_6285_ net711 VSS VSS VDD VDD _0333_ sky130_fd_sc_hd__inv_1
X_6286_ _0452_ _0283_ _0329_ _0333_ net657 net671 VSS VSS
+ VDD VDD _2261_ sky130_fd_sc_hd__mux4_2
X_6287_ _2222_ _2224_ VSS VSS VDD VDD _2262_ sky130_fd_sc_hd__xnor2_1
X_6288_ cpuregs\[0\]\[6\] cpuregs\[1\]\[6\] cpuregs\[2\]\[6\]
+ cpuregs\[3\]\[6\] net770 net768 VSS VSS VDD VDD _2263_ sky130_fd_sc_hd__mux4_2
X_6289_ cpuregs\[4\]\[6\] cpuregs\[5\]\[6\] cpuregs\[6\]\[6\]
+ cpuregs\[7\]\[6\] net773 net768 VSS VSS VDD VDD _2264_ sky130_fd_sc_hd__mux4_2
X_6290_ cpuregs\[16\]\[6\] cpuregs\[17\]\[6\] cpuregs\[18\]\[6\]
+ cpuregs\[19\]\[6\] net770 net768 VSS VSS VDD VDD _2265_ sky130_fd_sc_hd__mux4_2
X_6291_ cpuregs\[20\]\[6\] cpuregs\[21\]\[6\] cpuregs\[22\]\[6\]
+ cpuregs\[23\]\[6\] net770 net768 VSS VSS VDD VDD _2266_ sky130_fd_sc_hd__mux4_2
X_6292_ _2263_ _2264_ _2265_ _2266_ net765 net763 VSS VSS
+ VDD VDD _2267_ sky130_fd_sc_hd__mux4_2
X_6293_ cpuregs\[8\]\[6\] cpuregs\[9\]\[6\] cpuregs\[10\]\[6\]
+ cpuregs\[11\]\[6\] net770 net768 VSS VSS VDD VDD _2268_ sky130_fd_sc_hd__mux4_2
X_6294_ cpuregs\[12\]\[6\] cpuregs\[13\]\[6\] cpuregs\[14\]\[6\]
+ cpuregs\[15\]\[6\] net770 net768 VSS VSS VDD VDD _2269_ sky130_fd_sc_hd__mux4_2
X_6295_ cpuregs\[24\]\[6\] cpuregs\[25\]\[6\] cpuregs\[26\]\[6\]
+ cpuregs\[27\]\[6\] net770 net768 VSS VSS VDD VDD _2270_ sky130_fd_sc_hd__mux4_2
X_6296_ cpuregs\[28\]\[6\] cpuregs\[29\]\[6\] cpuregs\[30\]\[6\]
+ cpuregs\[31\]\[6\] net770 net768 VSS VSS VDD VDD _2271_ sky130_fd_sc_hd__mux4_2
X_6297_ _2268_ _2269_ _2270_ _2271_ net765 net763 VSS VSS
+ VDD VDD _2272_ sky130_fd_sc_hd__mux4_2
X_6298_ _2267_ _2272_ net764 VSS VSS VDD VDD _2273_ sky130_fd_sc_hd__mux2i_1
X_6299_ reg_pc\[6\] net688 VSS VSS VDD VDD _2274_ sky130_fd_sc_hd__nand2_1
X_6300_ _1687_ net669 _2274_ VSS VSS VDD VDD _2275_ sky130_fd_sc_hd__o21ai_0
X_6301_ _1728_ _2275_ VSS VSS VDD VDD _2276_ sky130_fd_sc_hd__nand2_1
X_6302_ net689 _2261_ _2262_ net691 _2276_ VSS VSS VDD VDD
+ _4624_ sky130_fd_sc_hd__o221ai_1
X_6303_ _0244_ _0222_ VSS VSS VDD VDD _2277_ sky130_fd_sc_hd__or2_2
X_6304_ _2215_ _2277_ _2216_ VSS VSS VDD VDD _2278_ sky130_fd_sc_hd__o21ai_0
X_6305_ cpuregs\[0\]\[5\] cpuregs\[1\]\[5\] cpuregs\[2\]\[5\]
+ cpuregs\[3\]\[5\] net770 net768 VSS VSS VDD VDD _2279_ sky130_fd_sc_hd__mux4_2
X_6306_ cpuregs\[4\]\[5\] cpuregs\[5\]\[5\] cpuregs\[6\]\[5\]
+ cpuregs\[7\]\[5\] net770 net768 VSS VSS VDD VDD _2280_ sky130_fd_sc_hd__mux4_2
X_6307_ cpuregs\[16\]\[5\] cpuregs\[17\]\[5\] cpuregs\[18\]\[5\]
+ cpuregs\[19\]\[5\] net770 net768 VSS VSS VDD VDD _2281_ sky130_fd_sc_hd__mux4_2
X_6308_ cpuregs\[20\]\[5\] cpuregs\[21\]\[5\] cpuregs\[22\]\[5\]
+ cpuregs\[23\]\[5\] net770 net768 VSS VSS VDD VDD _2282_ sky130_fd_sc_hd__mux4_2
X_6309_ _2279_ _2280_ _2281_ _2282_ net765 net763 VSS VSS
+ VDD VDD _2283_ sky130_fd_sc_hd__mux4_2
X_6310_ cpuregs\[8\]\[5\] cpuregs\[9\]\[5\] cpuregs\[10\]\[5\]
+ cpuregs\[11\]\[5\] net770 net768 VSS VSS VDD VDD _2284_ sky130_fd_sc_hd__mux4_2
X_6311_ cpuregs\[12\]\[5\] cpuregs\[13\]\[5\] cpuregs\[14\]\[5\]
+ cpuregs\[15\]\[5\] net770 net768 VSS VSS VDD VDD _2285_ sky130_fd_sc_hd__mux4_2
X_6312_ cpuregs\[24\]\[5\] cpuregs\[25\]\[5\] cpuregs\[26\]\[5\]
+ cpuregs\[27\]\[5\] net770 net768 VSS VSS VDD VDD _2286_ sky130_fd_sc_hd__mux4_2
X_6313_ cpuregs\[28\]\[5\] cpuregs\[29\]\[5\] cpuregs\[30\]\[5\]
+ cpuregs\[31\]\[5\] net770 net768 VSS VSS VDD VDD _2287_ sky130_fd_sc_hd__mux4_2
X_6314_ _2284_ _2285_ _2286_ _2287_ net765 net763 VSS VSS
+ VDD VDD _2288_ sky130_fd_sc_hd__mux4_2
X_6315_ _2283_ _2288_ net764 VSS VSS VDD VDD _2289_ sky130_fd_sc_hd__mux2i_1
X_6316_ reg_pc\[5\] net688 VSS VSS VDD VDD _2290_ sky130_fd_sc_hd__nand2_1
X_6317_ _1687_ _2289_ _2290_ VSS VSS VDD VDD _2291_ sky130_fd_sc_hd__o21ai_0
X_6318_ net702 net721 net705 net707 net671 net658 VSS VSS
+ VDD VDD _2292_ sky130_fd_sc_hd__mux4_2
X_6319_ _1728_ _2291_ _2292_ net746 VSS VSS VDD VDD _2293_
+ sky130_fd_sc_hd__a22oi_1
X_6320_ net691 _2278_ _2293_ VSS VSS VDD VDD _4623_ sky130_fd_sc_hd__o21ai_0
X_6321_ _0227_ _0064_ _0226_ VSS VSS VDD VDD _2294_ sky130_fd_sc_hd__a21o_1
X_6322_ _0225_ _2294_ _0223_ _0224_ VSS VSS VDD VDD _2295_
+ sky130_fd_sc_hd__a211oi_1
X_6323_ cpuregs\[0\]\[4\] cpuregs\[1\]\[4\] cpuregs\[2\]\[4\]
+ cpuregs\[3\]\[4\] net771 _0042_ VSS VSS VDD VDD _2296_ sky130_fd_sc_hd__mux4_2
X_6324_ cpuregs\[4\]\[4\] cpuregs\[5\]\[4\] cpuregs\[6\]\[4\]
+ cpuregs\[7\]\[4\] net771 _0042_ VSS VSS VDD VDD _2297_ sky130_fd_sc_hd__mux4_2
X_6325_ cpuregs\[16\]\[4\] cpuregs\[17\]\[4\] cpuregs\[18\]\[4\]
+ cpuregs\[19\]\[4\] net771 _0042_ VSS VSS VDD VDD _2298_ sky130_fd_sc_hd__mux4_2
X_6326_ cpuregs\[20\]\[4\] cpuregs\[21\]\[4\] cpuregs\[22\]\[4\]
+ cpuregs\[23\]\[4\] net771 _0042_ VSS VSS VDD VDD _2299_ sky130_fd_sc_hd__mux4_2
X_6327_ _2296_ _2297_ _2298_ _2299_ _0043_ _0045_ VSS VSS
+ VDD VDD _2300_ sky130_fd_sc_hd__mux4_2
X_6328_ cpuregs\[8\]\[4\] cpuregs\[9\]\[4\] cpuregs\[10\]\[4\]
+ cpuregs\[11\]\[4\] net771 _0042_ VSS VSS VDD VDD _2301_ sky130_fd_sc_hd__mux4_2
X_6329_ cpuregs\[12\]\[4\] cpuregs\[13\]\[4\] cpuregs\[14\]\[4\]
+ cpuregs\[15\]\[4\] net771 _0042_ VSS VSS VDD VDD _2302_ sky130_fd_sc_hd__mux4_2
X_6330_ cpuregs\[24\]\[4\] cpuregs\[25\]\[4\] cpuregs\[26\]\[4\]
+ cpuregs\[27\]\[4\] net771 net769 VSS VSS VDD VDD _2303_ sky130_fd_sc_hd__mux4_2
X_6331_ cpuregs\[28\]\[4\] cpuregs\[29\]\[4\] cpuregs\[30\]\[4\]
+ cpuregs\[31\]\[4\] net771 net769 VSS VSS VDD VDD _2304_ sky130_fd_sc_hd__mux4_2
X_6332_ _2301_ _2302_ _2303_ _2304_ _0043_ _0045_ VSS VSS
+ VDD VDD _2305_ sky130_fd_sc_hd__mux4_2
X_6333_ _2300_ _2305_ _0044_ VSS VSS VDD VDD _2306_ sky130_fd_sc_hd__mux2i_1
X_6334_ reg_pc\[4\] net688 VSS VSS VDD VDD _2307_ sky130_fd_sc_hd__nand2_1
X_6335_ _1687_ _2306_ _2307_ VSS VSS VDD VDD _2308_ sky130_fd_sc_hd__o21ai_0
X_6336_ _1728_ _2308_ VSS VSS VDD VDD _2309_ sky130_fd_sc_hd__nand2_1
X_6337_ net703 net732 net706 net708 net671 net658 VSS VSS
+ VDD VDD _2310_ sky130_fd_sc_hd__mux4_2
X_6338_ net746 _2310_ VSS VSS VDD VDD _2311_ sky130_fd_sc_hd__nand2_1
X_6339_ net691 _1623_ _2295_ _2309_ _2311_ VSS VSS VDD VDD
+ _4622_ sky130_fd_sc_hd__o311ai_0
X_6340_ cpuregs\[0\]\[3\] cpuregs\[1\]\[3\] cpuregs\[2\]\[3\]
+ cpuregs\[3\]\[3\] net771 _0042_ VSS VSS VDD VDD _2312_ sky130_fd_sc_hd__mux4_2
X_6341_ cpuregs\[4\]\[3\] cpuregs\[5\]\[3\] cpuregs\[6\]\[3\]
+ cpuregs\[7\]\[3\] net771 _0042_ VSS VSS VDD VDD _2313_ sky130_fd_sc_hd__mux4_2
X_6342_ cpuregs\[16\]\[3\] cpuregs\[17\]\[3\] cpuregs\[18\]\[3\]
+ cpuregs\[19\]\[3\] net770 _0042_ VSS VSS VDD VDD _2314_ sky130_fd_sc_hd__mux4_2
X_6343_ cpuregs\[20\]\[3\] cpuregs\[21\]\[3\] cpuregs\[22\]\[3\]
+ cpuregs\[23\]\[3\] net770 _0042_ VSS VSS VDD VDD _2315_ sky130_fd_sc_hd__mux4_2
X_6344_ _2312_ _2313_ _2314_ _2315_ _0043_ _0045_ VSS VSS
+ VDD VDD _2316_ sky130_fd_sc_hd__mux4_2
X_6345_ cpuregs\[8\]\[3\] cpuregs\[9\]\[3\] cpuregs\[10\]\[3\]
+ cpuregs\[11\]\[3\] net771 _0042_ VSS VSS VDD VDD _2317_ sky130_fd_sc_hd__mux4_2
X_6346_ cpuregs\[12\]\[3\] cpuregs\[13\]\[3\] cpuregs\[14\]\[3\]
+ cpuregs\[15\]\[3\] net771 _0042_ VSS VSS VDD VDD _2318_ sky130_fd_sc_hd__mux4_2
X_6347_ cpuregs\[24\]\[3\] cpuregs\[25\]\[3\] cpuregs\[26\]\[3\]
+ cpuregs\[27\]\[3\] net770 net769 VSS VSS VDD VDD _2319_ sky130_fd_sc_hd__mux4_2
X_6348_ cpuregs\[28\]\[3\] cpuregs\[29\]\[3\] cpuregs\[30\]\[3\]
+ cpuregs\[31\]\[3\] net770 net769 VSS VSS VDD VDD _2320_ sky130_fd_sc_hd__mux4_2
X_6349_ _2317_ _2318_ _2319_ _2320_ _0043_ _0045_ VSS VSS
+ VDD VDD _2321_ sky130_fd_sc_hd__mux4_2
X_6350_ _2316_ _2321_ _0044_ VSS VSS VDD VDD _2322_ sky130_fd_sc_hd__mux2i_1
X_6351_ _1687_ _2322_ VSS VSS VDD VDD _2323_ sky130_fd_sc_hd__nor2_1
X_6352_ reg_pc\[3\] net688 _2323_ VSS VSS VDD VDD _2324_ sky130_fd_sc_hd__a21oi_1
X_6353_ net707 VSS VSS VDD VDD _0464_ sky130_fd_sc_hd__inv_1
X_6354_ _0464_ net657 VSS VSS VDD VDD _2325_ sky130_fd_sc_hd__nor2_1
X_6355_ net704 net657 _2325_ VSS VSS VDD VDD _2326_ sky130_fd_sc_hd__a21oi_1
X_6356_ net711 net671 net658 VSS VSS VDD VDD _2327_ sky130_fd_sc_hd__nand3_1
X_6357_ net671 _2326_ _2327_ VSS VSS VDD VDD _2328_ sky130_fd_sc_hd__o21ai_0
X_6358_ _0219_ _0063_ _0245_ VSS VSS VDD VDD _2329_ sky130_fd_sc_hd__a21o_1
X_6359_ _0227_ _2329_ _0226_ VSS VSS VDD VDD _2330_ sky130_fd_sc_hd__a21oi_1
X_6360_ _0225_ _2330_ VSS VSS VDD VDD _2331_ sky130_fd_sc_hd__xnor2_1
X_6361_ net746 _2328_ _2331_ net690 VSS VSS VDD VDD _2332_
+ sky130_fd_sc_hd__a22oi_1
X_6362_ _2036_ _2324_ _2332_ VSS VSS VDD VDD _4621_ sky130_fd_sc_hd__o21ai_0
X_6363_ cpuregs\[0\]\[2\] cpuregs\[1\]\[2\] cpuregs\[2\]\[2\]
+ cpuregs\[3\]\[2\] net770 _0042_ VSS VSS VDD VDD _2333_ sky130_fd_sc_hd__mux4_2
X_6364_ cpuregs\[4\]\[2\] cpuregs\[5\]\[2\] cpuregs\[6\]\[2\]
+ cpuregs\[7\]\[2\] net770 _0042_ VSS VSS VDD VDD _2334_ sky130_fd_sc_hd__mux4_2
X_6365_ cpuregs\[16\]\[2\] cpuregs\[17\]\[2\] cpuregs\[18\]\[2\]
+ cpuregs\[19\]\[2\] net770 _0042_ VSS VSS VDD VDD _2335_ sky130_fd_sc_hd__mux4_2
X_6366_ cpuregs\[20\]\[2\] cpuregs\[21\]\[2\] cpuregs\[22\]\[2\]
+ cpuregs\[23\]\[2\] net770 _0042_ VSS VSS VDD VDD _2336_ sky130_fd_sc_hd__mux4_2
X_6367_ _2333_ _2334_ _2335_ _2336_ _0043_ _0045_ VSS VSS
+ VDD VDD _2337_ sky130_fd_sc_hd__mux4_2
X_6368_ cpuregs\[8\]\[2\] cpuregs\[9\]\[2\] cpuregs\[10\]\[2\]
+ cpuregs\[11\]\[2\] net770 _0042_ VSS VSS VDD VDD _2338_ sky130_fd_sc_hd__mux4_2
X_6369_ cpuregs\[12\]\[2\] cpuregs\[13\]\[2\] cpuregs\[14\]\[2\]
+ cpuregs\[15\]\[2\] net770 _0042_ VSS VSS VDD VDD _2339_ sky130_fd_sc_hd__mux4_2
X_6370_ cpuregs\[24\]\[2\] cpuregs\[25\]\[2\] cpuregs\[26\]\[2\]
+ cpuregs\[27\]\[2\] net770 _0042_ VSS VSS VDD VDD _2340_ sky130_fd_sc_hd__mux4_2
X_6371_ cpuregs\[28\]\[2\] cpuregs\[29\]\[2\] cpuregs\[30\]\[2\]
+ cpuregs\[31\]\[2\] net770 _0042_ VSS VSS VDD VDD _2341_ sky130_fd_sc_hd__mux4_2
X_6372_ _2338_ _2339_ _2340_ _2341_ _0043_ _0045_ VSS VSS
+ VDD VDD _2342_ sky130_fd_sc_hd__mux4_2
X_6373_ _2337_ _2342_ _0044_ VSS VSS VDD VDD _2343_ sky130_fd_sc_hd__mux2i_1
X_6374_ _1687_ _2343_ VSS VSS VDD VDD _2344_ sky130_fd_sc_hd__nor2_1
X_6375_ reg_pc\[2\] net688 _2344_ VSS VSS VDD VDD _2345_ sky130_fd_sc_hd__a21oi_1
X_6376_ net708 VSS VSS VDD VDD _0470_ sky130_fd_sc_hd__inv_1
X_6377_ _0470_ net657 VSS VSS VDD VDD _2346_ sky130_fd_sc_hd__nor2_1
X_6378_ net705 net657 _2346_ VSS VSS VDD VDD _2347_ sky130_fd_sc_hd__a21oi_1
X_6379_ net721 net671 net658 VSS VSS VDD VDD _2348_ sky130_fd_sc_hd__nand3_1
X_6380_ net671 _2347_ _2348_ VSS VSS VDD VDD _2349_ sky130_fd_sc_hd__o21ai_0
X_6381_ _0227_ _0064_ VSS VSS VDD VDD _2350_ sky130_fd_sc_hd__xor2_1
X_6382_ net746 _2349_ _2350_ net690 VSS VSS VDD VDD _2351_
+ sky130_fd_sc_hd__a22oi_1
X_6383_ _2036_ _2345_ _2351_ VSS VSS VDD VDD _4618_ sky130_fd_sc_hd__o21ai_0
X_6384_ cpuregs\[0\]\[1\] cpuregs\[1\]\[1\] cpuregs\[2\]\[1\]
+ cpuregs\[3\]\[1\] _0041_ _0042_ VSS VSS VDD VDD _2352_ sky130_fd_sc_hd__mux4_2
X_6385_ cpuregs\[4\]\[1\] cpuregs\[5\]\[1\] cpuregs\[6\]\[1\]
+ cpuregs\[7\]\[1\] _0041_ _0042_ VSS VSS VDD VDD _2353_ sky130_fd_sc_hd__mux4_2
X_6386_ cpuregs\[16\]\[1\] cpuregs\[17\]\[1\] cpuregs\[18\]\[1\]
+ cpuregs\[19\]\[1\] _0041_ _0042_ VSS VSS VDD VDD _2354_ sky130_fd_sc_hd__mux4_2
X_6387_ cpuregs\[20\]\[1\] cpuregs\[21\]\[1\] cpuregs\[22\]\[1\]
+ cpuregs\[23\]\[1\] _0041_ _0042_ VSS VSS VDD VDD _2355_ sky130_fd_sc_hd__mux4_2
X_6388_ _2352_ _2353_ _2354_ _2355_ _0043_ _0045_ VSS VSS
+ VDD VDD _2356_ sky130_fd_sc_hd__mux4_2
X_6389_ cpuregs\[8\]\[1\] cpuregs\[9\]\[1\] cpuregs\[10\]\[1\]
+ cpuregs\[11\]\[1\] _0041_ _0042_ VSS VSS VDD VDD _2357_ sky130_fd_sc_hd__mux4_2
X_6390_ cpuregs\[12\]\[1\] cpuregs\[13\]\[1\] cpuregs\[14\]\[1\]
+ cpuregs\[15\]\[1\] _0041_ _0042_ VSS VSS VDD VDD _2358_ sky130_fd_sc_hd__mux4_2
X_6391_ cpuregs\[24\]\[1\] cpuregs\[25\]\[1\] cpuregs\[26\]\[1\]
+ cpuregs\[27\]\[1\] _0041_ _0042_ VSS VSS VDD VDD _2359_ sky130_fd_sc_hd__mux4_2
X_6392_ cpuregs\[28\]\[1\] cpuregs\[29\]\[1\] cpuregs\[30\]\[1\]
+ cpuregs\[31\]\[1\] _0041_ _0042_ VSS VSS VDD VDD _2360_ sky130_fd_sc_hd__mux4_2
X_6393_ _2357_ _2358_ _2359_ _2360_ _0043_ _0045_ VSS VSS
+ VDD VDD _2361_ sky130_fd_sc_hd__mux4_2
X_6394_ _2356_ _2361_ _0044_ VSS VSS VDD VDD _2362_ sky130_fd_sc_hd__mux2i_1
X_6395_ _1687_ _2362_ VSS VSS VDD VDD _2363_ sky130_fd_sc_hd__nor2_1
X_6396_ reg_pc\[1\] net688 _2363_ VSS VSS VDD VDD _2364_ sky130_fd_sc_hd__a21oi_1
X_6397_ _0333_ net657 VSS VSS VDD VDD _2365_ sky130_fd_sc_hd__nor2_1
X_6398_ net706 net657 _2365_ VSS VSS VDD VDD _2366_ sky130_fd_sc_hd__a21oi_1
X_6399_ net732 net671 net658 VSS VSS VDD VDD _2367_ sky130_fd_sc_hd__nand3_1
X_6400_ net671 _2366_ _2367_ VSS VSS VDD VDD _2368_ sky130_fd_sc_hd__o21ai_0
X_6401_ _0065_ net690 _2368_ net746 VSS VSS VDD VDD _2369_
+ sky130_fd_sc_hd__a22oi_1
X_6402_ _2036_ _2364_ _2369_ VSS VSS VDD VDD _4607_ sky130_fd_sc_hd__o21ai_0
X_6403_ _0055_ net657 VSS VSS VDD VDD _2370_ sky130_fd_sc_hd__nor2_1
X_6404_ net707 net657 _2370_ VSS VSS VDD VDD _2371_ sky130_fd_sc_hd__a21oi_1
X_6405_ cpuregs\[0\]\[0\] cpuregs\[1\]\[0\] cpuregs\[2\]\[0\]
+ cpuregs\[3\]\[0\] _0041_ net768 VSS VSS VDD VDD _2372_ sky130_fd_sc_hd__mux4_2
X_6406_ cpuregs\[4\]\[0\] cpuregs\[5\]\[0\] cpuregs\[6\]\[0\]
+ cpuregs\[7\]\[0\] net774 net768 VSS VSS VDD VDD _2373_ sky130_fd_sc_hd__mux4_2
X_6407_ cpuregs\[8\]\[0\] cpuregs\[9\]\[0\] cpuregs\[10\]\[0\]
+ cpuregs\[11\]\[0\] _0041_ net768 VSS VSS VDD VDD _2374_ sky130_fd_sc_hd__mux4_2
X_6408_ cpuregs\[12\]\[0\] cpuregs\[13\]\[0\] cpuregs\[14\]\[0\]
+ cpuregs\[15\]\[0\] _0041_ net768 VSS VSS VDD VDD _2375_ sky130_fd_sc_hd__mux4_2
X_6409_ _2372_ _2373_ _2374_ _2375_ _0043_ net764 VSS VSS
+ VDD VDD _2376_ sky130_fd_sc_hd__mux4_2
X_6410_ cpuregs\[16\]\[0\] cpuregs\[17\]\[0\] cpuregs\[18\]\[0\]
+ cpuregs\[19\]\[0\] _0041_ net768 VSS VSS VDD VDD _2377_ sky130_fd_sc_hd__mux4_2
X_6411_ cpuregs\[20\]\[0\] cpuregs\[21\]\[0\] cpuregs\[22\]\[0\]
+ cpuregs\[23\]\[0\] _0041_ net768 VSS VSS VDD VDD _2378_ sky130_fd_sc_hd__mux4_2
X_6412_ cpuregs\[24\]\[0\] cpuregs\[25\]\[0\] cpuregs\[26\]\[0\]
+ cpuregs\[27\]\[0\] _0041_ net768 VSS VSS VDD VDD _2379_ sky130_fd_sc_hd__mux4_2
X_6413_ cpuregs\[28\]\[0\] cpuregs\[29\]\[0\] cpuregs\[30\]\[0\]
+ cpuregs\[31\]\[0\] _0041_ net768 VSS VSS VDD VDD _2380_ sky130_fd_sc_hd__mux4_2
X_6414_ _2377_ _2378_ _2379_ _2380_ net766 net764 VSS VSS
+ VDD VDD _2381_ sky130_fd_sc_hd__mux4_2
X_6415_ _2376_ _2381_ _0045_ VSS VSS VDD VDD _2382_ sky130_fd_sc_hd__mux2i_1
X_6416_ _1687_ _2036_ _2382_ VSS VSS VDD VDD _2383_ sky130_fd_sc_hd__nor3_1
X_6417_ _0228_ net690 _2383_ VSS VSS VDD VDD _2384_ sky130_fd_sc_hd__a21oi_1
X_6418_ net689 net671 _2371_ _2384_ VSS VSS VDD VDD _4596_
+ sky130_fd_sc_hd__o31ai_1
Xplace757 cpu_state\[3\] VSS VSS VDD VDD net748 sky130_fd_sc_hd__buf_4
Xplace753 decoder_trigger VSS VSS VDD VDD net744 sky130_fd_sc_hd__buf_4
Xplace705 _0978_ VSS VSS VDD VDD net696 sky130_fd_sc_hd__buf_4
Xplace703 _1023_ VSS VSS VDD VDD net694 sky130_fd_sc_hd__buf_4
Xplace702 _1504_ VSS VSS VDD VDD net693 sky130_fd_sc_hd__buf_4
Xplace701 _1541_ VSS VSS VDD VDD net692 sky130_fd_sc_hd__buf_4
Xplace698 _1667_ VSS VSS VDD VDD net689 sky130_fd_sc_hd__buf_4
X_6426_ cpuregs\[0\]\[30\] cpuregs\[1\]\[30\] cpuregs\[2\]\[30\]
+ cpuregs\[3\]\[30\] _0046_ _0047_ VSS VSS VDD VDD _2392_ sky130_fd_sc_hd__mux4_2
Xplace696 _2423_ VSS VSS VDD VDD net687 sky130_fd_sc_hd__buf_4
Xplace695 _2933_ VSS VSS VDD VDD net686 sky130_fd_sc_hd__buf_4
Xplace704 _1002_ VSS VSS VDD VDD net695 sky130_fd_sc_hd__buf_4
X_6430_ cpuregs\[4\]\[30\] cpuregs\[5\]\[30\] cpuregs\[6\]\[30\]
+ cpuregs\[7\]\[30\] _0046_ _0047_ VSS VSS VDD VDD _2396_ sky130_fd_sc_hd__mux4_2
X_6431_ cpuregs\[8\]\[30\] cpuregs\[9\]\[30\] cpuregs\[10\]\[30\]
+ cpuregs\[11\]\[30\] _0046_ _0047_ VSS VSS VDD VDD _2397_ sky130_fd_sc_hd__mux4_2
Xplace690 _4247_ VSS VSS VDD VDD net681 sky130_fd_sc_hd__buf_4
Xplace689 _0812_ VSS VSS VDD VDD net680 sky130_fd_sc_hd__buf_4
Xplace707 _0865_ VSS VSS VDD VDD net698 sky130_fd_sc_hd__buf_4
Xplace708 _0864_ VSS VSS VDD VDD net699 sky130_fd_sc_hd__buf_4
Xplace688 _1099_ VSS VSS VDD VDD net679 sky130_fd_sc_hd__buf_4
X_6437_ cpuregs\[12\]\[30\] cpuregs\[13\]\[30\] cpuregs\[14\]\[30\]
+ cpuregs\[15\]\[30\] _0046_ _0047_ VSS VSS VDD VDD _2403_ sky130_fd_sc_hd__mux4_2
Xplace709 net361 VSS VSS VDD VDD net700 sky130_fd_sc_hd__buf_4
Xplace712 net338 VSS VSS VDD VDD net703 sky130_fd_sc_hd__buf_4
Xplace713 net337 VSS VSS VDD VDD net704 sky130_fd_sc_hd__buf_4
Xplace682 cpuregs_wrdata\[3\] VSS VSS VDD VDD net673 sky130_fd_sc_hd__buf_4
X_6442_ _2392_ _2396_ _2397_ _2403_ _0048_ _0049_ VSS VSS
+ VDD VDD _2408_ sky130_fd_sc_hd__mux4_2
X_6443_ cpuregs\[16\]\[30\] cpuregs\[17\]\[30\] cpuregs\[18\]\[30\]
+ cpuregs\[19\]\[30\] net760 net757 VSS VSS VDD VDD _2409_ sky130_fd_sc_hd__mux4_2
X_6444_ cpuregs\[20\]\[30\] cpuregs\[21\]\[30\] cpuregs\[22\]\[30\]
+ cpuregs\[23\]\[30\] net760 net757 VSS VSS VDD VDD _2410_ sky130_fd_sc_hd__mux4_2
X_6445_ cpuregs\[24\]\[30\] cpuregs\[25\]\[30\] cpuregs\[26\]\[30\]
+ cpuregs\[27\]\[30\] net760 net757 VSS VSS VDD VDD _2411_ sky130_fd_sc_hd__mux4_2
X_6446_ cpuregs\[28\]\[30\] cpuregs\[29\]\[30\] cpuregs\[30\]\[30\]
+ cpuregs\[31\]\[30\] net760 net757 VSS VSS VDD VDD _2412_ sky130_fd_sc_hd__mux4_2
X_6447_ _2409_ _2410_ _2411_ _2412_ net754 _0049_ VSS VSS
+ VDD VDD _2413_ sky130_fd_sc_hd__mux4_2
Xplace716 net334 VSS VSS VDD VDD net707 sky130_fd_sc_hd__buf_4
Xplace714 net336 VSS VSS VDD VDD net705 sky130_fd_sc_hd__buf_4
X_6450_ _2408_ _2413_ net751 VSS VSS VDD VDD _2416_ sky130_fd_sc_hd__mux2i_1
X_6451_ is_lui_auipc_jal is_jalr_addi_slti_sltiu_xori_ori_andi
+ VSS VSS VDD VDD _2417_ sky130_fd_sc_hd__nor2_1
X_6452_ decoded_imm_j\[2\] decoded_imm_j\[1\] VSS VSS VDD
+ VDD _2418_ sky130_fd_sc_hd__nor2_1
X_6453_ decoded_imm_j\[11\] decoded_imm_j\[4\] decoded_imm_j\[3\]
+ VSS VSS VDD VDD _2419_ sky130_fd_sc_hd__nor3_1
X_6454_ _2418_ _2419_ VSS VSS VDD VDD _2420_ sky130_fd_sc_hd__nand2_1
X_6455_ _2417_ _2420_ VSS VSS VDD VDD _2421_ sky130_fd_sc_hd__nand2_1
Xplace715 net335 VSS VSS VDD VDD net706 sky130_fd_sc_hd__buf_4
X_6457_ is_lui_auipc_jal is_jalr_addi_slti_sltiu_xori_ori_andi
+ VSS VSS VDD VDD _2423_ sky130_fd_sc_hd__or2_2
Xplace671 _0525_ VSS VSS VDD VDD net662 sky130_fd_sc_hd__buf_4
Xplace681 cpuregs_wrdata\[2\] VSS VSS VDD VDD net672 sky130_fd_sc_hd__buf_4
X_6460_ decoded_imm\[30\] net687 VSS VSS VDD VDD _2426_ sky130_fd_sc_hd__nand2_1
X_6461_ _2416_ net668 _2426_ VSS VSS VDD VDD _4587_ sky130_fd_sc_hd__o21ai_0
Xplace717 net333 VSS VSS VDD VDD net708 sky130_fd_sc_hd__buf_4
Xplace718 net332 VSS VSS VDD VDD net709 sky130_fd_sc_hd__buf_4
X_6464_ cpuregs\[0\]\[29\] cpuregs\[1\]\[29\] cpuregs\[2\]\[29\]
+ cpuregs\[3\]\[29\] net762 net756 VSS VSS VDD VDD _2429_ sky130_fd_sc_hd__mux4_2
Xplace719 net331 VSS VSS VDD VDD net710 sky130_fd_sc_hd__buf_4
Xplace720 net330 VSS VSS VDD VDD net711 sky130_fd_sc_hd__buf_4
X_6467_ cpuregs\[4\]\[29\] cpuregs\[5\]\[29\] cpuregs\[6\]\[29\]
+ cpuregs\[7\]\[29\] net762 net756 VSS VSS VDD VDD _2432_ sky130_fd_sc_hd__mux4_2
Xplace736 net313 VSS VSS VDD VDD net727 sky130_fd_sc_hd__buf_4
Xplace721 net328 VSS VSS VDD VDD net712 sky130_fd_sc_hd__buf_4
X_6470_ cpuregs\[8\]\[29\] cpuregs\[9\]\[29\] cpuregs\[10\]\[29\]
+ cpuregs\[11\]\[29\] net762 net756 VSS VSS VDD VDD _2435_ sky130_fd_sc_hd__mux4_2
Xplace723 net326 VSS VSS VDD VDD net714 sky130_fd_sc_hd__buf_4
Xplace722 net327 VSS VSS VDD VDD net713 sky130_fd_sc_hd__buf_4
X_6473_ cpuregs\[12\]\[29\] cpuregs\[13\]\[29\] cpuregs\[14\]\[29\]
+ cpuregs\[15\]\[29\] net762 net756 VSS VSS VDD VDD _2438_ sky130_fd_sc_hd__mux4_2
Xplace661 _4575_ VSS VSS VDD VDD net652 sky130_fd_sc_hd__buf_4
Xplace660 _0844_ VSS VSS VDD VDD net651 sky130_fd_sc_hd__buf_4
X_6476_ _2429_ _2432_ _2435_ _2438_ net753 net752 VSS VSS
+ VDD VDD _2441_ sky130_fd_sc_hd__mux4_2
Xplace659 _0842_ VSS VSS VDD VDD net650 sky130_fd_sc_hd__buf_4
Xplace658 _0848_ VSS VSS VDD VDD net649 sky130_fd_sc_hd__buf_4
X_6479_ cpuregs\[16\]\[29\] cpuregs\[17\]\[29\] cpuregs\[18\]\[29\]
+ cpuregs\[19\]\[29\] net761 net755 VSS VSS VDD VDD _2444_ sky130_fd_sc_hd__mux4_2
X_6480_ cpuregs\[20\]\[29\] cpuregs\[21\]\[29\] cpuregs\[22\]\[29\]
+ cpuregs\[23\]\[29\] net761 net755 VSS VSS VDD VDD _2445_ sky130_fd_sc_hd__mux4_2
Xplace657 _0841_ VSS VSS VDD VDD net648 sky130_fd_sc_hd__buf_4
Xplace656 _0840_ VSS VSS VDD VDD net647 sky130_fd_sc_hd__buf_4
X_6483_ cpuregs\[24\]\[29\] cpuregs\[25\]\[29\] cpuregs\[26\]\[29\]
+ cpuregs\[27\]\[29\] net761 net755 VSS VSS VDD VDD _2448_ sky130_fd_sc_hd__mux4_2
Xplace655 _0839_ VSS VSS VDD VDD net646 sky130_fd_sc_hd__buf_4
Xplace654 _0856_ VSS VSS VDD VDD net645 sky130_fd_sc_hd__buf_4
X_6486_ cpuregs\[28\]\[29\] cpuregs\[29\]\[29\] cpuregs\[30\]\[29\]
+ cpuregs\[31\]\[29\] net761 net755 VSS VSS VDD VDD _2451_ sky130_fd_sc_hd__mux4_2
Xplace724 net325 VSS VSS VDD VDD net715 sky130_fd_sc_hd__buf_4
Xplace653 _0849_ VSS VSS VDD VDD net644 sky130_fd_sc_hd__buf_4
X_6489_ _2444_ _2445_ _2448_ _2451_ net753 net752 VSS VSS
+ VDD VDD _2454_ sky130_fd_sc_hd__mux4_2
Xplace652 _0838_ VSS VSS VDD VDD net643 sky130_fd_sc_hd__buf_4
X_6491_ _2441_ _2454_ _0050_ VSS VSS VDD VDD _2456_ sky130_fd_sc_hd__mux2i_1
Xplace651 _0847_ VSS VSS VDD VDD net642 sky130_fd_sc_hd__buf_4
X_6493_ decoded_imm\[29\] net687 VSS VSS VDD VDD _2458_ sky130_fd_sc_hd__nand2_1
X_6494_ net668 _2456_ _2458_ VSS VSS VDD VDD _4585_ sky130_fd_sc_hd__o21ai_0
Xplace650 _0837_ VSS VSS VDD VDD net641 sky130_fd_sc_hd__buf_4
Xplace649 _0836_ VSS VSS VDD VDD net640 sky130_fd_sc_hd__buf_4
X_6497_ cpuregs\[0\]\[28\] cpuregs\[1\]\[28\] cpuregs\[2\]\[28\]
+ cpuregs\[3\]\[28\] net762 net756 VSS VSS VDD VDD _2461_ sky130_fd_sc_hd__mux4_2
X_6498_ cpuregs\[4\]\[28\] cpuregs\[5\]\[28\] cpuregs\[6\]\[28\]
+ cpuregs\[7\]\[28\] net762 net756 VSS VSS VDD VDD _2462_ sky130_fd_sc_hd__mux4_2
X_6499_ cpuregs\[8\]\[28\] cpuregs\[9\]\[28\] cpuregs\[10\]\[28\]
+ cpuregs\[11\]\[28\] net762 net756 VSS VSS VDD VDD _2463_ sky130_fd_sc_hd__mux4_2
Xplace725 net324 VSS VSS VDD VDD net716 sky130_fd_sc_hd__buf_4
Xplace648 _0850_ VSS VSS VDD VDD net639 sky130_fd_sc_hd__buf_4
X_6502_ cpuregs\[12\]\[28\] cpuregs\[13\]\[28\] cpuregs\[14\]\[28\]
+ cpuregs\[15\]\[28\] net762 net756 VSS VSS VDD VDD _2466_ sky130_fd_sc_hd__mux4_2
X_6503_ _2461_ _2462_ _2463_ _2466_ net753 net752 VSS VSS
+ VDD VDD _2467_ sky130_fd_sc_hd__mux4_2
Xplace647 _0835_ VSS VSS VDD VDD net638 sky130_fd_sc_hd__buf_4
Xplace646 _0846_ VSS VSS VDD VDD net637 sky130_fd_sc_hd__buf_4
X_6506_ cpuregs\[16\]\[28\] cpuregs\[17\]\[28\] cpuregs\[18\]\[28\]
+ cpuregs\[19\]\[28\] net761 net755 VSS VSS VDD VDD _2470_ sky130_fd_sc_hd__mux4_2
Xplace645 _0834_ VSS VSS VDD VDD net636 sky130_fd_sc_hd__buf_4
Xplace644 _0833_ VSS VSS VDD VDD net635 sky130_fd_sc_hd__buf_4
X_6509_ cpuregs\[20\]\[28\] cpuregs\[21\]\[28\] cpuregs\[22\]\[28\]
+ cpuregs\[23\]\[28\] net761 net755 VSS VSS VDD VDD _2473_ sky130_fd_sc_hd__mux4_2
X_6510_ cpuregs\[24\]\[28\] cpuregs\[25\]\[28\] cpuregs\[26\]\[28\]
+ cpuregs\[27\]\[28\] net761 net755 VSS VSS VDD VDD _2474_ sky130_fd_sc_hd__mux4_2
X_6511_ cpuregs\[28\]\[28\] cpuregs\[29\]\[28\] cpuregs\[30\]\[28\]
+ cpuregs\[31\]\[28\] net761 net755 VSS VSS VDD VDD _2475_ sky130_fd_sc_hd__mux4_2
X_6512_ _2470_ _2473_ _2474_ _2475_ net753 net752 VSS VSS
+ VDD VDD _2476_ sky130_fd_sc_hd__mux4_2
X_6513_ _2467_ _2476_ _0050_ VSS VSS VDD VDD _2477_ sky130_fd_sc_hd__mux2i_1
X_6514_ decoded_imm\[28\] net687 VSS VSS VDD VDD _2478_ sky130_fd_sc_hd__nand2_1
X_6515_ net668 _2477_ _2478_ VSS VSS VDD VDD _4584_ sky130_fd_sc_hd__o21ai_0
X_6516_ cpuregs\[0\]\[27\] cpuregs\[1\]\[27\] cpuregs\[2\]\[27\]
+ cpuregs\[3\]\[27\] net761 net755 VSS VSS VDD VDD _2479_ sky130_fd_sc_hd__mux4_2
X_6517_ cpuregs\[4\]\[27\] cpuregs\[5\]\[27\] cpuregs\[6\]\[27\]
+ cpuregs\[7\]\[27\] net761 net755 VSS VSS VDD VDD _2480_ sky130_fd_sc_hd__mux4_2
Xplace643 _0851_ VSS VSS VDD VDD net634 sky130_fd_sc_hd__buf_4
Xplace726 net323 VSS VSS VDD VDD net717 sky130_fd_sc_hd__buf_4
X_6520_ cpuregs\[8\]\[27\] cpuregs\[9\]\[27\] cpuregs\[10\]\[27\]
+ cpuregs\[11\]\[27\] net761 net755 VSS VSS VDD VDD _2483_ sky130_fd_sc_hd__mux4_2
X_6521_ cpuregs\[12\]\[27\] cpuregs\[13\]\[27\] cpuregs\[14\]\[27\]
+ cpuregs\[15\]\[27\] net761 net755 VSS VSS VDD VDD _2484_ sky130_fd_sc_hd__mux4_2
X_6522_ _2479_ _2480_ _2483_ _2484_ net754 net752 VSS VSS
+ VDD VDD _2485_ sky130_fd_sc_hd__mux4_2
X_6523_ cpuregs\[16\]\[27\] cpuregs\[17\]\[27\] cpuregs\[18\]\[27\]
+ cpuregs\[19\]\[27\] net761 net755 VSS VSS VDD VDD _2486_ sky130_fd_sc_hd__mux4_2
X_6524_ cpuregs\[20\]\[27\] cpuregs\[21\]\[27\] cpuregs\[22\]\[27\]
+ cpuregs\[23\]\[27\] net761 net755 VSS VSS VDD VDD _2487_ sky130_fd_sc_hd__mux4_2
X_6525_ cpuregs\[24\]\[27\] cpuregs\[25\]\[27\] cpuregs\[26\]\[27\]
+ cpuregs\[27\]\[27\] net761 net755 VSS VSS VDD VDD _2488_ sky130_fd_sc_hd__mux4_2
X_6526_ cpuregs\[28\]\[27\] cpuregs\[29\]\[27\] cpuregs\[30\]\[27\]
+ cpuregs\[31\]\[27\] net761 net755 VSS VSS VDD VDD _2489_ sky130_fd_sc_hd__mux4_2
X_6527_ _2486_ _2487_ _2488_ _2489_ net754 net752 VSS VSS
+ VDD VDD _2490_ sky130_fd_sc_hd__mux4_2
X_6528_ _2485_ _2490_ net751 VSS VSS VDD VDD _2491_ sky130_fd_sc_hd__mux2i_1
X_6529_ decoded_imm\[27\] net687 VSS VSS VDD VDD _2492_ sky130_fd_sc_hd__nand2_1
X_6530_ net668 _2491_ _2492_ VSS VSS VDD VDD _4583_ sky130_fd_sc_hd__o21ai_0
X_6531_ cpuregs\[0\]\[26\] cpuregs\[1\]\[26\] cpuregs\[2\]\[26\]
+ cpuregs\[3\]\[26\] net762 net756 VSS VSS VDD VDD _2493_ sky130_fd_sc_hd__mux4_2
Xplace642 _0863_ VSS VSS VDD VDD net633 sky130_fd_sc_hd__buf_4
Xplace727 net322 VSS VSS VDD VDD net718 sky130_fd_sc_hd__buf_4
X_6534_ cpuregs\[4\]\[26\] cpuregs\[5\]\[26\] cpuregs\[6\]\[26\]
+ cpuregs\[7\]\[26\] net761 net755 VSS VSS VDD VDD _2496_ sky130_fd_sc_hd__mux4_2
Xplace641 _0862_ VSS VSS VDD VDD net632 sky130_fd_sc_hd__buf_4
Xplace640 _0861_ VSS VSS VDD VDD net631 sky130_fd_sc_hd__buf_4
X_6537_ cpuregs\[8\]\[26\] cpuregs\[9\]\[26\] cpuregs\[10\]\[26\]
+ cpuregs\[11\]\[26\] net762 net756 VSS VSS VDD VDD _2499_ sky130_fd_sc_hd__mux4_2
X_6538_ cpuregs\[12\]\[26\] cpuregs\[13\]\[26\] cpuregs\[14\]\[26\]
+ cpuregs\[15\]\[26\] net762 net756 VSS VSS VDD VDD _2500_ sky130_fd_sc_hd__mux4_2
X_6539_ _2493_ _2496_ _2499_ _2500_ net753 net752 VSS VSS
+ VDD VDD _2501_ sky130_fd_sc_hd__mux4_2
X_6540_ cpuregs\[16\]\[26\] cpuregs\[17\]\[26\] cpuregs\[18\]\[26\]
+ cpuregs\[19\]\[26\] net761 net755 VSS VSS VDD VDD _2502_ sky130_fd_sc_hd__mux4_2
Xplace728 net321 VSS VSS VDD VDD net719 sky130_fd_sc_hd__buf_4
Xplace639 _0860_ VSS VSS VDD VDD net630 sky130_fd_sc_hd__buf_4
X_6543_ cpuregs\[20\]\[26\] cpuregs\[21\]\[26\] cpuregs\[22\]\[26\]
+ cpuregs\[23\]\[26\] net761 net755 VSS VSS VDD VDD _2505_ sky130_fd_sc_hd__mux4_2
X_6544_ cpuregs\[24\]\[26\] cpuregs\[25\]\[26\] cpuregs\[26\]\[26\]
+ cpuregs\[27\]\[26\] net761 net755 VSS VSS VDD VDD _2506_ sky130_fd_sc_hd__mux4_2
X_6545_ cpuregs\[28\]\[26\] cpuregs\[29\]\[26\] cpuregs\[30\]\[26\]
+ cpuregs\[31\]\[26\] net761 net755 VSS VSS VDD VDD _2507_ sky130_fd_sc_hd__mux4_2
X_6546_ _2502_ _2505_ _2506_ _2507_ net753 net752 VSS VSS
+ VDD VDD _2508_ sky130_fd_sc_hd__mux4_2
X_6547_ _2501_ _2508_ _0050_ VSS VSS VDD VDD _2509_ sky130_fd_sc_hd__mux2i_1
X_6548_ decoded_imm\[26\] net687 VSS VSS VDD VDD _2510_ sky130_fd_sc_hd__nand2_1
X_6549_ net668 _2509_ _2510_ VSS VSS VDD VDD _4582_ sky130_fd_sc_hd__o21ai_0
Xplace729 net320 VSS VSS VDD VDD net720 sky130_fd_sc_hd__buf_4
Xplace638 _0852_ VSS VSS VDD VDD net629 sky130_fd_sc_hd__buf_4
X_6552_ cpuregs\[0\]\[25\] cpuregs\[1\]\[25\] cpuregs\[2\]\[25\]
+ cpuregs\[3\]\[25\] net762 net756 VSS VSS VDD VDD _2513_ sky130_fd_sc_hd__mux4_2
X_6553_ cpuregs\[4\]\[25\] cpuregs\[5\]\[25\] cpuregs\[6\]\[25\]
+ cpuregs\[7\]\[25\] net762 net756 VSS VSS VDD VDD _2514_ sky130_fd_sc_hd__mux4_2
X_6554_ cpuregs\[8\]\[25\] cpuregs\[9\]\[25\] cpuregs\[10\]\[25\]
+ cpuregs\[11\]\[25\] net762 net756 VSS VSS VDD VDD _2515_ sky130_fd_sc_hd__mux4_2
Xplace730 net319 VSS VSS VDD VDD net721 sky130_fd_sc_hd__buf_4
Xplace637 _0859_ VSS VSS VDD VDD net628 sky130_fd_sc_hd__buf_4
X_6557_ cpuregs\[12\]\[25\] cpuregs\[13\]\[25\] cpuregs\[14\]\[25\]
+ cpuregs\[15\]\[25\] net762 net756 VSS VSS VDD VDD _2518_ sky130_fd_sc_hd__mux4_2
Xplace636 _0858_ VSS VSS VDD VDD net627 sky130_fd_sc_hd__buf_4
Xplace731 net318 VSS VSS VDD VDD net722 sky130_fd_sc_hd__buf_4
X_6560_ _2513_ _2514_ _2515_ _2518_ net753 net752 VSS VSS
+ VDD VDD _2521_ sky130_fd_sc_hd__mux4_2
X_6561_ cpuregs\[16\]\[25\] cpuregs\[17\]\[25\] cpuregs\[18\]\[25\]
+ cpuregs\[19\]\[25\] net761 net755 VSS VSS VDD VDD _2522_ sky130_fd_sc_hd__mux4_2
X_6562_ cpuregs\[20\]\[25\] cpuregs\[21\]\[25\] cpuregs\[22\]\[25\]
+ cpuregs\[23\]\[25\] net761 net755 VSS VSS VDD VDD _2523_ sky130_fd_sc_hd__mux4_2
X_6563_ cpuregs\[24\]\[25\] cpuregs\[25\]\[25\] cpuregs\[26\]\[25\]
+ cpuregs\[27\]\[25\] net761 net755 VSS VSS VDD VDD _2524_ sky130_fd_sc_hd__mux4_2
Xplace635 _0857_ VSS VSS VDD VDD net626 sky130_fd_sc_hd__buf_4
Xplace634 _0853_ VSS VSS VDD VDD net625 sky130_fd_sc_hd__buf_4
X_6566_ cpuregs\[28\]\[25\] cpuregs\[29\]\[25\] cpuregs\[30\]\[25\]
+ cpuregs\[31\]\[25\] net761 net755 VSS VSS VDD VDD _2527_ sky130_fd_sc_hd__mux4_2
X_6567_ _2522_ _2523_ _2524_ _2527_ net753 net752 VSS VSS
+ VDD VDD _2528_ sky130_fd_sc_hd__mux4_2
X_6568_ _2521_ _2528_ _0050_ VSS VSS VDD VDD _2529_ sky130_fd_sc_hd__mux2i_1
X_6569_ decoded_imm\[25\] net687 VSS VSS VDD VDD _2530_ sky130_fd_sc_hd__nand2_1
X_6570_ net668 _2529_ _2530_ VSS VSS VDD VDD _4581_ sky130_fd_sc_hd__o21ai_0
X_6571_ cpuregs\[0\]\[24\] cpuregs\[1\]\[24\] cpuregs\[2\]\[24\]
+ cpuregs\[3\]\[24\] net761 net755 VSS VSS VDD VDD _2531_ sky130_fd_sc_hd__mux4_2
X_6572_ cpuregs\[4\]\[24\] cpuregs\[5\]\[24\] cpuregs\[6\]\[24\]
+ cpuregs\[7\]\[24\] net761 net755 VSS VSS VDD VDD _2532_ sky130_fd_sc_hd__mux4_2
X_6573_ cpuregs\[8\]\[24\] cpuregs\[9\]\[24\] cpuregs\[10\]\[24\]
+ cpuregs\[11\]\[24\] net761 net755 VSS VSS VDD VDD _2533_ sky130_fd_sc_hd__mux4_2
X_6574_ cpuregs\[12\]\[24\] cpuregs\[13\]\[24\] cpuregs\[14\]\[24\]
+ cpuregs\[15\]\[24\] net761 net755 VSS VSS VDD VDD _2534_ sky130_fd_sc_hd__mux4_2
X_6575_ _2531_ _2532_ _2533_ _2534_ net753 net752 VSS VSS
+ VDD VDD _2535_ sky130_fd_sc_hd__mux4_2
X_6576_ cpuregs\[16\]\[24\] cpuregs\[17\]\[24\] cpuregs\[18\]\[24\]
+ cpuregs\[19\]\[24\] net761 net755 VSS VSS VDD VDD _2536_ sky130_fd_sc_hd__mux4_2
X_6577_ cpuregs\[20\]\[24\] cpuregs\[21\]\[24\] cpuregs\[22\]\[24\]
+ cpuregs\[23\]\[24\] net761 net755 VSS VSS VDD VDD _2537_ sky130_fd_sc_hd__mux4_2
X_6578_ cpuregs\[24\]\[24\] cpuregs\[25\]\[24\] cpuregs\[26\]\[24\]
+ cpuregs\[27\]\[24\] net761 net755 VSS VSS VDD VDD _2538_ sky130_fd_sc_hd__mux4_2
X_6579_ cpuregs\[28\]\[24\] cpuregs\[29\]\[24\] cpuregs\[30\]\[24\]
+ cpuregs\[31\]\[24\] net761 net755 VSS VSS VDD VDD _2539_ sky130_fd_sc_hd__mux4_2
Xplace732 net317 VSS VSS VDD VDD net723 sky130_fd_sc_hd__buf_4
Xplace633 _0854_ VSS VSS VDD VDD net624 sky130_fd_sc_hd__buf_4
X_6582_ _2536_ _2537_ _2538_ _2539_ net753 net752 VSS VSS
+ VDD VDD _2542_ sky130_fd_sc_hd__mux4_2
X_6583_ _2535_ _2542_ _0050_ VSS VSS VDD VDD _2543_ sky130_fd_sc_hd__mux2i_1
X_6584_ decoded_imm\[24\] net687 VSS VSS VDD VDD _2544_ sky130_fd_sc_hd__nand2_1
X_6585_ net668 _2543_ _2544_ VSS VSS VDD VDD _4580_ sky130_fd_sc_hd__o21ai_0
X_6586_ cpuregs\[0\]\[23\] cpuregs\[1\]\[23\] cpuregs\[2\]\[23\]
+ cpuregs\[3\]\[23\] net761 net755 VSS VSS VDD VDD _2545_ sky130_fd_sc_hd__mux4_2
X_6587_ cpuregs\[4\]\[23\] cpuregs\[5\]\[23\] cpuregs\[6\]\[23\]
+ cpuregs\[7\]\[23\] net761 net755 VSS VSS VDD VDD _2546_ sky130_fd_sc_hd__mux4_2
X_6588_ cpuregs\[8\]\[23\] cpuregs\[9\]\[23\] cpuregs\[10\]\[23\]
+ cpuregs\[11\]\[23\] net761 net755 VSS VSS VDD VDD _2547_ sky130_fd_sc_hd__mux4_2
X_6589_ cpuregs\[12\]\[23\] cpuregs\[13\]\[23\] cpuregs\[14\]\[23\]
+ cpuregs\[15\]\[23\] net761 net755 VSS VSS VDD VDD _2548_ sky130_fd_sc_hd__mux4_2
X_6590_ _2545_ _2546_ _2547_ _2548_ net753 net752 VSS VSS
+ VDD VDD _2549_ sky130_fd_sc_hd__mux4_2
X_6591_ cpuregs\[16\]\[23\] cpuregs\[17\]\[23\] cpuregs\[18\]\[23\]
+ cpuregs\[19\]\[23\] net761 net755 VSS VSS VDD VDD _2550_ sky130_fd_sc_hd__mux4_2
X_6592_ cpuregs\[20\]\[23\] cpuregs\[21\]\[23\] cpuregs\[22\]\[23\]
+ cpuregs\[23\]\[23\] net761 net755 VSS VSS VDD VDD _2551_ sky130_fd_sc_hd__mux4_2
Xplace733 net316 VSS VSS VDD VDD net724 sky130_fd_sc_hd__buf_4
Xplace632 _0855_ VSS VSS VDD VDD net623 sky130_fd_sc_hd__buf_4
X_6595_ cpuregs\[24\]\[23\] cpuregs\[25\]\[23\] cpuregs\[26\]\[23\]
+ cpuregs\[27\]\[23\] net761 net755 VSS VSS VDD VDD _2554_ sky130_fd_sc_hd__mux4_2
X_6596_ cpuregs\[28\]\[23\] cpuregs\[29\]\[23\] cpuregs\[30\]\[23\]
+ cpuregs\[31\]\[23\] net761 net755 VSS VSS VDD VDD _2555_ sky130_fd_sc_hd__mux4_2
X_6597_ _2550_ _2551_ _2554_ _2555_ net753 net752 VSS VSS
+ VDD VDD _2556_ sky130_fd_sc_hd__mux4_2
X_6598_ _2549_ _2556_ _0050_ VSS VSS VDD VDD _2557_ sky130_fd_sc_hd__mux2i_1
X_6599_ decoded_imm\[23\] net687 VSS VSS VDD VDD _2558_ sky130_fd_sc_hd__nand2_1
X_6600_ net668 _2557_ _2558_ VSS VSS VDD VDD _4579_ sky130_fd_sc_hd__o21ai_0
X_6601_ cpuregs\[0\]\[22\] cpuregs\[1\]\[22\] cpuregs\[2\]\[22\]
+ cpuregs\[3\]\[22\] net761 net755 VSS VSS VDD VDD _2559_ sky130_fd_sc_hd__mux4_2
X_6602_ cpuregs\[4\]\[22\] cpuregs\[5\]\[22\] cpuregs\[6\]\[22\]
+ cpuregs\[7\]\[22\] net761 net755 VSS VSS VDD VDD _2560_ sky130_fd_sc_hd__mux4_2
X_6603_ cpuregs\[8\]\[22\] cpuregs\[9\]\[22\] cpuregs\[10\]\[22\]
+ cpuregs\[11\]\[22\] net761 net755 VSS VSS VDD VDD _2561_ sky130_fd_sc_hd__mux4_2
X_6604_ cpuregs\[12\]\[22\] cpuregs\[13\]\[22\] cpuregs\[14\]\[22\]
+ cpuregs\[15\]\[22\] net761 net755 VSS VSS VDD VDD _2562_ sky130_fd_sc_hd__mux4_2
X_6605_ _2559_ _2560_ _2561_ _2562_ net753 net752 VSS VSS
+ VDD VDD _2563_ sky130_fd_sc_hd__mux4_2
X_6606_ cpuregs\[16\]\[22\] cpuregs\[17\]\[22\] cpuregs\[18\]\[22\]
+ cpuregs\[19\]\[22\] net761 net755 VSS VSS VDD VDD _2564_ sky130_fd_sc_hd__mux4_2
X_6607_ cpuregs\[20\]\[22\] cpuregs\[21\]\[22\] cpuregs\[22\]\[22\]
+ cpuregs\[23\]\[22\] net761 net755 VSS VSS VDD VDD _2565_ sky130_fd_sc_hd__mux4_2
X_6608_ cpuregs\[24\]\[22\] cpuregs\[25\]\[22\] cpuregs\[26\]\[22\]
+ cpuregs\[27\]\[22\] net761 net755 VSS VSS VDD VDD _2566_ sky130_fd_sc_hd__mux4_2
X_6609_ cpuregs\[28\]\[22\] cpuregs\[29\]\[22\] cpuregs\[30\]\[22\]
+ cpuregs\[31\]\[22\] net761 net755 VSS VSS VDD VDD _2567_ sky130_fd_sc_hd__mux4_2
X_6610_ _2564_ _2565_ _2566_ _2567_ net753 net752 VSS VSS
+ VDD VDD _2568_ sky130_fd_sc_hd__mux4_2
X_6611_ _2563_ _2568_ _0050_ VSS VSS VDD VDD _2569_ sky130_fd_sc_hd__mux2i_1
X_6612_ decoded_imm\[22\] net687 VSS VSS VDD VDD _2570_ sky130_fd_sc_hd__nand2_1
X_6613_ net668 _2569_ _2570_ VSS VSS VDD VDD _4578_ sky130_fd_sc_hd__o21ai_0
Xplace629 _4347_ VSS VSS VDD VDD net620 sky130_fd_sc_hd__buf_4
X_6615_ cpuregs\[0\]\[21\] cpuregs\[1\]\[21\] cpuregs\[2\]\[21\]
+ cpuregs\[3\]\[21\] net761 net756 VSS VSS VDD VDD _2572_ sky130_fd_sc_hd__mux4_2
X_6616_ cpuregs\[4\]\[21\] cpuregs\[5\]\[21\] cpuregs\[6\]\[21\]
+ cpuregs\[7\]\[21\] net761 net756 VSS VSS VDD VDD _2573_ sky130_fd_sc_hd__mux4_2
X_6617_ cpuregs\[8\]\[21\] cpuregs\[9\]\[21\] cpuregs\[10\]\[21\]
+ cpuregs\[11\]\[21\] net761 net756 VSS VSS VDD VDD _2574_ sky130_fd_sc_hd__mux4_2
X_6618_ cpuregs\[12\]\[21\] cpuregs\[13\]\[21\] cpuregs\[14\]\[21\]
+ cpuregs\[15\]\[21\] net761 net756 VSS VSS VDD VDD _2575_ sky130_fd_sc_hd__mux4_2
X_6619_ _2572_ _2573_ _2574_ _2575_ net754 net752 VSS VSS
+ VDD VDD _2576_ sky130_fd_sc_hd__mux4_2
X_6620_ cpuregs\[16\]\[21\] cpuregs\[17\]\[21\] cpuregs\[18\]\[21\]
+ cpuregs\[19\]\[21\] net761 net756 VSS VSS VDD VDD _2577_ sky130_fd_sc_hd__mux4_2
X_6621_ cpuregs\[20\]\[21\] cpuregs\[21\]\[21\] cpuregs\[22\]\[21\]
+ cpuregs\[23\]\[21\] net758 net757 VSS VSS VDD VDD _2578_ sky130_fd_sc_hd__mux4_2
X_6622_ cpuregs\[24\]\[21\] cpuregs\[25\]\[21\] cpuregs\[26\]\[21\]
+ cpuregs\[27\]\[21\] net758 net757 VSS VSS VDD VDD _2579_ sky130_fd_sc_hd__mux4_2
X_6623_ cpuregs\[28\]\[21\] cpuregs\[29\]\[21\] cpuregs\[30\]\[21\]
+ cpuregs\[31\]\[21\] net758 net757 VSS VSS VDD VDD _2580_ sky130_fd_sc_hd__mux4_2
X_6624_ _2577_ _2578_ _2579_ _2580_ net754 net752 VSS VSS
+ VDD VDD _2581_ sky130_fd_sc_hd__mux4_2
X_6625_ _2576_ _2581_ net751 VSS VSS VDD VDD _2582_ sky130_fd_sc_hd__mux2i_1
X_6626_ decoded_imm\[21\] net687 VSS VSS VDD VDD _2583_ sky130_fd_sc_hd__nand2_1
X_6627_ net668 _2582_ _2583_ VSS VSS VDD VDD _4577_ sky130_fd_sc_hd__o21ai_0
X_6628_ cpuregs\[0\]\[20\] cpuregs\[1\]\[20\] cpuregs\[2\]\[20\]
+ cpuregs\[3\]\[20\] net761 net755 VSS VSS VDD VDD _2584_ sky130_fd_sc_hd__mux4_2
X_6629_ cpuregs\[4\]\[20\] cpuregs\[5\]\[20\] cpuregs\[6\]\[20\]
+ cpuregs\[7\]\[20\] net761 net755 VSS VSS VDD VDD _2585_ sky130_fd_sc_hd__mux4_2
X_6630_ cpuregs\[8\]\[20\] cpuregs\[9\]\[20\] cpuregs\[10\]\[20\]
+ cpuregs\[11\]\[20\] net761 net755 VSS VSS VDD VDD _2586_ sky130_fd_sc_hd__mux4_2
X_6631_ cpuregs\[12\]\[20\] cpuregs\[13\]\[20\] cpuregs\[14\]\[20\]
+ cpuregs\[15\]\[20\] net761 net755 VSS VSS VDD VDD _2587_ sky130_fd_sc_hd__mux4_2
Xplace631 _0845_ VSS VSS VDD VDD net622 sky130_fd_sc_hd__buf_4
Xplace734 net315 VSS VSS VDD VDD net725 sky130_fd_sc_hd__buf_4
X_6634_ _2584_ _2585_ _2586_ _2587_ net753 net752 VSS VSS
+ VDD VDD _2590_ sky130_fd_sc_hd__mux4_2
X_6635_ cpuregs\[16\]\[20\] cpuregs\[17\]\[20\] cpuregs\[18\]\[20\]
+ cpuregs\[19\]\[20\] net761 net755 VSS VSS VDD VDD _2591_ sky130_fd_sc_hd__mux4_2
X_6636_ cpuregs\[20\]\[20\] cpuregs\[21\]\[20\] cpuregs\[22\]\[20\]
+ cpuregs\[23\]\[20\] net761 net755 VSS VSS VDD VDD _2592_ sky130_fd_sc_hd__mux4_2
X_6637_ cpuregs\[24\]\[20\] cpuregs\[25\]\[20\] cpuregs\[26\]\[20\]
+ cpuregs\[27\]\[20\] net761 net755 VSS VSS VDD VDD _2593_ sky130_fd_sc_hd__mux4_2
X_6638_ cpuregs\[28\]\[20\] cpuregs\[29\]\[20\] cpuregs\[30\]\[20\]
+ cpuregs\[31\]\[20\] net761 net755 VSS VSS VDD VDD _2594_ sky130_fd_sc_hd__mux4_2
X_6639_ _2591_ _2592_ _2593_ _2594_ net753 net752 VSS VSS
+ VDD VDD _2595_ sky130_fd_sc_hd__mux4_2
Xplace735 net314 VSS VSS VDD VDD net726 sky130_fd_sc_hd__buf_4
X_6641_ _2590_ _2595_ _0050_ VSS VSS VDD VDD _2597_ sky130_fd_sc_hd__mux2i_1
X_6642_ decoded_imm\[20\] net687 VSS VSS VDD VDD _2598_ sky130_fd_sc_hd__nand2_1
X_6643_ net668 _2597_ _2598_ VSS VSS VDD VDD _4576_ sky130_fd_sc_hd__o21ai_0
X_6644_ cpuregs\[0\]\[19\] cpuregs\[1\]\[19\] cpuregs\[2\]\[19\]
+ cpuregs\[3\]\[19\] net760 net757 VSS VSS VDD VDD _2599_ sky130_fd_sc_hd__mux4_2
X_6645_ cpuregs\[4\]\[19\] cpuregs\[5\]\[19\] cpuregs\[6\]\[19\]
+ cpuregs\[7\]\[19\] net760 net757 VSS VSS VDD VDD _2600_ sky130_fd_sc_hd__mux4_2
X_6646_ cpuregs\[8\]\[19\] cpuregs\[9\]\[19\] cpuregs\[10\]\[19\]
+ cpuregs\[11\]\[19\] net760 net757 VSS VSS VDD VDD _2601_ sky130_fd_sc_hd__mux4_2
X_6647_ cpuregs\[12\]\[19\] cpuregs\[13\]\[19\] cpuregs\[14\]\[19\]
+ cpuregs\[15\]\[19\] net760 net757 VSS VSS VDD VDD _2602_ sky130_fd_sc_hd__mux4_2
X_6648_ _2599_ _2600_ _2601_ _2602_ net754 net752 VSS VSS
+ VDD VDD _2603_ sky130_fd_sc_hd__mux4_2
X_6649_ cpuregs\[16\]\[19\] cpuregs\[17\]\[19\] cpuregs\[18\]\[19\]
+ cpuregs\[19\]\[19\] net760 net757 VSS VSS VDD VDD _2604_ sky130_fd_sc_hd__mux4_2
X_6650_ cpuregs\[20\]\[19\] cpuregs\[21\]\[19\] cpuregs\[22\]\[19\]
+ cpuregs\[23\]\[19\] net760 net757 VSS VSS VDD VDD _2605_ sky130_fd_sc_hd__mux4_2
X_6651_ cpuregs\[24\]\[19\] cpuregs\[25\]\[19\] cpuregs\[26\]\[19\]
+ cpuregs\[27\]\[19\] net760 net757 VSS VSS VDD VDD _2606_ sky130_fd_sc_hd__mux4_2
X_6652_ cpuregs\[28\]\[19\] cpuregs\[29\]\[19\] cpuregs\[30\]\[19\]
+ cpuregs\[31\]\[19\] net760 net757 VSS VSS VDD VDD _2607_ sky130_fd_sc_hd__mux4_2
X_6653_ _2604_ _2605_ _2606_ _2607_ net754 net752 VSS VSS
+ VDD VDD _2608_ sky130_fd_sc_hd__mux4_2
X_6654_ _2603_ _2608_ net751 VSS VSS VDD VDD _2609_ sky130_fd_sc_hd__mux2i_1
X_6655_ decoded_imm\[19\] net687 VSS VSS VDD VDD _2610_ sky130_fd_sc_hd__nand2_1
X_6656_ net668 _2609_ _2610_ VSS VSS VDD VDD _4574_ sky130_fd_sc_hd__o21ai_0
X_6657_ cpuregs\[0\]\[18\] cpuregs\[1\]\[18\] cpuregs\[2\]\[18\]
+ cpuregs\[3\]\[18\] net760 net757 VSS VSS VDD VDD _2611_ sky130_fd_sc_hd__mux4_2
X_6658_ cpuregs\[4\]\[18\] cpuregs\[5\]\[18\] cpuregs\[6\]\[18\]
+ cpuregs\[7\]\[18\] net759 net757 VSS VSS VDD VDD _2612_ sky130_fd_sc_hd__mux4_2
X_6659_ cpuregs\[8\]\[18\] cpuregs\[9\]\[18\] cpuregs\[10\]\[18\]
+ cpuregs\[11\]\[18\] net759 net757 VSS VSS VDD VDD _2613_ sky130_fd_sc_hd__mux4_2
X_6660_ cpuregs\[12\]\[18\] cpuregs\[13\]\[18\] cpuregs\[14\]\[18\]
+ cpuregs\[15\]\[18\] net759 net757 VSS VSS VDD VDD _2614_ sky130_fd_sc_hd__mux4_2
X_6661_ _2611_ _2612_ _2613_ _2614_ net754 _0049_ VSS VSS
+ VDD VDD _2615_ sky130_fd_sc_hd__mux4_2
X_6662_ cpuregs\[16\]\[18\] cpuregs\[17\]\[18\] cpuregs\[18\]\[18\]
+ cpuregs\[19\]\[18\] net759 net757 VSS VSS VDD VDD _2616_ sky130_fd_sc_hd__mux4_2
X_6663_ cpuregs\[20\]\[18\] cpuregs\[21\]\[18\] cpuregs\[22\]\[18\]
+ cpuregs\[23\]\[18\] net759 net757 VSS VSS VDD VDD _2617_ sky130_fd_sc_hd__mux4_2
X_6664_ cpuregs\[24\]\[18\] cpuregs\[25\]\[18\] cpuregs\[26\]\[18\]
+ cpuregs\[27\]\[18\] net759 net757 VSS VSS VDD VDD _2618_ sky130_fd_sc_hd__mux4_2
X_6665_ cpuregs\[28\]\[18\] cpuregs\[29\]\[18\] cpuregs\[30\]\[18\]
+ cpuregs\[31\]\[18\] net759 net757 VSS VSS VDD VDD _2619_ sky130_fd_sc_hd__mux4_2
X_6666_ _2616_ _2617_ _2618_ _2619_ net754 _0049_ VSS VSS
+ VDD VDD _2620_ sky130_fd_sc_hd__mux4_2
X_6667_ _2615_ _2620_ net751 VSS VSS VDD VDD _2621_ sky130_fd_sc_hd__mux2i_1
X_6668_ decoded_imm\[18\] net687 VSS VSS VDD VDD _2622_ sky130_fd_sc_hd__nand2_1
X_6669_ net668 _2621_ _2622_ VSS VSS VDD VDD _4573_ sky130_fd_sc_hd__o21ai_0
X_6670_ cpuregs\[0\]\[17\] cpuregs\[1\]\[17\] cpuregs\[2\]\[17\]
+ cpuregs\[3\]\[17\] net762 net757 VSS VSS VDD VDD _2623_ sky130_fd_sc_hd__mux4_2
X_6671_ cpuregs\[4\]\[17\] cpuregs\[5\]\[17\] cpuregs\[6\]\[17\]
+ cpuregs\[7\]\[17\] net762 net756 VSS VSS VDD VDD _2624_ sky130_fd_sc_hd__mux4_2
X_6672_ cpuregs\[8\]\[17\] cpuregs\[9\]\[17\] cpuregs\[10\]\[17\]
+ cpuregs\[11\]\[17\] net762 net757 VSS VSS VDD VDD _2625_ sky130_fd_sc_hd__mux4_2
X_6673_ cpuregs\[12\]\[17\] cpuregs\[13\]\[17\] cpuregs\[14\]\[17\]
+ cpuregs\[15\]\[17\] net762 net756 VSS VSS VDD VDD _2626_ sky130_fd_sc_hd__mux4_2
X_6674_ _2623_ _2624_ _2625_ _2626_ net753 net752 VSS VSS
+ VDD VDD _2627_ sky130_fd_sc_hd__mux4_2
X_6675_ cpuregs\[16\]\[17\] cpuregs\[17\]\[17\] cpuregs\[18\]\[17\]
+ cpuregs\[19\]\[17\] net762 net756 VSS VSS VDD VDD _2628_ sky130_fd_sc_hd__mux4_2
X_6676_ cpuregs\[20\]\[17\] cpuregs\[21\]\[17\] cpuregs\[22\]\[17\]
+ cpuregs\[23\]\[17\] net762 net756 VSS VSS VDD VDD _2629_ sky130_fd_sc_hd__mux4_2
X_6677_ cpuregs\[24\]\[17\] cpuregs\[25\]\[17\] cpuregs\[26\]\[17\]
+ cpuregs\[27\]\[17\] _0046_ net757 VSS VSS VDD VDD _2630_ sky130_fd_sc_hd__mux4_2
X_6678_ cpuregs\[28\]\[17\] cpuregs\[29\]\[17\] cpuregs\[30\]\[17\]
+ cpuregs\[31\]\[17\] _0046_ net757 VSS VSS VDD VDD _2631_ sky130_fd_sc_hd__mux4_2
X_6679_ _2628_ _2629_ _2630_ _2631_ net753 net752 VSS VSS
+ VDD VDD _2632_ sky130_fd_sc_hd__mux4_2
X_6680_ _2627_ _2632_ _0050_ VSS VSS VDD VDD _2633_ sky130_fd_sc_hd__mux2i_1
X_6681_ decoded_imm\[17\] net687 VSS VSS VDD VDD _2634_ sky130_fd_sc_hd__nand2_1
X_6682_ net668 _2633_ _2634_ VSS VSS VDD VDD _4572_ sky130_fd_sc_hd__o21ai_0
X_6683_ cpuregs\[0\]\[16\] cpuregs\[1\]\[16\] cpuregs\[2\]\[16\]
+ cpuregs\[3\]\[16\] net761 net756 VSS VSS VDD VDD _2635_ sky130_fd_sc_hd__mux4_2
X_6684_ cpuregs\[4\]\[16\] cpuregs\[5\]\[16\] cpuregs\[6\]\[16\]
+ cpuregs\[7\]\[16\] net761 net756 VSS VSS VDD VDD _2636_ sky130_fd_sc_hd__mux4_2
X_6685_ cpuregs\[8\]\[16\] cpuregs\[9\]\[16\] cpuregs\[10\]\[16\]
+ cpuregs\[11\]\[16\] net761 net756 VSS VSS VDD VDD _2637_ sky130_fd_sc_hd__mux4_2
X_6686_ cpuregs\[12\]\[16\] cpuregs\[13\]\[16\] cpuregs\[14\]\[16\]
+ cpuregs\[15\]\[16\] net761 net756 VSS VSS VDD VDD _2638_ sky130_fd_sc_hd__mux4_2
X_6687_ _2635_ _2636_ _2637_ _2638_ net754 net752 VSS VSS
+ VDD VDD _2639_ sky130_fd_sc_hd__mux4_2
X_6688_ cpuregs\[16\]\[16\] cpuregs\[17\]\[16\] cpuregs\[18\]\[16\]
+ cpuregs\[19\]\[16\] net761 net756 VSS VSS VDD VDD _2640_ sky130_fd_sc_hd__mux4_2
X_6689_ cpuregs\[20\]\[16\] cpuregs\[21\]\[16\] cpuregs\[22\]\[16\]
+ cpuregs\[23\]\[16\] net761 net756 VSS VSS VDD VDD _2641_ sky130_fd_sc_hd__mux4_2
X_6690_ cpuregs\[24\]\[16\] cpuregs\[25\]\[16\] cpuregs\[26\]\[16\]
+ cpuregs\[27\]\[16\] net761 net756 VSS VSS VDD VDD _2642_ sky130_fd_sc_hd__mux4_2
X_6691_ cpuregs\[28\]\[16\] cpuregs\[29\]\[16\] cpuregs\[30\]\[16\]
+ cpuregs\[31\]\[16\] net761 net756 VSS VSS VDD VDD _2643_ sky130_fd_sc_hd__mux4_2
X_6692_ _2640_ _2641_ _2642_ _2643_ net754 net752 VSS VSS
+ VDD VDD _2644_ sky130_fd_sc_hd__mux4_2
X_6693_ _2639_ _2644_ net751 VSS VSS VDD VDD _2645_ sky130_fd_sc_hd__mux2i_1
X_6694_ decoded_imm\[16\] net687 VSS VSS VDD VDD _2646_ sky130_fd_sc_hd__nand2_1
X_6695_ net668 _2645_ _2646_ VSS VSS VDD VDD _4571_ sky130_fd_sc_hd__o21ai_0
X_6696_ cpuregs\[0\]\[15\] cpuregs\[1\]\[15\] cpuregs\[2\]\[15\]
+ cpuregs\[3\]\[15\] net762 net756 VSS VSS VDD VDD _2647_ sky130_fd_sc_hd__mux4_2
X_6697_ cpuregs\[4\]\[15\] cpuregs\[5\]\[15\] cpuregs\[6\]\[15\]
+ cpuregs\[7\]\[15\] net762 net756 VSS VSS VDD VDD _2648_ sky130_fd_sc_hd__mux4_2
X_6698_ cpuregs\[8\]\[15\] cpuregs\[9\]\[15\] cpuregs\[10\]\[15\]
+ cpuregs\[11\]\[15\] net762 net756 VSS VSS VDD VDD _2649_ sky130_fd_sc_hd__mux4_2
X_6699_ cpuregs\[12\]\[15\] cpuregs\[13\]\[15\] cpuregs\[14\]\[15\]
+ cpuregs\[15\]\[15\] net762 net756 VSS VSS VDD VDD _2650_ sky130_fd_sc_hd__mux4_2
X_6700_ _2647_ _2648_ _2649_ _2650_ net753 net752 VSS VSS
+ VDD VDD _2651_ sky130_fd_sc_hd__mux4_2
X_6701_ cpuregs\[16\]\[15\] cpuregs\[17\]\[15\] cpuregs\[18\]\[15\]
+ cpuregs\[19\]\[15\] net761 net755 VSS VSS VDD VDD _2652_ sky130_fd_sc_hd__mux4_2
X_6702_ cpuregs\[20\]\[15\] cpuregs\[21\]\[15\] cpuregs\[22\]\[15\]
+ cpuregs\[23\]\[15\] net761 net756 VSS VSS VDD VDD _2653_ sky130_fd_sc_hd__mux4_2
X_6703_ cpuregs\[24\]\[15\] cpuregs\[25\]\[15\] cpuregs\[26\]\[15\]
+ cpuregs\[27\]\[15\] net761 net756 VSS VSS VDD VDD _2654_ sky130_fd_sc_hd__mux4_2
X_6704_ cpuregs\[28\]\[15\] cpuregs\[29\]\[15\] cpuregs\[30\]\[15\]
+ cpuregs\[31\]\[15\] net762 net756 VSS VSS VDD VDD _2655_ sky130_fd_sc_hd__mux4_2
X_6705_ _2652_ _2653_ _2654_ _2655_ net753 net752 VSS VSS
+ VDD VDD _2656_ sky130_fd_sc_hd__mux4_2
X_6706_ _2651_ _2656_ _0050_ VSS VSS VDD VDD _2657_ sky130_fd_sc_hd__mux2i_1
X_6707_ decoded_imm\[15\] net687 VSS VSS VDD VDD _2658_ sky130_fd_sc_hd__nand2_1
X_6708_ net668 _2657_ _2658_ VSS VSS VDD VDD _4570_ sky130_fd_sc_hd__o21ai_0
X_6709_ cpuregs\[0\]\[14\] cpuregs\[1\]\[14\] cpuregs\[2\]\[14\]
+ cpuregs\[3\]\[14\] net761 net756 VSS VSS VDD VDD _2659_ sky130_fd_sc_hd__mux4_2
X_6710_ cpuregs\[4\]\[14\] cpuregs\[5\]\[14\] cpuregs\[6\]\[14\]
+ cpuregs\[7\]\[14\] net761 net756 VSS VSS VDD VDD _2660_ sky130_fd_sc_hd__mux4_2
X_6711_ cpuregs\[8\]\[14\] cpuregs\[9\]\[14\] cpuregs\[10\]\[14\]
+ cpuregs\[11\]\[14\] net761 net756 VSS VSS VDD VDD _2661_ sky130_fd_sc_hd__mux4_2
X_6712_ cpuregs\[12\]\[14\] cpuregs\[13\]\[14\] cpuregs\[14\]\[14\]
+ cpuregs\[15\]\[14\] net761 net756 VSS VSS VDD VDD _2662_ sky130_fd_sc_hd__mux4_2
X_6713_ _2659_ _2660_ _2661_ _2662_ net754 net752 VSS VSS
+ VDD VDD _2663_ sky130_fd_sc_hd__mux4_2
X_6714_ cpuregs\[16\]\[14\] cpuregs\[17\]\[14\] cpuregs\[18\]\[14\]
+ cpuregs\[19\]\[14\] net761 net756 VSS VSS VDD VDD _2664_ sky130_fd_sc_hd__mux4_2
X_6715_ cpuregs\[20\]\[14\] cpuregs\[21\]\[14\] cpuregs\[22\]\[14\]
+ cpuregs\[23\]\[14\] net759 net757 VSS VSS VDD VDD _2665_ sky130_fd_sc_hd__mux4_2
X_6716_ cpuregs\[24\]\[14\] cpuregs\[25\]\[14\] cpuregs\[26\]\[14\]
+ cpuregs\[27\]\[14\] net759 net757 VSS VSS VDD VDD _2666_ sky130_fd_sc_hd__mux4_2
X_6717_ cpuregs\[28\]\[14\] cpuregs\[29\]\[14\] cpuregs\[30\]\[14\]
+ cpuregs\[31\]\[14\] net758 net757 VSS VSS VDD VDD _2667_ sky130_fd_sc_hd__mux4_2
X_6718_ _2664_ _2665_ _2666_ _2667_ net754 net752 VSS VSS
+ VDD VDD _2668_ sky130_fd_sc_hd__mux4_2
X_6719_ _2663_ _2668_ net751 VSS VSS VDD VDD _2669_ sky130_fd_sc_hd__mux2i_1
X_6720_ decoded_imm\[14\] net687 VSS VSS VDD VDD _2670_ sky130_fd_sc_hd__nand2_1
X_6721_ net668 _2669_ _2670_ VSS VSS VDD VDD _4569_ sky130_fd_sc_hd__o21ai_0
X_6722_ cpuregs\[0\]\[13\] cpuregs\[1\]\[13\] cpuregs\[2\]\[13\]
+ cpuregs\[3\]\[13\] net759 net757 VSS VSS VDD VDD _2671_ sky130_fd_sc_hd__mux4_2
X_6723_ cpuregs\[4\]\[13\] cpuregs\[5\]\[13\] cpuregs\[6\]\[13\]
+ cpuregs\[7\]\[13\] net759 net757 VSS VSS VDD VDD _2672_ sky130_fd_sc_hd__mux4_2
X_6724_ cpuregs\[8\]\[13\] cpuregs\[9\]\[13\] cpuregs\[10\]\[13\]
+ cpuregs\[11\]\[13\] net759 net757 VSS VSS VDD VDD _2673_ sky130_fd_sc_hd__mux4_2
X_6725_ cpuregs\[12\]\[13\] cpuregs\[13\]\[13\] cpuregs\[14\]\[13\]
+ cpuregs\[15\]\[13\] net758 net757 VSS VSS VDD VDD _2674_ sky130_fd_sc_hd__mux4_2
X_6726_ _2671_ _2672_ _2673_ _2674_ _0048_ _0049_ VSS VSS
+ VDD VDD _2675_ sky130_fd_sc_hd__mux4_2
X_6727_ cpuregs\[16\]\[13\] cpuregs\[17\]\[13\] cpuregs\[18\]\[13\]
+ cpuregs\[19\]\[13\] net758 net757 VSS VSS VDD VDD _2676_ sky130_fd_sc_hd__mux4_2
X_6728_ cpuregs\[20\]\[13\] cpuregs\[21\]\[13\] cpuregs\[22\]\[13\]
+ cpuregs\[23\]\[13\] net758 net757 VSS VSS VDD VDD _2677_ sky130_fd_sc_hd__mux4_2
X_6729_ cpuregs\[24\]\[13\] cpuregs\[25\]\[13\] cpuregs\[26\]\[13\]
+ cpuregs\[27\]\[13\] net758 net757 VSS VSS VDD VDD _2678_ sky130_fd_sc_hd__mux4_2
X_6730_ cpuregs\[28\]\[13\] cpuregs\[29\]\[13\] cpuregs\[30\]\[13\]
+ cpuregs\[31\]\[13\] net758 net757 VSS VSS VDD VDD _2679_ sky130_fd_sc_hd__mux4_2
X_6731_ _2676_ _2677_ _2678_ _2679_ _0048_ _0049_ VSS VSS
+ VDD VDD _2680_ sky130_fd_sc_hd__mux4_2
X_6732_ _2675_ _2680_ net751 VSS VSS VDD VDD _2681_ sky130_fd_sc_hd__mux2i_1
X_6733_ decoded_imm\[13\] net687 VSS VSS VDD VDD _2682_ sky130_fd_sc_hd__nand2_1
X_6734_ net668 _2681_ _2682_ VSS VSS VDD VDD _4568_ sky130_fd_sc_hd__o21ai_0
X_6735_ cpuregs\[0\]\[12\] cpuregs\[1\]\[12\] cpuregs\[2\]\[12\]
+ cpuregs\[3\]\[12\] _0046_ _0047_ VSS VSS VDD VDD _2683_ sky130_fd_sc_hd__mux4_2
X_6736_ cpuregs\[4\]\[12\] cpuregs\[5\]\[12\] cpuregs\[6\]\[12\]
+ cpuregs\[7\]\[12\] _0046_ _0047_ VSS VSS VDD VDD _2684_ sky130_fd_sc_hd__mux4_2
X_6737_ cpuregs\[8\]\[12\] cpuregs\[9\]\[12\] cpuregs\[10\]\[12\]
+ cpuregs\[11\]\[12\] net760 net757 VSS VSS VDD VDD _2685_ sky130_fd_sc_hd__mux4_2
X_6738_ cpuregs\[12\]\[12\] cpuregs\[13\]\[12\] cpuregs\[14\]\[12\]
+ cpuregs\[15\]\[12\] _0046_ _0047_ VSS VSS VDD VDD _2686_ sky130_fd_sc_hd__mux4_2
X_6739_ _2683_ _2684_ _2685_ _2686_ _0048_ _0049_ VSS VSS
+ VDD VDD _2687_ sky130_fd_sc_hd__mux4_2
X_6740_ cpuregs\[16\]\[12\] cpuregs\[17\]\[12\] cpuregs\[18\]\[12\]
+ cpuregs\[19\]\[12\] net758 net757 VSS VSS VDD VDD _2688_ sky130_fd_sc_hd__mux4_2
X_6741_ cpuregs\[20\]\[12\] cpuregs\[21\]\[12\] cpuregs\[22\]\[12\]
+ cpuregs\[23\]\[12\] net758 net757 VSS VSS VDD VDD _2689_ sky130_fd_sc_hd__mux4_2
X_6742_ cpuregs\[24\]\[12\] cpuregs\[25\]\[12\] cpuregs\[26\]\[12\]
+ cpuregs\[27\]\[12\] net758 net757 VSS VSS VDD VDD _2690_ sky130_fd_sc_hd__mux4_2
X_6743_ cpuregs\[28\]\[12\] cpuregs\[29\]\[12\] cpuregs\[30\]\[12\]
+ cpuregs\[31\]\[12\] net758 net757 VSS VSS VDD VDD _2691_ sky130_fd_sc_hd__mux4_2
X_6744_ _2688_ _2689_ _2690_ _2691_ _0048_ _0049_ VSS VSS
+ VDD VDD _2692_ sky130_fd_sc_hd__mux4_2
X_6745_ _2687_ _2692_ net751 VSS VSS VDD VDD _2693_ sky130_fd_sc_hd__mux2i_1
X_6746_ decoded_imm\[12\] net687 VSS VSS VDD VDD _2694_ sky130_fd_sc_hd__nand2_1
X_6747_ net668 _2693_ _2694_ VSS VSS VDD VDD _4567_ sky130_fd_sc_hd__o21ai_0
X_6748_ cpuregs\[0\]\[11\] cpuregs\[1\]\[11\] cpuregs\[2\]\[11\]
+ cpuregs\[3\]\[11\] net759 net757 VSS VSS VDD VDD _2695_ sky130_fd_sc_hd__mux4_2
X_6749_ cpuregs\[4\]\[11\] cpuregs\[5\]\[11\] cpuregs\[6\]\[11\]
+ cpuregs\[7\]\[11\] net759 net757 VSS VSS VDD VDD _2696_ sky130_fd_sc_hd__mux4_2
X_6750_ cpuregs\[8\]\[11\] cpuregs\[9\]\[11\] cpuregs\[10\]\[11\]
+ cpuregs\[11\]\[11\] net759 net757 VSS VSS VDD VDD _2697_ sky130_fd_sc_hd__mux4_2
X_6751_ cpuregs\[12\]\[11\] cpuregs\[13\]\[11\] cpuregs\[14\]\[11\]
+ cpuregs\[15\]\[11\] net759 net757 VSS VSS VDD VDD _2698_ sky130_fd_sc_hd__mux4_2
X_6752_ _2695_ _2696_ _2697_ _2698_ _0048_ _0049_ VSS VSS
+ VDD VDD _2699_ sky130_fd_sc_hd__mux4_2
X_6753_ cpuregs\[16\]\[11\] cpuregs\[17\]\[11\] cpuregs\[18\]\[11\]
+ cpuregs\[19\]\[11\] net759 net757 VSS VSS VDD VDD _2700_ sky130_fd_sc_hd__mux4_2
X_6754_ cpuregs\[20\]\[11\] cpuregs\[21\]\[11\] cpuregs\[22\]\[11\]
+ cpuregs\[23\]\[11\] net758 net757 VSS VSS VDD VDD _2701_ sky130_fd_sc_hd__mux4_2
X_6755_ cpuregs\[24\]\[11\] cpuregs\[25\]\[11\] cpuregs\[26\]\[11\]
+ cpuregs\[27\]\[11\] net758 net757 VSS VSS VDD VDD _2702_ sky130_fd_sc_hd__mux4_2
X_6756_ cpuregs\[28\]\[11\] cpuregs\[29\]\[11\] cpuregs\[30\]\[11\]
+ cpuregs\[31\]\[11\] net758 net757 VSS VSS VDD VDD _2703_ sky130_fd_sc_hd__mux4_2
X_6757_ _2700_ _2701_ _2702_ _2703_ _0048_ _0049_ VSS VSS
+ VDD VDD _2704_ sky130_fd_sc_hd__mux4_2
X_6758_ _2699_ _2704_ net751 VSS VSS VDD VDD _2705_ sky130_fd_sc_hd__mux2i_1
X_6759_ decoded_imm\[11\] net687 VSS VSS VDD VDD _2706_ sky130_fd_sc_hd__nand2_1
X_6760_ net668 _2705_ _2706_ VSS VSS VDD VDD _4566_ sky130_fd_sc_hd__o21ai_0
X_6761_ cpuregs\[0\]\[10\] cpuregs\[1\]\[10\] cpuregs\[2\]\[10\]
+ cpuregs\[3\]\[10\] net760 net757 VSS VSS VDD VDD _2707_ sky130_fd_sc_hd__mux4_2
X_6762_ cpuregs\[4\]\[10\] cpuregs\[5\]\[10\] cpuregs\[6\]\[10\]
+ cpuregs\[7\]\[10\] net760 net757 VSS VSS VDD VDD _2708_ sky130_fd_sc_hd__mux4_2
X_6763_ cpuregs\[8\]\[10\] cpuregs\[9\]\[10\] cpuregs\[10\]\[10\]
+ cpuregs\[11\]\[10\] net760 net757 VSS VSS VDD VDD _2709_ sky130_fd_sc_hd__mux4_2
X_6764_ cpuregs\[12\]\[10\] cpuregs\[13\]\[10\] cpuregs\[14\]\[10\]
+ cpuregs\[15\]\[10\] net760 net757 VSS VSS VDD VDD _2710_ sky130_fd_sc_hd__mux4_2
X_6765_ _2707_ _2708_ _2709_ _2710_ net754 _0049_ VSS VSS
+ VDD VDD _2711_ sky130_fd_sc_hd__mux4_2
X_6766_ cpuregs\[16\]\[10\] cpuregs\[17\]\[10\] cpuregs\[18\]\[10\]
+ cpuregs\[19\]\[10\] net759 net757 VSS VSS VDD VDD _2712_ sky130_fd_sc_hd__mux4_2
X_6767_ cpuregs\[20\]\[10\] cpuregs\[21\]\[10\] cpuregs\[22\]\[10\]
+ cpuregs\[23\]\[10\] net758 net757 VSS VSS VDD VDD _2713_ sky130_fd_sc_hd__mux4_2
X_6768_ cpuregs\[24\]\[10\] cpuregs\[25\]\[10\] cpuregs\[26\]\[10\]
+ cpuregs\[27\]\[10\] net758 net757 VSS VSS VDD VDD _2714_ sky130_fd_sc_hd__mux4_2
X_6769_ cpuregs\[28\]\[10\] cpuregs\[29\]\[10\] cpuregs\[30\]\[10\]
+ cpuregs\[31\]\[10\] net758 net757 VSS VSS VDD VDD _2715_ sky130_fd_sc_hd__mux4_2
X_6770_ _2712_ _2713_ _2714_ _2715_ net754 _0049_ VSS VSS
+ VDD VDD _2716_ sky130_fd_sc_hd__mux4_2
X_6771_ _2711_ _2716_ net751 VSS VSS VDD VDD _2717_ sky130_fd_sc_hd__mux2i_1
Xplace737 net312 VSS VSS VDD VDD net728 sky130_fd_sc_hd__buf_4
X_6773_ decoded_imm\[10\] net687 VSS VSS VDD VDD _2719_ sky130_fd_sc_hd__nand2_1
X_6774_ net668 _2717_ _2719_ VSS VSS VDD VDD _4565_ sky130_fd_sc_hd__o21ai_0
X_6775_ cpuregs\[0\]\[9\] cpuregs\[1\]\[9\] cpuregs\[2\]\[9\]
+ cpuregs\[3\]\[9\] net758 net757 VSS VSS VDD VDD _2720_ sky130_fd_sc_hd__mux4_2
X_6776_ cpuregs\[4\]\[9\] cpuregs\[5\]\[9\] cpuregs\[6\]\[9\]
+ cpuregs\[7\]\[9\] net758 net757 VSS VSS VDD VDD _2721_ sky130_fd_sc_hd__mux4_2
X_6777_ cpuregs\[8\]\[9\] cpuregs\[9\]\[9\] cpuregs\[10\]\[9\]
+ cpuregs\[11\]\[9\] net758 net757 VSS VSS VDD VDD _2722_ sky130_fd_sc_hd__mux4_2
X_6778_ cpuregs\[12\]\[9\] cpuregs\[13\]\[9\] cpuregs\[14\]\[9\]
+ cpuregs\[15\]\[9\] net758 net757 VSS VSS VDD VDD _2723_ sky130_fd_sc_hd__mux4_2
X_6779_ _2720_ _2721_ _2722_ _2723_ _0048_ _0049_ VSS VSS
+ VDD VDD _2724_ sky130_fd_sc_hd__mux4_2
X_6780_ cpuregs\[16\]\[9\] cpuregs\[17\]\[9\] cpuregs\[18\]\[9\]
+ cpuregs\[19\]\[9\] net758 net757 VSS VSS VDD VDD _2725_ sky130_fd_sc_hd__mux4_2
X_6781_ cpuregs\[20\]\[9\] cpuregs\[21\]\[9\] cpuregs\[22\]\[9\]
+ cpuregs\[23\]\[9\] net758 net757 VSS VSS VDD VDD _2726_ sky130_fd_sc_hd__mux4_2
X_6782_ cpuregs\[24\]\[9\] cpuregs\[25\]\[9\] cpuregs\[26\]\[9\]
+ cpuregs\[27\]\[9\] net758 net757 VSS VSS VDD VDD _2727_ sky130_fd_sc_hd__mux4_2
X_6783_ cpuregs\[28\]\[9\] cpuregs\[29\]\[9\] cpuregs\[30\]\[9\]
+ cpuregs\[31\]\[9\] net758 net757 VSS VSS VDD VDD _2728_ sky130_fd_sc_hd__mux4_2
X_6784_ _2725_ _2726_ _2727_ _2728_ _0048_ _0049_ VSS VSS
+ VDD VDD _2729_ sky130_fd_sc_hd__mux4_2
X_6785_ _2724_ _2729_ net751 VSS VSS VDD VDD _2730_ sky130_fd_sc_hd__mux2i_1
X_6786_ decoded_imm\[9\] net687 VSS VSS VDD VDD _2731_ sky130_fd_sc_hd__nand2_1
X_6787_ net668 _2730_ _2731_ VSS VSS VDD VDD _4595_ sky130_fd_sc_hd__o21ai_0
X_6788_ cpuregs\[0\]\[8\] cpuregs\[1\]\[8\] cpuregs\[2\]\[8\]
+ cpuregs\[3\]\[8\] net760 net757 VSS VSS VDD VDD _2732_ sky130_fd_sc_hd__mux4_2
X_6789_ cpuregs\[4\]\[8\] cpuregs\[5\]\[8\] cpuregs\[6\]\[8\]
+ cpuregs\[7\]\[8\] net760 net757 VSS VSS VDD VDD _2733_ sky130_fd_sc_hd__mux4_2
X_6790_ cpuregs\[8\]\[8\] cpuregs\[9\]\[8\] cpuregs\[10\]\[8\]
+ cpuregs\[11\]\[8\] net760 net757 VSS VSS VDD VDD _2734_ sky130_fd_sc_hd__mux4_2
X_6791_ cpuregs\[12\]\[8\] cpuregs\[13\]\[8\] cpuregs\[14\]\[8\]
+ cpuregs\[15\]\[8\] net760 net757 VSS VSS VDD VDD _2735_ sky130_fd_sc_hd__mux4_2
X_6792_ _2732_ _2733_ _2734_ _2735_ net754 net752 VSS VSS
+ VDD VDD _2736_ sky130_fd_sc_hd__mux4_2
X_6793_ cpuregs\[16\]\[8\] cpuregs\[17\]\[8\] cpuregs\[18\]\[8\]
+ cpuregs\[19\]\[8\] net759 net757 VSS VSS VDD VDD _2737_ sky130_fd_sc_hd__mux4_2
X_6794_ cpuregs\[20\]\[8\] cpuregs\[21\]\[8\] cpuregs\[22\]\[8\]
+ cpuregs\[23\]\[8\] net759 net757 VSS VSS VDD VDD _2738_ sky130_fd_sc_hd__mux4_2
X_6795_ cpuregs\[24\]\[8\] cpuregs\[25\]\[8\] cpuregs\[26\]\[8\]
+ cpuregs\[27\]\[8\] net759 net757 VSS VSS VDD VDD _2739_ sky130_fd_sc_hd__mux4_2
X_6796_ cpuregs\[28\]\[8\] cpuregs\[29\]\[8\] cpuregs\[30\]\[8\]
+ cpuregs\[31\]\[8\] net759 net757 VSS VSS VDD VDD _2740_ sky130_fd_sc_hd__mux4_2
X_6797_ _2737_ _2738_ _2739_ _2740_ net754 net752 VSS VSS
+ VDD VDD _2741_ sky130_fd_sc_hd__mux4_2
X_6798_ _2736_ _2741_ net751 VSS VSS VDD VDD _2742_ sky130_fd_sc_hd__mux2i_1
X_6799_ decoded_imm\[8\] net687 VSS VSS VDD VDD _2743_ sky130_fd_sc_hd__nand2_1
X_6800_ net668 _2742_ _2743_ VSS VSS VDD VDD _4594_ sky130_fd_sc_hd__o21ai_0
X_6801_ cpuregs\[0\]\[7\] cpuregs\[1\]\[7\] cpuregs\[2\]\[7\]
+ cpuregs\[3\]\[7\] net761 net756 VSS VSS VDD VDD _2744_ sky130_fd_sc_hd__mux4_2
X_6802_ cpuregs\[4\]\[7\] cpuregs\[5\]\[7\] cpuregs\[6\]\[7\]
+ cpuregs\[7\]\[7\] net761 net756 VSS VSS VDD VDD _2745_ sky130_fd_sc_hd__mux4_2
X_6803_ cpuregs\[8\]\[7\] cpuregs\[9\]\[7\] cpuregs\[10\]\[7\]
+ cpuregs\[11\]\[7\] net761 net756 VSS VSS VDD VDD _2746_ sky130_fd_sc_hd__mux4_2
X_6804_ cpuregs\[12\]\[7\] cpuregs\[13\]\[7\] cpuregs\[14\]\[7\]
+ cpuregs\[15\]\[7\] net761 net756 VSS VSS VDD VDD _2747_ sky130_fd_sc_hd__mux4_2
X_6805_ _2744_ _2745_ _2746_ _2747_ net754 net752 VSS VSS
+ VDD VDD _2748_ sky130_fd_sc_hd__mux4_2
X_6806_ cpuregs\[16\]\[7\] cpuregs\[17\]\[7\] cpuregs\[18\]\[7\]
+ cpuregs\[19\]\[7\] net758 net757 VSS VSS VDD VDD _2749_ sky130_fd_sc_hd__mux4_2
X_6807_ cpuregs\[20\]\[7\] cpuregs\[21\]\[7\] cpuregs\[22\]\[7\]
+ cpuregs\[23\]\[7\] net758 net757 VSS VSS VDD VDD _2750_ sky130_fd_sc_hd__mux4_2
X_6808_ cpuregs\[24\]\[7\] cpuregs\[25\]\[7\] cpuregs\[26\]\[7\]
+ cpuregs\[27\]\[7\] net758 net757 VSS VSS VDD VDD _2751_ sky130_fd_sc_hd__mux4_2
X_6809_ cpuregs\[28\]\[7\] cpuregs\[29\]\[7\] cpuregs\[30\]\[7\]
+ cpuregs\[31\]\[7\] net758 net757 VSS VSS VDD VDD _2752_ sky130_fd_sc_hd__mux4_2
X_6810_ _2749_ _2750_ _2751_ _2752_ net754 net752 VSS VSS
+ VDD VDD _2753_ sky130_fd_sc_hd__mux4_2
X_6811_ _2748_ _2753_ _0050_ VSS VSS VDD VDD _2754_ sky130_fd_sc_hd__mux2i_1
X_6812_ decoded_imm\[7\] net687 VSS VSS VDD VDD _2755_ sky130_fd_sc_hd__nand2_1
X_6813_ net668 _2754_ _2755_ VSS VSS VDD VDD _4593_ sky130_fd_sc_hd__o21ai_0
X_6814_ cpuregs\[0\]\[6\] cpuregs\[1\]\[6\] cpuregs\[2\]\[6\]
+ cpuregs\[3\]\[6\] net761 net756 VSS VSS VDD VDD _2756_ sky130_fd_sc_hd__mux4_2
X_6815_ cpuregs\[4\]\[6\] cpuregs\[5\]\[6\] cpuregs\[6\]\[6\]
+ cpuregs\[7\]\[6\] net761 net755 VSS VSS VDD VDD _2757_ sky130_fd_sc_hd__mux4_2
X_6816_ cpuregs\[8\]\[6\] cpuregs\[9\]\[6\] cpuregs\[10\]\[6\]
+ cpuregs\[11\]\[6\] net761 net756 VSS VSS VDD VDD _2758_ sky130_fd_sc_hd__mux4_2
X_6817_ cpuregs\[12\]\[6\] cpuregs\[13\]\[6\] cpuregs\[14\]\[6\]
+ cpuregs\[15\]\[6\] net761 net756 VSS VSS VDD VDD _2759_ sky130_fd_sc_hd__mux4_2
X_6818_ _2756_ _2757_ _2758_ _2759_ net754 net752 VSS VSS
+ VDD VDD _2760_ sky130_fd_sc_hd__mux4_2
X_6819_ cpuregs\[16\]\[6\] cpuregs\[17\]\[6\] cpuregs\[18\]\[6\]
+ cpuregs\[19\]\[6\] net761 net756 VSS VSS VDD VDD _2761_ sky130_fd_sc_hd__mux4_2
X_6820_ cpuregs\[20\]\[6\] cpuregs\[21\]\[6\] cpuregs\[22\]\[6\]
+ cpuregs\[23\]\[6\] net758 net757 VSS VSS VDD VDD _2762_ sky130_fd_sc_hd__mux4_2
X_6821_ cpuregs\[24\]\[6\] cpuregs\[25\]\[6\] cpuregs\[26\]\[6\]
+ cpuregs\[27\]\[6\] net758 net757 VSS VSS VDD VDD _2763_ sky130_fd_sc_hd__mux4_2
X_6822_ cpuregs\[28\]\[6\] cpuregs\[29\]\[6\] cpuregs\[30\]\[6\]
+ cpuregs\[31\]\[6\] net758 net757 VSS VSS VDD VDD _2764_ sky130_fd_sc_hd__mux4_2
X_6823_ _2761_ _2762_ _2763_ _2764_ net754 net752 VSS VSS
+ VDD VDD _2765_ sky130_fd_sc_hd__mux4_2
X_6824_ _2760_ _2765_ net751 VSS VSS VDD VDD _2766_ sky130_fd_sc_hd__mux2i_1
X_6825_ decoded_imm\[6\] net687 VSS VSS VDD VDD _2767_ sky130_fd_sc_hd__nand2_1
X_6826_ net668 _2766_ _2767_ VSS VSS VDD VDD _4592_ sky130_fd_sc_hd__o21ai_0
X_6827_ cpuregs\[0\]\[5\] cpuregs\[1\]\[5\] cpuregs\[2\]\[5\]
+ cpuregs\[3\]\[5\] net759 net757 VSS VSS VDD VDD _2768_ sky130_fd_sc_hd__mux4_2
X_6828_ cpuregs\[4\]\[5\] cpuregs\[5\]\[5\] cpuregs\[6\]\[5\]
+ cpuregs\[7\]\[5\] net759 net757 VSS VSS VDD VDD _2769_ sky130_fd_sc_hd__mux4_2
X_6829_ cpuregs\[8\]\[5\] cpuregs\[9\]\[5\] cpuregs\[10\]\[5\]
+ cpuregs\[11\]\[5\] net759 net757 VSS VSS VDD VDD _2770_ sky130_fd_sc_hd__mux4_2
X_6830_ cpuregs\[12\]\[5\] cpuregs\[13\]\[5\] cpuregs\[14\]\[5\]
+ cpuregs\[15\]\[5\] net759 net757 VSS VSS VDD VDD _2771_ sky130_fd_sc_hd__mux4_2
X_6831_ _2768_ _2769_ _2770_ _2771_ _0048_ _0049_ VSS VSS
+ VDD VDD _2772_ sky130_fd_sc_hd__mux4_2
X_6832_ cpuregs\[16\]\[5\] cpuregs\[17\]\[5\] cpuregs\[18\]\[5\]
+ cpuregs\[19\]\[5\] net759 net757 VSS VSS VDD VDD _2773_ sky130_fd_sc_hd__mux4_2
X_6833_ cpuregs\[20\]\[5\] cpuregs\[21\]\[5\] cpuregs\[22\]\[5\]
+ cpuregs\[23\]\[5\] net758 net757 VSS VSS VDD VDD _2774_ sky130_fd_sc_hd__mux4_2
X_6834_ cpuregs\[24\]\[5\] cpuregs\[25\]\[5\] cpuregs\[26\]\[5\]
+ cpuregs\[27\]\[5\] net758 net757 VSS VSS VDD VDD _2775_ sky130_fd_sc_hd__mux4_2
X_6835_ cpuregs\[28\]\[5\] cpuregs\[29\]\[5\] cpuregs\[30\]\[5\]
+ cpuregs\[31\]\[5\] net758 net757 VSS VSS VDD VDD _2776_ sky130_fd_sc_hd__mux4_2
X_6836_ _2773_ _2774_ _2775_ _2776_ _0048_ _0049_ VSS VSS
+ VDD VDD _2777_ sky130_fd_sc_hd__mux4_2
X_6837_ _2772_ _2777_ net751 VSS VSS VDD VDD _2778_ sky130_fd_sc_hd__mux2i_1
X_6838_ decoded_imm\[5\] net687 VSS VSS VDD VDD _2779_ sky130_fd_sc_hd__nand2_1
X_6839_ net668 _2778_ _2779_ VSS VSS VDD VDD _4591_ sky130_fd_sc_hd__o21ai_0
Xplace621 _3712_ VSS VSS VDD VDD net612 sky130_fd_sc_hd__buf_4
X_6841_ cpuregs\[0\]\[4\] cpuregs\[1\]\[4\] cpuregs\[2\]\[4\]
+ cpuregs\[3\]\[4\] _0046_ _0047_ VSS VSS VDD VDD _2781_ sky130_fd_sc_hd__mux4_2
X_6842_ cpuregs\[4\]\[4\] cpuregs\[5\]\[4\] cpuregs\[6\]\[4\]
+ cpuregs\[7\]\[4\] _0046_ _0047_ VSS VSS VDD VDD _2782_ sky130_fd_sc_hd__mux4_2
Xplace738 net311 VSS VSS VDD VDD net729 sky130_fd_sc_hd__buf_4
Xplace739 net310 VSS VSS VDD VDD net730 sky130_fd_sc_hd__buf_4
X_6845_ cpuregs\[8\]\[4\] cpuregs\[9\]\[4\] cpuregs\[10\]\[4\]
+ cpuregs\[11\]\[4\] net760 net757 VSS VSS VDD VDD _2785_ sky130_fd_sc_hd__mux4_2
Xplace617 cpuregs_wrdata\[22\] VSS VSS VDD VDD net608 sky130_fd_sc_hd__buf_4
X_6847_ cpuregs\[12\]\[4\] cpuregs\[13\]\[4\] cpuregs\[14\]\[4\]
+ cpuregs\[15\]\[4\] net760 net757 VSS VSS VDD VDD _2787_ sky130_fd_sc_hd__mux4_2
X_6848_ _2781_ _2782_ _2785_ _2787_ _0048_ _0049_ VSS VSS
+ VDD VDD _2788_ sky130_fd_sc_hd__mux4_2
X_6849_ cpuregs\[16\]\[4\] cpuregs\[17\]\[4\] cpuregs\[18\]\[4\]
+ cpuregs\[19\]\[4\] net760 net757 VSS VSS VDD VDD _2789_ sky130_fd_sc_hd__mux4_2
X_6850_ cpuregs\[20\]\[4\] cpuregs\[21\]\[4\] cpuregs\[22\]\[4\]
+ cpuregs\[23\]\[4\] net760 net757 VSS VSS VDD VDD _2790_ sky130_fd_sc_hd__mux4_2
X_6851_ cpuregs\[24\]\[4\] cpuregs\[25\]\[4\] cpuregs\[26\]\[4\]
+ cpuregs\[27\]\[4\] net758 net757 VSS VSS VDD VDD _2791_ sky130_fd_sc_hd__mux4_2
X_6852_ cpuregs\[28\]\[4\] cpuregs\[29\]\[4\] cpuregs\[30\]\[4\]
+ cpuregs\[31\]\[4\] net758 net757 VSS VSS VDD VDD _2792_ sky130_fd_sc_hd__mux4_2
X_6853_ _2789_ _2790_ _2791_ _2792_ net754 _0049_ VSS VSS
+ VDD VDD _2793_ sky130_fd_sc_hd__mux4_2
X_6854_ _2788_ _2793_ net751 VSS VSS VDD VDD _2794_ sky130_fd_sc_hd__mux2_2
X_6855_ _2420_ _2794_ VSS VSS VDD VDD _2795_ sky130_fd_sc_hd__nand2_1
X_6856_ decoded_imm\[4\] net687 VSS VSS VDD VDD _2796_ sky130_fd_sc_hd__nand2_1
X_6857_ net687 _2795_ _2796_ VSS VSS VDD VDD _4590_ sky130_fd_sc_hd__o21ai_0
X_6858_ cpuregs\[0\]\[3\] cpuregs\[1\]\[3\] cpuregs\[2\]\[3\]
+ cpuregs\[3\]\[3\] _0046_ _0047_ VSS VSS VDD VDD _2797_ sky130_fd_sc_hd__mux4_2
X_6859_ cpuregs\[4\]\[3\] cpuregs\[5\]\[3\] cpuregs\[6\]\[3\]
+ cpuregs\[7\]\[3\] _0046_ _0047_ VSS VSS VDD VDD _2798_ sky130_fd_sc_hd__mux4_2
X_6860_ cpuregs\[8\]\[3\] cpuregs\[9\]\[3\] cpuregs\[10\]\[3\]
+ cpuregs\[11\]\[3\] net760 net757 VSS VSS VDD VDD _2799_ sky130_fd_sc_hd__mux4_2
X_6861_ cpuregs\[12\]\[3\] cpuregs\[13\]\[3\] cpuregs\[14\]\[3\]
+ cpuregs\[15\]\[3\] net760 net757 VSS VSS VDD VDD _2800_ sky130_fd_sc_hd__mux4_2
X_6862_ _2797_ _2798_ _2799_ _2800_ _0048_ _0049_ VSS VSS
+ VDD VDD _2801_ sky130_fd_sc_hd__mux4_2
X_6863_ cpuregs\[16\]\[3\] cpuregs\[17\]\[3\] cpuregs\[18\]\[3\]
+ cpuregs\[19\]\[3\] net758 net757 VSS VSS VDD VDD _2802_ sky130_fd_sc_hd__mux4_2
X_6864_ cpuregs\[20\]\[3\] cpuregs\[21\]\[3\] cpuregs\[22\]\[3\]
+ cpuregs\[23\]\[3\] net758 net757 VSS VSS VDD VDD _2803_ sky130_fd_sc_hd__mux4_2
X_6865_ cpuregs\[24\]\[3\] cpuregs\[25\]\[3\] cpuregs\[26\]\[3\]
+ cpuregs\[27\]\[3\] net758 net757 VSS VSS VDD VDD _2804_ sky130_fd_sc_hd__mux4_2
X_6866_ cpuregs\[28\]\[3\] cpuregs\[29\]\[3\] cpuregs\[30\]\[3\]
+ cpuregs\[31\]\[3\] net758 net757 VSS VSS VDD VDD _2805_ sky130_fd_sc_hd__mux4_2
X_6867_ _2802_ _2803_ _2804_ _2805_ _0048_ _0049_ VSS VSS
+ VDD VDD _2806_ sky130_fd_sc_hd__mux4_2
X_6868_ _2801_ _2806_ net751 VSS VSS VDD VDD _2807_ sky130_fd_sc_hd__mux2_2
X_6869_ _2420_ _2807_ VSS VSS VDD VDD _2808_ sky130_fd_sc_hd__nand2_1
X_6870_ decoded_imm\[3\] net687 VSS VSS VDD VDD _2809_ sky130_fd_sc_hd__nand2_1
X_6871_ net687 _2808_ _2809_ VSS VSS VDD VDD _4589_ sky130_fd_sc_hd__o21ai_0
X_6872_ cpuregs\[0\]\[2\] cpuregs\[1\]\[2\] cpuregs\[2\]\[2\]
+ cpuregs\[3\]\[2\] net760 net757 VSS VSS VDD VDD _2810_ sky130_fd_sc_hd__mux4_2
X_6873_ cpuregs\[4\]\[2\] cpuregs\[5\]\[2\] cpuregs\[6\]\[2\]
+ cpuregs\[7\]\[2\] net760 net757 VSS VSS VDD VDD _2811_ sky130_fd_sc_hd__mux4_2
X_6874_ cpuregs\[8\]\[2\] cpuregs\[9\]\[2\] cpuregs\[10\]\[2\]
+ cpuregs\[11\]\[2\] net760 net757 VSS VSS VDD VDD _2812_ sky130_fd_sc_hd__mux4_2
X_6875_ cpuregs\[12\]\[2\] cpuregs\[13\]\[2\] cpuregs\[14\]\[2\]
+ cpuregs\[15\]\[2\] net760 net757 VSS VSS VDD VDD _2813_ sky130_fd_sc_hd__mux4_2
X_6876_ _2810_ _2811_ _2812_ _2813_ _0048_ _0049_ VSS VSS
+ VDD VDD _2814_ sky130_fd_sc_hd__mux4_2
X_6877_ cpuregs\[16\]\[2\] cpuregs\[17\]\[2\] cpuregs\[18\]\[2\]
+ cpuregs\[19\]\[2\] net758 net757 VSS VSS VDD VDD _2815_ sky130_fd_sc_hd__mux4_2
X_6878_ cpuregs\[20\]\[2\] cpuregs\[21\]\[2\] cpuregs\[22\]\[2\]
+ cpuregs\[23\]\[2\] net760 net757 VSS VSS VDD VDD _2816_ sky130_fd_sc_hd__mux4_2
X_6879_ cpuregs\[24\]\[2\] cpuregs\[25\]\[2\] cpuregs\[26\]\[2\]
+ cpuregs\[27\]\[2\] net758 net757 VSS VSS VDD VDD _2817_ sky130_fd_sc_hd__mux4_2
X_6880_ cpuregs\[28\]\[2\] cpuregs\[29\]\[2\] cpuregs\[30\]\[2\]
+ cpuregs\[31\]\[2\] net758 net757 VSS VSS VDD VDD _2818_ sky130_fd_sc_hd__mux4_2
X_6881_ _2815_ _2816_ _2817_ _2818_ _0048_ _0049_ VSS VSS
+ VDD VDD _2819_ sky130_fd_sc_hd__mux4_2
X_6882_ _2814_ _2819_ net751 VSS VSS VDD VDD _2820_ sky130_fd_sc_hd__mux2_2
X_6883_ _2420_ _2820_ VSS VSS VDD VDD _2821_ sky130_fd_sc_hd__nand2_1
X_6884_ decoded_imm\[2\] net687 VSS VSS VDD VDD _2822_ sky130_fd_sc_hd__nand2_1
X_6885_ net687 _2821_ _2822_ VSS VSS VDD VDD _4586_ sky130_fd_sc_hd__o21ai_0
X_6886_ cpuregs\[0\]\[1\] cpuregs\[1\]\[1\] cpuregs\[2\]\[1\]
+ cpuregs\[3\]\[1\] _0046_ _0047_ VSS VSS VDD VDD _2823_ sky130_fd_sc_hd__mux4_2
X_6887_ cpuregs\[4\]\[1\] cpuregs\[5\]\[1\] cpuregs\[6\]\[1\]
+ cpuregs\[7\]\[1\] _0046_ _0047_ VSS VSS VDD VDD _2824_ sky130_fd_sc_hd__mux4_2
X_6888_ cpuregs\[8\]\[1\] cpuregs\[9\]\[1\] cpuregs\[10\]\[1\]
+ cpuregs\[11\]\[1\] _0046_ _0047_ VSS VSS VDD VDD _2825_ sky130_fd_sc_hd__mux4_2
X_6889_ cpuregs\[12\]\[1\] cpuregs\[13\]\[1\] cpuregs\[14\]\[1\]
+ cpuregs\[15\]\[1\] _0046_ _0047_ VSS VSS VDD VDD _2826_ sky130_fd_sc_hd__mux4_2
X_6890_ _2823_ _2824_ _2825_ _2826_ _0048_ _0049_ VSS VSS
+ VDD VDD _2827_ sky130_fd_sc_hd__mux4_2
X_6891_ cpuregs\[16\]\[1\] cpuregs\[17\]\[1\] cpuregs\[18\]\[1\]
+ cpuregs\[19\]\[1\] _0046_ _0047_ VSS VSS VDD VDD _2828_ sky130_fd_sc_hd__mux4_2
X_6892_ cpuregs\[20\]\[1\] cpuregs\[21\]\[1\] cpuregs\[22\]\[1\]
+ cpuregs\[23\]\[1\] _0046_ _0047_ VSS VSS VDD VDD _2829_ sky130_fd_sc_hd__mux4_2
X_6893_ cpuregs\[24\]\[1\] cpuregs\[25\]\[1\] cpuregs\[26\]\[1\]
+ cpuregs\[27\]\[1\] net760 net757 VSS VSS VDD VDD _2830_ sky130_fd_sc_hd__mux4_2
X_6894_ cpuregs\[28\]\[1\] cpuregs\[29\]\[1\] cpuregs\[30\]\[1\]
+ cpuregs\[31\]\[1\] _0046_ net757 VSS VSS VDD VDD _2831_ sky130_fd_sc_hd__mux4_2
X_6895_ _2828_ _2829_ _2830_ _2831_ net754 _0049_ VSS VSS
+ VDD VDD _2832_ sky130_fd_sc_hd__mux4_2
X_6896_ _2827_ _2832_ _0050_ VSS VSS VDD VDD _2833_ sky130_fd_sc_hd__mux2_2
X_6897_ _2420_ _2833_ VSS VSS VDD VDD _2834_ sky130_fd_sc_hd__nand2_1
X_6898_ decoded_imm\[1\] net687 VSS VSS VDD VDD _2835_ sky130_fd_sc_hd__nand2_1
X_6899_ net687 _2834_ _2835_ VSS VSS VDD VDD _4575_ sky130_fd_sc_hd__o21ai_0
X_6900_ cpuregs\[0\]\[0\] cpuregs\[1\]\[0\] cpuregs\[2\]\[0\]
+ cpuregs\[3\]\[0\] net762 net757 VSS VSS VDD VDD _2836_ sky130_fd_sc_hd__mux4_2
X_6901_ cpuregs\[4\]\[0\] cpuregs\[5\]\[0\] cpuregs\[6\]\[0\]
+ cpuregs\[7\]\[0\] net762 net757 VSS VSS VDD VDD _2837_ sky130_fd_sc_hd__mux4_2
X_6902_ cpuregs\[8\]\[0\] cpuregs\[9\]\[0\] cpuregs\[10\]\[0\]
+ cpuregs\[11\]\[0\] net762 net757 VSS VSS VDD VDD _2838_ sky130_fd_sc_hd__mux4_2
X_6903_ cpuregs\[12\]\[0\] cpuregs\[13\]\[0\] cpuregs\[14\]\[0\]
+ cpuregs\[15\]\[0\] net762 net757 VSS VSS VDD VDD _2839_ sky130_fd_sc_hd__mux4_2
X_6904_ _2836_ _2837_ _2838_ _2839_ net753 net752 VSS VSS
+ VDD VDD _2840_ sky130_fd_sc_hd__mux4_2
X_6905_ cpuregs\[16\]\[0\] cpuregs\[17\]\[0\] cpuregs\[18\]\[0\]
+ cpuregs\[19\]\[0\] _0046_ net757 VSS VSS VDD VDD _2841_ sky130_fd_sc_hd__mux4_2
X_6906_ cpuregs\[20\]\[0\] cpuregs\[21\]\[0\] cpuregs\[22\]\[0\]
+ cpuregs\[23\]\[0\] _0046_ net757 VSS VSS VDD VDD _2842_ sky130_fd_sc_hd__mux4_2
X_6907_ cpuregs\[24\]\[0\] cpuregs\[25\]\[0\] cpuregs\[26\]\[0\]
+ cpuregs\[27\]\[0\] _0046_ net757 VSS VSS VDD VDD _2843_ sky130_fd_sc_hd__mux4_2
X_6908_ cpuregs\[28\]\[0\] cpuregs\[29\]\[0\] cpuregs\[30\]\[0\]
+ cpuregs\[31\]\[0\] _0046_ net757 VSS VSS VDD VDD _2844_ sky130_fd_sc_hd__mux4_2
X_6909_ _2841_ _2842_ _2843_ _2844_ net754 net752 VSS VSS
+ VDD VDD _2845_ sky130_fd_sc_hd__mux4_2
X_6910_ _2840_ _2845_ _0050_ VSS VSS VDD VDD _2846_ sky130_fd_sc_hd__mux2_2
X_6911_ _2420_ _2846_ VSS VSS VDD VDD _2847_ sky130_fd_sc_hd__nand2_1
X_6912_ decoded_imm\[0\] net687 VSS VSS VDD VDD _2848_ sky130_fd_sc_hd__nand2_1
X_6913_ net687 _2847_ _2848_ VSS VSS VDD VDD _4564_ sky130_fd_sc_hd__o21ai_0
Xplace740 net309 VSS VSS VDD VDD net731 sky130_fd_sc_hd__buf_4
X_6915_ is_slli_srli_srai _2808_ VSS VSS VDD VDD _2850_ sky130_fd_sc_hd__nor2_1
X_6916_ decoded_imm_j\[3\] is_slli_srli_srai _2850_ VSS VSS
+ VDD VDD _2851_ sky130_fd_sc_hd__a21oi_1
X_6917_ _0158_ net658 VSS VSS VDD VDD _2852_ sky130_fd_sc_hd__nor2_1
X_6918_ reg_sh\[1\] reg_sh\[0\] net657 VSS VSS VDD VDD _2853_
+ sky130_fd_sc_hd__nor3_1
X_6919_ _2852_ _2853_ net746 VSS VSS VDD VDD _2854_ sky130_fd_sc_hd__o21ai_0
X_6920_ net746 _2851_ _2854_ VSS VSS VDD VDD _0039_ sky130_fd_sc_hd__o21ai_0
X_6921_ _0165_ _1674_ _0155_ VSS VSS VDD VDD _2855_ sky130_fd_sc_hd__o21ai_0
X_6922_ is_slli_srli_srai _2821_ VSS VSS VDD VDD _2856_ sky130_fd_sc_hd__nor2_1
X_6923_ decoded_imm_j\[2\] is_slli_srli_srai _2856_ net746
+ VSS VSS VDD VDD _2857_ sky130_fd_sc_hd__a211oi_1
X_6924_ net746 _2855_ _2857_ VSS VSS VDD VDD _0038_ sky130_fd_sc_hd__a21oi_1
X_6925_ decoded_imm_j\[1\] is_slli_srli_srai VSS VSS VDD VDD
+ _2858_ sky130_fd_sc_hd__nand2_1
X_6926_ is_slli_srli_srai _2834_ _2858_ VSS VSS VDD VDD _2859_
+ sky130_fd_sc_hd__o21ai_0
X_6927_ _0166_ net657 net746 VSS VSS VDD VDD _2860_ sky130_fd_sc_hd__o21ai_0
X_6928_ net746 _2859_ _2860_ VSS VSS VDD VDD _0037_ sky130_fd_sc_hd__o21a_1
X_6929_ is_slli_srli_srai _2847_ VSS VSS VDD VDD _2861_ sky130_fd_sc_hd__nor2_1
X_6930_ decoded_imm_j\[11\] is_slli_srli_srai _2861_ VSS VSS
+ VDD VDD _2862_ sky130_fd_sc_hd__a21oi_1
X_6931_ _0163_ net746 net658 VSS VSS VDD VDD _2863_ sky130_fd_sc_hd__nand3_1
X_6932_ net746 _2862_ _2863_ VSS VSS VDD VDD _0036_ sky130_fd_sc_hd__o21ai_0
X_6933_ latched_is_lh latched_is_lb _0962_ VSS VSS VDD VDD
+ _2864_ sky130_fd_sc_hd__nor3_1
X_6934_ net144 net162 net721 VSS VSS VDD VDD _2865_ sky130_fd_sc_hd__mux2_2
X_6935_ net144 net696 _2865_ mem_wordsize\[2\] VSS VSS VDD
+ VDD _2866_ sky130_fd_sc_hd__a22o_1
X_6936_ net721 net153 VSS VSS VDD VDD _2867_ sky130_fd_sc_hd__nand2_1
X_6937_ net308 _2865_ VSS VSS VDD VDD _2868_ sky130_fd_sc_hd__nand2_1
X_6938_ net732 _2867_ _2868_ VSS VSS VDD VDD _2869_ sky130_fd_sc_hd__o21ai_0
X_6939_ mem_wordsize\[2\] net721 VSS VSS VDD VDD _2870_ sky130_fd_sc_hd__and2_1
Xplace741 net308 VSS VSS VDD VDD net732 sky130_fd_sc_hd__buf_4
Xplace743 mem_wordsize\[1\] VSS VSS VDD VDD net734 sky130_fd_sc_hd__buf_4
X_6942_ net748 VSS VSS VDD VDD _2873_ sky130_fd_sc_hd__inv_1
Xplace744 mem_rdata_q\[27\] VSS VSS VDD VDD net735 sky130_fd_sc_hd__buf_4
X_6944_ cpu_state\[2\] VSS VSS VDD VDD _2875_ sky130_fd_sc_hd__inv_1
X_6945_ _2873_ _1667_ _2875_ VSS VSS VDD VDD _2876_ sky130_fd_sc_hd__nand3_1
X_6946_ net167 net267 _2870_ net153 _2876_ VSS VSS VDD VDD
+ _2877_ sky130_fd_sc_hd__a221o_1
X_6947_ net734 _2869_ _2877_ VSS VSS VDD VDD _2878_ sky130_fd_sc_hd__a21oi_1
X_6948_ latched_is_lb _2876_ VSS VSS VDD VDD _2879_ sky130_fd_sc_hd__nor2_1
X_6949_ _2878_ _2879_ VSS VSS VDD VDD _2880_ sky130_fd_sc_hd__nor2_1
X_6950_ latched_is_lh _2866_ _2880_ VSS VSS VDD VDD _2881_
+ sky130_fd_sc_hd__a21o_1
X_6951_ net161 net678 _2881_ VSS VSS VDD VDD _2882_ sky130_fd_sc_hd__a21oi_1
X_6952_ _0438_ VSS VSS VDD VDD _2883_ sky130_fd_sc_hd__inv_1
X_6953_ _0066_ _0071_ _0070_ VSS VSS VDD VDD _2884_ sky130_fd_sc_hd__a21o_1
X_6954_ _0364_ _2884_ _0363_ VSS VSS VDD VDD _2885_ sky130_fd_sc_hd__a21oi_1
X_6955_ _0410_ _0361_ _0409_ VSS VSS VDD VDD _2886_ sky130_fd_sc_hd__a21oi_1
X_6956_ _0356_ _0437_ VSS VSS VDD VDD _2887_ sky130_fd_sc_hd__nor2_1
X_6957_ _2883_ _2885_ _2886_ _2887_ VSS VSS VDD VDD _2888_
+ sky130_fd_sc_hd__o211ai_1
X_6958_ _0362_ _0410_ VSS VSS VDD VDD _2889_ sky130_fd_sc_hd__nand2_1
X_6959_ _0356_ _0357_ VSS VSS VDD VDD _2890_ sky130_fd_sc_hd__nor2_1
X_6960_ _2889_ _2890_ _2886_ VSS VSS VDD VDD _2891_ sky130_fd_sc_hd__o21ai_0
X_6961_ _2888_ _2891_ VSS VSS VDD VDD _2892_ sky130_fd_sc_hd__and2_1
X_6962_ _0497_ _0131_ _0290_ VSS VSS VDD VDD _2893_ sky130_fd_sc_hd__nand3_1
X_6963_ _0495_ _0104_ VSS VSS VDD VDD _2894_ sky130_fd_sc_hd__nand2_1
X_6964_ _2893_ _2894_ VSS VSS VDD VDD _2895_ sky130_fd_sc_hd__nor2_1
X_6965_ _0104_ _0494_ _0103_ VSS VSS VDD VDD _2896_ sky130_fd_sc_hd__a21oi_1
X_6966_ _2893_ _2896_ VSS VSS VDD VDD _2897_ sky130_fd_sc_hd__nor2_1
X_6967_ _0130_ _0290_ _0289_ VSS VSS VDD VDD _2898_ sky130_fd_sc_hd__a21oi_1
X_6968_ _2898_ _0497_ VSS VSS VDD VDD _2899_ sky130_fd_sc_hd__nor2b_1
X_6969_ _0496_ _2897_ _2899_ VSS VSS VDD VDD _2900_ sky130_fd_sc_hd__or3_1
X_6970_ _0446_ _2900_ _0445_ VSS VSS VDD VDD _2901_ sky130_fd_sc_hd__a21o_1
X_6971_ _0446_ _2892_ _2895_ _2901_ VSS VSS VDD VDD _2902_
+ sky130_fd_sc_hd__a31oi_1
X_6972_ _0442_ _0355_ _0154_ VSS VSS VDD VDD _2903_ sky130_fd_sc_hd__and3_1
X_6973_ _0384_ _0444_ _2903_ VSS VSS VDD VDD _2904_ sky130_fd_sc_hd__nand3_1
Xplace749 instr_rdinstrh VSS VSS VDD VDD net740 sky130_fd_sc_hd__buf_4
Xplace759 cpu_state\[1\] VSS VSS VDD VDD net750 sky130_fd_sc_hd__buf_4
X_6976_ _0450_ _0386_ _0507_ _0135_ VSS VSS VDD VDD _2907_
+ sky130_fd_sc_hd__nand4_1
Xplace760 _0050_ VSS VSS VDD VDD net751 sky130_fd_sc_hd__buf_4
X_6978_ _0233_ _0265_ _0448_ VSS VSS VDD VDD _2909_ sky130_fd_sc_hd__nand3_1
X_6979_ _2904_ _2907_ _2909_ VSS VSS VDD VDD _2910_ sky130_fd_sc_hd__or3_1
X_6980_ _0265_ _0447_ _0264_ VSS VSS VDD VDD _2911_ sky130_fd_sc_hd__a21o_1
X_6981_ _0233_ _2911_ _0232_ VSS VSS VDD VDD _2912_ sky130_fd_sc_hd__a21oi_1
X_6982_ _2912_ _0450_ VSS VSS VDD VDD _2913_ sky130_fd_sc_hd__nor2b_1
X_6983_ _0449_ _2913_ _0386_ VSS VSS VDD VDD _2914_ sky130_fd_sc_hd__o21ai_0
X_6984_ _0134_ _0506_ _0385_ VSS VSS VDD VDD _2915_ sky130_fd_sc_hd__nor3_1
X_6985_ _0134_ _0506_ _0135_ VSS VSS VDD VDD _2916_ sky130_fd_sc_hd__or3_1
X_6986_ _0507_ _0506_ _2916_ VSS VSS VDD VDD _2917_ sky130_fd_sc_hd__o21ai_0
X_6987_ _2914_ _2915_ _2917_ _2904_ VSS VSS VDD VDD _2918_
+ sky130_fd_sc_hd__a211o_1
X_6988_ _2902_ _2910_ _2918_ VSS VSS VDD VDD _2919_ sky130_fd_sc_hd__o21a_1
X_6989_ _0355_ _0153_ _0354_ VSS VSS VDD VDD _2920_ sky130_fd_sc_hd__a21o_1
X_6990_ _0383_ _2903_ _2920_ _0442_ _0441_ VSS VSS VDD VDD
+ _2921_ sky130_fd_sc_hd__a221o_1
X_6991_ _0444_ _2921_ _0443_ VSS VSS VDD VDD _2922_ sky130_fd_sc_hd__a21oi_1
X_6992_ _0352_ _0151_ _2922_ VSS VSS VDD VDD _2923_ sky130_fd_sc_hd__nor3b_1
X_6993_ _0151_ _0152_ VSS VSS VDD VDD _2924_ sky130_fd_sc_hd__or2_2
X_6994_ _0353_ _2924_ _0352_ VSS VSS VDD VDD _2925_ sky130_fd_sc_hd__a21oi_1
X_6995_ _0282_ _0292_ VSS VSS VDD VDD _2926_ sky130_fd_sc_hd__nand2_1
X_6996_ _2919_ _2923_ _2925_ _2926_ VSS VSS VDD VDD _2927_
+ sky130_fd_sc_hd__a211o_1
X_6997_ _0292_ _0281_ _0291_ VSS VSS VDD VDD _2928_ sky130_fd_sc_hd__a21oi_1
Xplace613 cpuregs_wrdata\[25\] VSS VSS VDD VDD net604 sky130_fd_sc_hd__buf_4
Xplace614 cpuregs_wrdata\[26\] VSS VSS VDD VDD net605 sky130_fd_sc_hd__buf_4
Xplace615 cpuregs_wrdata\[19\] VSS VSS VDD VDD net606 sky130_fd_sc_hd__buf_4
X_7001_ count_instr\[30\] net741 net740 count_instr\[62\]
+ count_cycle\[62\] net742 VSS VSS VDD VDD _2932_ sky130_fd_sc_hd__a222oi_1
X_7002_ net742 net741 net740 VSS VSS VDD VDD _2933_ sky130_fd_sc_hd__nor3_2
X_7003_ count_cycle\[30\] net686 VSS VSS VDD VDD _2934_ sky130_fd_sc_hd__nand2_1
X_7004_ _2932_ _2934_ VSS VSS VDD VDD _2935_ sky130_fd_sc_hd__nand2_1
X_7005_ net748 net747 net749 VSS VSS VDD VDD _2936_ sky130_fd_sc_hd__nor3_4
X_7006_ net710 net747 net749 _2935_ net685 VSS VSS VDD VDD
+ _2937_ sky130_fd_sc_hd__a221oi_1
X_7007_ _0440_ _2937_ VSS VSS VDD VDD _2938_ sky130_fd_sc_hd__nand2_1
X_7008_ _2927_ _2928_ _2938_ VSS VSS VDD VDD _2939_ sky130_fd_sc_hd__a21oi_1
X_7009_ _0440_ _2937_ _2927_ _2928_ VSS VSS VDD VDD _2940_
+ sky130_fd_sc_hd__and4b_1
Xoutput373 net364 VSS VSS VDD VDD trap sky130_fd_sc_hd__clkdlybuf4s50_1
X_7011_ _2873_ _2937_ VSS VSS VDD VDD _2942_ sky130_fd_sc_hd__and2_1
X_7012_ _2882_ _2939_ _2940_ _2942_ VSS VSS VDD VDD _0027_
+ sky130_fd_sc_hd__nor4_1
Xoutput372 net363 VSS VSS VDD VDD pcpi_rs2[9] sky130_fd_sc_hd__clkdlybuf4s50_1
Xoutput371 net362 VSS VSS VDD VDD pcpi_rs2[8] sky130_fd_sc_hd__clkdlybuf4s50_1
Xoutput370 net263 VSS VSS VDD VDD pcpi_rs2[7] sky130_fd_sc_hd__clkdlybuf4s50_1
Xoutput369 net262 VSS VSS VDD VDD pcpi_rs2[6] sky130_fd_sc_hd__clkdlybuf4s50_1
Xoutput368 net261 VSS VSS VDD VDD pcpi_rs2[5] sky130_fd_sc_hd__clkdlybuf4s50_1
Xoutput367 net260 VSS VSS VDD VDD pcpi_rs2[4] sky130_fd_sc_hd__clkdlybuf4s50_1
X_7019_ count_instr\[29\] net741 net740 count_instr\[61\]
+ count_cycle\[61\] net742 VSS VSS VDD VDD _2949_ sky130_fd_sc_hd__a222oi_1
Xoutput366 net259 VSS VSS VDD VDD pcpi_rs2[3] sky130_fd_sc_hd__clkdlybuf4s50_1
X_7021_ count_cycle\[29\] net686 VSS VSS VDD VDD _2951_ sky130_fd_sc_hd__nand2_1
X_7022_ _2949_ _2951_ VSS VSS VDD VDD _2952_ sky130_fd_sc_hd__nand2_1
Xoutput365 net700 VSS VSS VDD VDD pcpi_rs2[31] sky130_fd_sc_hd__clkdlybuf4s50_1
X_7024_ net329 net747 net749 _2952_ net685 VSS VSS VDD VDD
+ _2954_ sky130_fd_sc_hd__a221oi_1
Xoutput364 net701 VSS VSS VDD VDD pcpi_rs2[30] sky130_fd_sc_hd__clkdlybuf4s50_1
X_7026_ _2886_ _2889_ VSS VSS VDD VDD _2956_ sky130_fd_sc_hd__nand2_1
X_7027_ _0067_ _0364_ _0437_ _0363_ VSS VSS VDD VDD _2957_
+ sky130_fd_sc_hd__a211oi_1
X_7028_ _0438_ _0437_ _0357_ VSS VSS VDD VDD _2958_ sky130_fd_sc_hd__o21ai_0
X_7029_ _0356_ _0409_ _0361_ VSS VSS VDD VDD _2959_ sky130_fd_sc_hd__nor3_1
X_7030_ _2957_ _2958_ _2959_ VSS VSS VDD VDD _2960_ sky130_fd_sc_hd__o21ai_0
X_7031_ _2956_ _2895_ _2960_ VSS VSS VDD VDD _2961_ sky130_fd_sc_hd__nand3_1
X_7032_ _0233_ _0264_ VSS VSS VDD VDD _2962_ sky130_fd_sc_hd__nand2_1
X_7033_ _0445_ _0448_ _0447_ _0232_ VSS VSS VDD VDD _2963_
+ sky130_fd_sc_hd__a211oi_1
X_7034_ _2962_ _2963_ VSS VSS VDD VDD _2964_ sky130_fd_sc_hd__nand2_1
X_7035_ _0496_ _2897_ _2899_ _2964_ VSS VSS VDD VDD _2965_
+ sky130_fd_sc_hd__nor4_1
X_7036_ _0445_ _0446_ _0448_ VSS VSS VDD VDD _2966_ sky130_fd_sc_hd__o21ai_0
X_7037_ _0264_ _0447_ VSS VSS VDD VDD _2967_ sky130_fd_sc_hd__nor2_1
X_7038_ _0265_ _0264_ _0233_ VSS VSS VDD VDD _2968_ sky130_fd_sc_hd__o21ai_0
X_7039_ _2966_ _2967_ _2968_ VSS VSS VDD VDD _2969_ sky130_fd_sc_hd__a21oi_1
X_7040_ _2907_ VSS VSS VDD VDD _2970_ sky130_fd_sc_hd__inv_1
X_7041_ _0232_ _2969_ _2970_ _2903_ _0384_ VSS VSS VDD VDD
+ _2971_ sky130_fd_sc_hd__o2111ai_1
X_7042_ _2961_ _2965_ _2971_ VSS VSS VDD VDD _2972_ sky130_fd_sc_hd__a21oi_1
X_7043_ _0154_ _0153_ VSS VSS VDD VDD _2973_ sky130_fd_sc_hd__or2_2
X_7044_ _0355_ _2973_ _0354_ VSS VSS VDD VDD _2974_ sky130_fd_sc_hd__a21o_1
X_7045_ _0384_ VSS VSS VDD VDD _2975_ sky130_fd_sc_hd__inv_1
X_7046_ _0386_ _0449_ _0134_ _0385_ VSS VSS VDD VDD _2976_
+ sky130_fd_sc_hd__a211o_1
X_7047_ _0134_ _0135_ _0507_ VSS VSS VDD VDD _2977_ sky130_fd_sc_hd__o21a_1
X_7048_ _2976_ _2977_ _0506_ VSS VSS VDD VDD _2978_ sky130_fd_sc_hd__a21oi_1
X_7049_ _0383_ _0354_ _0153_ VSS VSS VDD VDD _2979_ sky130_fd_sc_hd__nor3_1
X_7050_ _2975_ _2978_ _2979_ VSS VSS VDD VDD _2980_ sky130_fd_sc_hd__o21ai_0
X_7051_ _0442_ _2974_ _2980_ _0441_ VSS VSS VDD VDD _2981_
+ sky130_fd_sc_hd__a31o_2
X_7052_ _0151_ _0444_ _0443_ _2924_ VSS VSS VDD VDD _2982_
+ sky130_fd_sc_hd__o31a_1
X_7053_ _0151_ _0443_ _2972_ _2981_ _2982_ VSS VSS VDD VDD
+ _2983_ sky130_fd_sc_hd__o41ai_1
X_7054_ _0282_ _0353_ VSS VSS VDD VDD _2984_ sky130_fd_sc_hd__nand2_1
X_7055_ _0282_ _0352_ _0281_ VSS VSS VDD VDD _2985_ sky130_fd_sc_hd__a21oi_1
X_7056_ _2983_ _2984_ _2985_ VSS VSS VDD VDD _2986_ sky130_fd_sc_hd__o21ai_0
X_7057_ _0292_ _2986_ VSS VSS VDD VDD _2987_ sky130_fd_sc_hd__xor2_1
X_7058_ net748 _2987_ VSS VSS VDD VDD _2988_ sky130_fd_sc_hd__nand2_1
Xoutput363 net256 VSS VSS VDD VDD pcpi_rs2[2] sky130_fd_sc_hd__clkdlybuf4s50_1
Xoutput362 net359 VSS VSS VDD VDD pcpi_rs2[29] sky130_fd_sc_hd__clkdlybuf4s50_1
X_7061_ net159 net678 _2881_ VSS VSS VDD VDD _2991_ sky130_fd_sc_hd__a21oi_1
X_7062_ _2954_ _2988_ _2991_ VSS VSS VDD VDD _0025_ sky130_fd_sc_hd__a21oi_1
X_7063_ _2919_ _2923_ _2925_ VSS VSS VDD VDD _2992_ sky130_fd_sc_hd__a21oi_1
X_7064_ _0282_ _2992_ VSS VSS VDD VDD _2993_ sky130_fd_sc_hd__xnor2_1
Xoutput361 net358 VSS VSS VDD VDD pcpi_rs2[28] sky130_fd_sc_hd__clkdlybuf4s50_1
Xoutput360 net357 VSS VSS VDD VDD pcpi_rs2[27] sky130_fd_sc_hd__clkdlybuf4s50_1
Xoutput359 net356 VSS VSS VDD VDD pcpi_rs2[26] sky130_fd_sc_hd__clkdlybuf4s50_1
Xoutput358 net355 VSS VSS VDD VDD pcpi_rs2[25] sky130_fd_sc_hd__clkdlybuf4s50_1
X_7069_ count_instr\[28\] net741 net740 count_instr\[60\]
+ count_cycle\[60\] net742 VSS VSS VDD VDD _2998_ sky130_fd_sc_hd__a222oi_1
Xoutput357 net354 VSS VSS VDD VDD pcpi_rs2[24] sky130_fd_sc_hd__clkdlybuf4s50_1
X_7071_ count_cycle\[28\] net686 VSS VSS VDD VDD _3000_ sky130_fd_sc_hd__nand2_1
X_7072_ _2998_ _3000_ VSS VSS VDD VDD _3001_ sky130_fd_sc_hd__nand2_1
Xoutput356 net353 VSS VSS VDD VDD pcpi_rs2[23] sky130_fd_sc_hd__clkdlybuf4s50_1
X_7074_ net712 net747 net749 _3001_ net685 VSS VSS VDD VDD
+ _3003_ sky130_fd_sc_hd__a221oi_1
X_7075_ net158 net678 _2881_ VSS VSS VDD VDD _3004_ sky130_fd_sc_hd__a21oi_1
X_7076_ _2873_ _2993_ _3003_ _3004_ VSS VSS VDD VDD _0024_
+ sky130_fd_sc_hd__o22ai_1
Xoutput355 net352 VSS VSS VDD VDD pcpi_rs2[22] sky130_fd_sc_hd__clkdlybuf4s50_1
Xoutput354 net351 VSS VSS VDD VDD pcpi_rs2[21] sky130_fd_sc_hd__clkdlybuf4s50_1
Xoutput353 net350 VSS VSS VDD VDD pcpi_rs2[20] sky130_fd_sc_hd__clkdlybuf4s50_1
X_7080_ count_instr\[27\] net741 net740 count_instr\[59\]
+ count_cycle\[59\] net742 VSS VSS VDD VDD _3008_ sky130_fd_sc_hd__a222oi_1
Xoutput352 net245 VSS VSS VDD VDD pcpi_rs2[1] sky130_fd_sc_hd__clkdlybuf4s50_1
X_7082_ count_cycle\[27\] net686 VSS VSS VDD VDD _3010_ sky130_fd_sc_hd__nand2_1
X_7083_ _3008_ _3010_ VSS VSS VDD VDD _3011_ sky130_fd_sc_hd__nand2_1
X_7084_ net713 net747 net749 _3011_ net685 VSS VSS VDD VDD
+ _3012_ sky130_fd_sc_hd__a221oi_1
X_7085_ _0353_ _2983_ VSS VSS VDD VDD _3013_ sky130_fd_sc_hd__xnor2_1
X_7086_ net748 _3013_ VSS VSS VDD VDD _3014_ sky130_fd_sc_hd__nand2_1
X_7087_ net157 net678 _2881_ VSS VSS VDD VDD _3015_ sky130_fd_sc_hd__a21oi_1
X_7088_ _3012_ _3014_ _3015_ VSS VSS VDD VDD _0023_ sky130_fd_sc_hd__a21oi_1
X_7089_ _2919_ _2922_ VSS VSS VDD VDD _3016_ sky130_fd_sc_hd__nand2_1
X_7090_ _0152_ _3016_ VSS VSS VDD VDD _3017_ sky130_fd_sc_hd__xor2_1
X_7091_ net748 _3017_ VSS VSS VDD VDD _3018_ sky130_fd_sc_hd__nand2_1
X_7092_ count_instr\[26\] net741 net740 count_instr\[58\]
+ count_cycle\[58\] net742 VSS VSS VDD VDD _3019_ sky130_fd_sc_hd__a222oi_1
X_7093_ count_cycle\[26\] net686 VSS VSS VDD VDD _3020_ sky130_fd_sc_hd__nand2_1
X_7094_ _3019_ _3020_ VSS VSS VDD VDD _3021_ sky130_fd_sc_hd__nand2_1
X_7095_ net714 net747 net749 _3021_ net685 VSS VSS VDD VDD
+ _3022_ sky130_fd_sc_hd__a221oi_1
X_7096_ net156 net678 _2881_ VSS VSS VDD VDD _3023_ sky130_fd_sc_hd__a21oi_1
X_7097_ _3018_ _3022_ _3023_ VSS VSS VDD VDD _0022_ sky130_fd_sc_hd__a21oi_1
Xoutput351 net349 VSS VSS VDD VDD pcpi_rs2[19] sky130_fd_sc_hd__clkdlybuf4s50_1
X_7099_ _2972_ _2981_ VSS VSS VDD VDD _3025_ sky130_fd_sc_hd__nor2_1
X_7100_ _0444_ _3025_ VSS VSS VDD VDD _3026_ sky130_fd_sc_hd__xnor2_1
X_7101_ net715 VSS VSS VDD VDD _0254_ sky130_fd_sc_hd__inv_1
X_7102_ count_instr\[25\] net741 net740 count_instr\[57\]
+ count_cycle\[57\] net742 VSS VSS VDD VDD _3027_ sky130_fd_sc_hd__a222oi_1
X_7103_ count_cycle\[25\] net686 _3027_ VSS VSS VDD VDD _3028_
+ sky130_fd_sc_hd__a21boi_0
X_7104_ _0254_ net689 _2875_ _3028_ _2876_ VSS VSS VDD VDD
+ _3029_ sky130_fd_sc_hd__o221ai_1
X_7105_ net748 _3026_ _3029_ VSS VSS VDD VDD _3030_ sky130_fd_sc_hd__a21oi_1
X_7106_ net155 net678 _2881_ VSS VSS VDD VDD _3031_ sky130_fd_sc_hd__a21oi_1
X_7107_ _3030_ _3031_ VSS VSS VDD VDD _0021_ sky130_fd_sc_hd__nor2_1
Xoutput350 net348 VSS VSS VDD VDD pcpi_rs2[18] sky130_fd_sc_hd__clkdlybuf4s50_1
X_7109_ count_instr\[24\] net741 net740 count_instr\[56\]
+ count_cycle\[56\] net742 VSS VSS VDD VDD _3033_ sky130_fd_sc_hd__a222oi_1
X_7110_ count_cycle\[24\] net686 VSS VSS VDD VDD _3034_ sky130_fd_sc_hd__nand2_1
X_7111_ _3033_ _3034_ VSS VSS VDD VDD _3035_ sky130_fd_sc_hd__nand2_1
X_7112_ net716 net747 net749 _3035_ net685 VSS VSS VDD VDD
+ _3036_ sky130_fd_sc_hd__a221oi_1
X_7113_ _0265_ _0448_ VSS VSS VDD VDD _3037_ sky130_fd_sc_hd__nand2_1
X_7114_ _0233_ _0384_ _2970_ VSS VSS VDD VDD _3038_ sky130_fd_sc_hd__nand3_1
X_7115_ _2914_ _2915_ _2917_ _2975_ VSS VSS VDD VDD _3039_
+ sky130_fd_sc_hd__a211o_1
X_7116_ _2902_ _3037_ _3038_ _3039_ VSS VSS VDD VDD _3040_
+ sky130_fd_sc_hd__o31ai_1
X_7117_ _0383_ _0354_ _0153_ _3040_ _2974_ VSS VSS VDD VDD
+ _3041_ sky130_fd_sc_hd__o41ai_1
X_7118_ _0442_ _3041_ VSS VSS VDD VDD _3042_ sky130_fd_sc_hd__xnor2_1
X_7119_ net748 _3042_ VSS VSS VDD VDD _3043_ sky130_fd_sc_hd__nand2_1
X_7120_ net154 net678 _2881_ VSS VSS VDD VDD _3044_ sky130_fd_sc_hd__a21oi_1
X_7121_ _3036_ _3043_ _3044_ VSS VSS VDD VDD _0020_ sky130_fd_sc_hd__a21oi_1
X_7122_ count_instr\[23\] net741 net740 count_instr\[55\]
+ count_cycle\[55\] net742 VSS VSS VDD VDD _3045_ sky130_fd_sc_hd__a222oi_1
X_7123_ count_cycle\[23\] net686 VSS VSS VDD VDD _3046_ sky130_fd_sc_hd__nand2_1
X_7124_ _3045_ _3046_ VSS VSS VDD VDD _3047_ sky130_fd_sc_hd__nand2_1
Xoutput349 net347 VSS VSS VDD VDD pcpi_rs2[17] sky130_fd_sc_hd__clkdlybuf4s50_1
X_7126_ net717 net747 net749 _3047_ net685 VSS VSS VDD VDD
+ _3049_ sky130_fd_sc_hd__a221oi_1
Xoutput348 net346 VSS VSS VDD VDD pcpi_rs2[16] sky130_fd_sc_hd__clkdlybuf4s50_1
X_7128_ _0232_ _2969_ VSS VSS VDD VDD _3051_ sky130_fd_sc_hd__nor2_1
X_7129_ _2961_ _2965_ _3051_ VSS VSS VDD VDD _3052_ sky130_fd_sc_hd__a21oi_1
X_7130_ _0450_ _3052_ _0449_ VSS VSS VDD VDD _3053_ sky130_fd_sc_hd__a21oi_1
X_7131_ _3053_ _0135_ _0507_ _0386_ VSS VSS VDD VDD _3054_
+ sky130_fd_sc_hd__nand4b_1
X_7132_ _0385_ _0135_ _0134_ VSS VSS VDD VDD _3055_ sky130_fd_sc_hd__a21o_1
X_7133_ _0507_ _3055_ VSS VSS VDD VDD _3056_ sky130_fd_sc_hd__nand2_1
X_7134_ _0383_ _0506_ _0153_ VSS VSS VDD VDD _3057_ sky130_fd_sc_hd__nor3_1
X_7135_ _0383_ _0384_ _0153_ _2973_ VSS VSS VDD VDD _3058_
+ sky130_fd_sc_hd__o31ai_1
X_7136_ _3054_ _3056_ _3057_ _3058_ VSS VSS VDD VDD _3059_
+ sky130_fd_sc_hd__a31oi_1
X_7137_ _0355_ _3059_ VSS VSS VDD VDD _3060_ sky130_fd_sc_hd__xor2_1
X_7138_ net748 _3060_ VSS VSS VDD VDD _3061_ sky130_fd_sc_hd__nand2_1
X_7139_ net153 net678 _2881_ VSS VSS VDD VDD _3062_ sky130_fd_sc_hd__a21oi_1
X_7140_ _3049_ _3061_ _3062_ VSS VSS VDD VDD _0019_ sky130_fd_sc_hd__a21oi_1
X_7141_ _0383_ _3040_ VSS VSS VDD VDD _3063_ sky130_fd_sc_hd__nor2_1
X_7142_ _0154_ _3063_ VSS VSS VDD VDD _3064_ sky130_fd_sc_hd__xor2_1
X_7143_ count_instr\[22\] net741 net740 count_instr\[54\]
+ count_cycle\[54\] net742 VSS VSS VDD VDD _3065_ sky130_fd_sc_hd__a222oi_1
X_7144_ count_cycle\[22\] net686 VSS VSS VDD VDD _3066_ sky130_fd_sc_hd__nand2_1
X_7145_ _3065_ _3066_ VSS VSS VDD VDD _3067_ sky130_fd_sc_hd__nand2_1
X_7146_ net718 net747 net749 _3067_ net685 VSS VSS VDD VDD
+ _3068_ sky130_fd_sc_hd__a221oi_1
X_7147_ net152 net678 _2881_ VSS VSS VDD VDD _3069_ sky130_fd_sc_hd__a21oi_1
X_7148_ _2873_ _3064_ _3068_ _3069_ VSS VSS VDD VDD _0018_
+ sky130_fd_sc_hd__o22ai_1
X_7149_ _3054_ _3056_ VSS VSS VDD VDD _3070_ sky130_fd_sc_hd__nand2_1
X_7150_ _0506_ _3070_ VSS VSS VDD VDD _3071_ sky130_fd_sc_hd__nor2_1
X_7151_ _2975_ _3071_ VSS VSS VDD VDD _3072_ sky130_fd_sc_hd__xnor2_1
X_7152_ count_instr\[21\] net741 net740 count_instr\[53\]
+ count_cycle\[53\] net742 VSS VSS VDD VDD _3073_ sky130_fd_sc_hd__a222oi_1
X_7153_ count_cycle\[21\] net686 VSS VSS VDD VDD _3074_ sky130_fd_sc_hd__nand2_1
X_7154_ _3073_ _3074_ VSS VSS VDD VDD _3075_ sky130_fd_sc_hd__nand2_1
X_7155_ net719 net747 net749 _3075_ net685 VSS VSS VDD VDD
+ _3076_ sky130_fd_sc_hd__a221oi_1
X_7156_ net151 net678 _2881_ VSS VSS VDD VDD _3077_ sky130_fd_sc_hd__a21oi_1
X_7157_ _2873_ _3072_ _3076_ _3077_ VSS VSS VDD VDD _0017_
+ sky130_fd_sc_hd__o22ai_1
X_7158_ count_instr\[20\] net741 net740 count_instr\[52\]
+ count_cycle\[52\] net742 VSS VSS VDD VDD _3078_ sky130_fd_sc_hd__a222oi_1
X_7159_ count_cycle\[20\] net686 VSS VSS VDD VDD _3079_ sky130_fd_sc_hd__nand2_1
X_7160_ _3078_ _3079_ VSS VSS VDD VDD _3080_ sky130_fd_sc_hd__nand2_1
X_7161_ net720 net747 net749 _3080_ net685 VSS VSS VDD VDD
+ _3081_ sky130_fd_sc_hd__a221oi_1
X_7162_ _0385_ VSS VSS VDD VDD _3082_ sky130_fd_sc_hd__inv_1
X_7163_ _3082_ _2914_ VSS VSS VDD VDD _3083_ sky130_fd_sc_hd__nand2_1
X_7164_ _0450_ _0233_ _0386_ _0135_ VSS VSS VDD VDD _3084_
+ sky130_fd_sc_hd__nand4_1
X_7165_ _2902_ _3037_ _3084_ VSS VSS VDD VDD _3085_ sky130_fd_sc_hd__nor3_1
X_7166_ _0135_ _3083_ _3085_ _0134_ VSS VSS VDD VDD _3086_
+ sky130_fd_sc_hd__a211oi_1
X_7167_ _0507_ _3086_ VSS VSS VDD VDD _3087_ sky130_fd_sc_hd__xnor2_1
X_7168_ net748 _3087_ VSS VSS VDD VDD _3088_ sky130_fd_sc_hd__nand2_1
X_7169_ net150 net678 _2881_ VSS VSS VDD VDD _3089_ sky130_fd_sc_hd__a21oi_1
X_7170_ _3081_ _3088_ _3089_ VSS VSS VDD VDD _0016_ sky130_fd_sc_hd__a21oi_1
X_7171_ _0386_ VSS VSS VDD VDD _3090_ sky130_fd_sc_hd__inv_1
X_7172_ _3090_ _3053_ _3082_ VSS VSS VDD VDD _3091_ sky130_fd_sc_hd__o21a_1
X_7173_ _0135_ _3091_ VSS VSS VDD VDD _3092_ sky130_fd_sc_hd__xnor2_1
X_7174_ net748 _3092_ VSS VSS VDD VDD _3093_ sky130_fd_sc_hd__nand2_1
X_7175_ count_instr\[19\] net741 net740 count_instr\[51\]
+ count_cycle\[51\] net742 VSS VSS VDD VDD _3094_ sky130_fd_sc_hd__a222oi_1
X_7176_ count_cycle\[19\] net686 VSS VSS VDD VDD _3095_ sky130_fd_sc_hd__nand2_1
X_7177_ _3094_ _3095_ VSS VSS VDD VDD _3096_ sky130_fd_sc_hd__nand2_1
X_7178_ net722 net746 net749 _3096_ net685 VSS VSS VDD VDD
+ _3097_ sky130_fd_sc_hd__a221oi_1
X_7179_ net148 net678 _2881_ VSS VSS VDD VDD _3098_ sky130_fd_sc_hd__a21oi_1
X_7180_ _3093_ _3097_ _3098_ VSS VSS VDD VDD _0014_ sky130_fd_sc_hd__a21oi_1
X_7181_ _2902_ _3037_ _2911_ VSS VSS VDD VDD _3099_ sky130_fd_sc_hd__o21bai_1
X_7182_ _0233_ _3099_ _0232_ VSS VSS VDD VDD _3100_ sky130_fd_sc_hd__a21o_1
X_7183_ _0450_ _3100_ _3090_ _2873_ _0449_ VSS VSS VDD VDD
+ _3101_ sky130_fd_sc_hd__a2111o_1
X_7184_ _2873_ _0386_ VSS VSS VDD VDD _3102_ sky130_fd_sc_hd__nor2_1
X_7185_ _0450_ _3100_ _3102_ VSS VSS VDD VDD _3103_ sky130_fd_sc_hd__nand3_1
X_7186_ net147 net678 _2881_ VSS VSS VDD VDD _3104_ sky130_fd_sc_hd__a21oi_1
X_7187_ count_instr\[18\] net741 net740 count_instr\[50\]
+ count_cycle\[50\] net742 VSS VSS VDD VDD _3105_ sky130_fd_sc_hd__a222oi_1
X_7188_ count_cycle\[18\] net686 VSS VSS VDD VDD _3106_ sky130_fd_sc_hd__nand2_1
X_7189_ _3105_ _3106_ VSS VSS VDD VDD _3107_ sky130_fd_sc_hd__nand2_1
X_7190_ net723 net746 net749 _3107_ net685 VSS VSS VDD VDD
+ _3108_ sky130_fd_sc_hd__a221oi_1
X_7191_ _3104_ _3108_ VSS VSS VDD VDD _3109_ sky130_fd_sc_hd__nor2_1
X_7192_ _0449_ _3102_ _3109_ VSS VSS VDD VDD _3110_ sky130_fd_sc_hd__a21oi_1
X_7193_ _3101_ _3103_ _3110_ VSS VSS VDD VDD _0013_ sky130_fd_sc_hd__nand3_1
X_7194_ count_instr\[17\] net741 net740 count_instr\[49\]
+ count_cycle\[49\] net742 VSS VSS VDD VDD _3111_ sky130_fd_sc_hd__a222oi_1
X_7195_ count_cycle\[17\] net686 VSS VSS VDD VDD _3112_ sky130_fd_sc_hd__nand2_1
X_7196_ _3111_ _3112_ VSS VSS VDD VDD _3113_ sky130_fd_sc_hd__nand2_1
X_7197_ net724 net746 net749 _3113_ net685 VSS VSS VDD VDD
+ _3114_ sky130_fd_sc_hd__a221oi_1
X_7198_ _0450_ _3052_ VSS VSS VDD VDD _3115_ sky130_fd_sc_hd__xor2_1
X_7199_ net748 _3115_ VSS VSS VDD VDD _3116_ sky130_fd_sc_hd__nand2_1
X_7200_ net146 net678 _2881_ VSS VSS VDD VDD _3117_ sky130_fd_sc_hd__a21oi_1
X_7201_ _3114_ _3116_ _3117_ VSS VSS VDD VDD _0012_ sky130_fd_sc_hd__a21oi_1
X_7202_ count_instr\[16\] net741 net740 count_instr\[48\]
+ count_cycle\[48\] net742 VSS VSS VDD VDD _3118_ sky130_fd_sc_hd__a222oi_1
X_7203_ count_cycle\[16\] net686 VSS VSS VDD VDD _3119_ sky130_fd_sc_hd__nand2_1
X_7204_ _3118_ _3119_ VSS VSS VDD VDD _3120_ sky130_fd_sc_hd__nand2_1
X_7205_ net725 net746 net749 _3120_ net685 VSS VSS VDD VDD
+ _3121_ sky130_fd_sc_hd__a221oi_1
X_7206_ _0233_ _3099_ VSS VSS VDD VDD _3122_ sky130_fd_sc_hd__xor2_1
X_7207_ net748 _3122_ VSS VSS VDD VDD _3123_ sky130_fd_sc_hd__nand2_1
X_7208_ net145 net678 _2881_ VSS VSS VDD VDD _3124_ sky130_fd_sc_hd__a21oi_1
X_7209_ _3121_ _3123_ _3124_ VSS VSS VDD VDD _0011_ sky130_fd_sc_hd__a21oi_1
X_7210_ count_instr\[15\] net741 net740 count_instr\[47\]
+ count_cycle\[47\] net742 VSS VSS VDD VDD _3125_ sky130_fd_sc_hd__a222oi_1
X_7211_ count_cycle\[15\] net686 VSS VSS VDD VDD _3126_ sky130_fd_sc_hd__nand2_1
X_7212_ _3125_ _3126_ VSS VSS VDD VDD _3127_ sky130_fd_sc_hd__nand2_1
X_7213_ net726 net746 net749 _3127_ net685 VSS VSS VDD VDD
+ _3128_ sky130_fd_sc_hd__a221oi_1
X_7214_ _2900_ _2961_ VSS VSS VDD VDD _3129_ sky130_fd_sc_hd__nand2b_1
X_7215_ _0446_ _3129_ _0445_ VSS VSS VDD VDD _3130_ sky130_fd_sc_hd__a21o_1
X_7216_ _0448_ _3130_ _0447_ VSS VSS VDD VDD _3131_ sky130_fd_sc_hd__a21oi_1
X_7217_ _0265_ _3131_ VSS VSS VDD VDD _3132_ sky130_fd_sc_hd__xnor2_1
X_7218_ net748 _3132_ VSS VSS VDD VDD _3133_ sky130_fd_sc_hd__nand2_1
X_7219_ latched_is_lh latched_is_lb VSS VSS VDD VDD _3134_
+ sky130_fd_sc_hd__nand2b_1
Xoutput347 net345 VSS VSS VDD VDD pcpi_rs2[15] sky130_fd_sc_hd__clkdlybuf4s50_1
X_7221_ _2866_ _3134_ _2880_ VSS VSS VDD VDD _3136_ sky130_fd_sc_hd__a21oi_1
X_7222_ _3128_ _3133_ _3136_ VSS VSS VDD VDD _0010_ sky130_fd_sc_hd__a21oi_1
X_7223_ count_instr\[14\] net741 net740 count_instr\[46\]
+ count_cycle\[46\] net742 VSS VSS VDD VDD _3137_ sky130_fd_sc_hd__a222oi_1
X_7224_ count_cycle\[14\] net686 VSS VSS VDD VDD _3138_ sky130_fd_sc_hd__nand2_1
X_7225_ _3137_ _3138_ VSS VSS VDD VDD _3139_ sky130_fd_sc_hd__nand2_1
X_7226_ net727 net746 net749 _3139_ net685 VSS VSS VDD VDD
+ _3140_ sky130_fd_sc_hd__a221oi_1
X_7227_ _0448_ _2902_ VSS VSS VDD VDD _3141_ sky130_fd_sc_hd__xnor2_1
X_7228_ net748 _3141_ VSS VSS VDD VDD _3142_ sky130_fd_sc_hd__nand2_1
X_7229_ net733 net721 _0988_ VSS VSS VDD VDD _3143_ sky130_fd_sc_hd__a21boi_1
X_7230_ net161 _2870_ _3143_ net143 VSS VSS VDD VDD _3144_
+ sky130_fd_sc_hd__a22o_1
X_7231_ _3134_ _3144_ _2880_ VSS VSS VDD VDD _3145_ sky130_fd_sc_hd__a21oi_1
X_7232_ _3140_ _3142_ _3145_ VSS VSS VDD VDD _0009_ sky130_fd_sc_hd__a21oi_1
X_7233_ count_instr\[13\] net741 net740 count_instr\[45\]
+ count_cycle\[45\] net742 VSS VSS VDD VDD _3146_ sky130_fd_sc_hd__a222oi_1
X_7234_ count_cycle\[13\] net686 VSS VSS VDD VDD _3147_ sky130_fd_sc_hd__nand2_1
X_7235_ _3146_ _3147_ VSS VSS VDD VDD _3148_ sky130_fd_sc_hd__nand2_1
X_7236_ net728 net746 net749 _3148_ net685 VSS VSS VDD VDD
+ _3149_ sky130_fd_sc_hd__a221oi_1
X_7237_ _0446_ _3129_ VSS VSS VDD VDD _3150_ sky130_fd_sc_hd__xor2_1
X_7238_ net748 _3150_ VSS VSS VDD VDD _3151_ sky130_fd_sc_hd__nand2_1
X_7239_ net159 _2870_ _3143_ net142 VSS VSS VDD VDD _3152_
+ sky130_fd_sc_hd__a22o_1
X_7240_ _3134_ _3152_ _2880_ VSS VSS VDD VDD _3153_ sky130_fd_sc_hd__a21oi_1
X_7241_ _3149_ _3151_ _3153_ VSS VSS VDD VDD _0008_ sky130_fd_sc_hd__a21oi_1
X_7242_ count_instr\[12\] net741 net740 count_instr\[44\]
+ count_cycle\[44\] net742 VSS VSS VDD VDD _3154_ sky130_fd_sc_hd__a222oi_1
X_7243_ count_cycle\[12\] net686 VSS VSS VDD VDD _3155_ sky130_fd_sc_hd__nand2_1
X_7244_ _3154_ _3155_ VSS VSS VDD VDD _3156_ sky130_fd_sc_hd__nand2_1
X_7245_ net729 net746 net749 _3156_ net685 VSS VSS VDD VDD
+ _3157_ sky130_fd_sc_hd__a221oi_1
X_7246_ _0104_ VSS VSS VDD VDD _3158_ sky130_fd_sc_hd__inv_1
X_7247_ _0495_ _2888_ _2891_ _0494_ VSS VSS VDD VDD _3159_
+ sky130_fd_sc_hd__a31oi_1
X_7248_ _3158_ _3159_ _0103_ VSS VSS VDD VDD _3160_ sky130_fd_sc_hd__o21bai_1
X_7249_ _0131_ _3160_ _0130_ VSS VSS VDD VDD _3161_ sky130_fd_sc_hd__a21o_1
X_7250_ _0290_ _3161_ _0289_ VSS VSS VDD VDD _3162_ sky130_fd_sc_hd__a21oi_1
X_7251_ _0497_ _3162_ VSS VSS VDD VDD _3163_ sky130_fd_sc_hd__xnor2_1
X_7252_ net748 _3163_ VSS VSS VDD VDD _3164_ sky130_fd_sc_hd__nand2_1
X_7253_ net158 _2870_ _3143_ net141 VSS VSS VDD VDD _3165_
+ sky130_fd_sc_hd__a22o_1
X_7254_ _3134_ _3165_ _2880_ VSS VSS VDD VDD _3166_ sky130_fd_sc_hd__a21oi_1
X_7255_ _3157_ _3164_ _3166_ VSS VSS VDD VDD _0007_ sky130_fd_sc_hd__a21oi_1
X_7256_ count_instr\[11\] net741 net740 count_instr\[43\]
+ count_cycle\[43\] net742 VSS VSS VDD VDD _3167_ sky130_fd_sc_hd__a222oi_1
X_7257_ count_cycle\[11\] net686 VSS VSS VDD VDD _3168_ sky130_fd_sc_hd__nand2_1
X_7258_ _3167_ _3168_ VSS VSS VDD VDD _3169_ sky130_fd_sc_hd__nand2_1
X_7259_ net730 net746 net749 _3169_ net685 VSS VSS VDD VDD
+ _3170_ sky130_fd_sc_hd__a221oi_1
X_7260_ _0495_ _2956_ _2960_ _0494_ VSS VSS VDD VDD _3171_
+ sky130_fd_sc_hd__a31oi_1
X_7261_ _3158_ _3171_ _0103_ VSS VSS VDD VDD _3172_ sky130_fd_sc_hd__o21bai_1
X_7262_ _0131_ _3172_ _0130_ VSS VSS VDD VDD _3173_ sky130_fd_sc_hd__a21oi_1
X_7263_ _0290_ _3173_ VSS VSS VDD VDD _3174_ sky130_fd_sc_hd__xnor2_1
X_7264_ net748 _3174_ VSS VSS VDD VDD _3175_ sky130_fd_sc_hd__nand2_1
X_7265_ net157 _2870_ _3143_ net140 VSS VSS VDD VDD _3176_
+ sky130_fd_sc_hd__a22o_1
X_7266_ _3134_ _3176_ _2880_ VSS VSS VDD VDD _3177_ sky130_fd_sc_hd__a21oi_1
X_7267_ _3170_ _3175_ _3177_ VSS VSS VDD VDD _0006_ sky130_fd_sc_hd__a21oi_1
X_7268_ count_instr\[10\] net741 net740 count_instr\[42\]
+ count_cycle\[42\] net742 VSS VSS VDD VDD _3178_ sky130_fd_sc_hd__a222oi_1
X_7269_ count_cycle\[10\] net686 VSS VSS VDD VDD _3179_ sky130_fd_sc_hd__nand2_1
X_7270_ _3178_ _3179_ VSS VSS VDD VDD _3180_ sky130_fd_sc_hd__nand2_1
X_7271_ net731 net746 net749 _3180_ net685 VSS VSS VDD VDD
+ _3181_ sky130_fd_sc_hd__a221oi_1
X_7272_ _0131_ _3160_ VSS VSS VDD VDD _3182_ sky130_fd_sc_hd__xor2_1
X_7273_ net748 _3182_ VSS VSS VDD VDD _3183_ sky130_fd_sc_hd__nand2_1
X_7274_ net156 _2870_ _3143_ net139 VSS VSS VDD VDD _3184_
+ sky130_fd_sc_hd__a22o_1
X_7275_ _3134_ _3184_ _2880_ VSS VSS VDD VDD _3185_ sky130_fd_sc_hd__a21oi_1
X_7276_ _3181_ _3183_ _3185_ VSS VSS VDD VDD _0005_ sky130_fd_sc_hd__a21oi_1
X_7277_ count_instr\[9\] net741 net740 count_instr\[41\] count_cycle\[41\]
+ net742 VSS VSS VDD VDD _3186_ sky130_fd_sc_hd__a222oi_1
X_7278_ count_cycle\[9\] net686 VSS VSS VDD VDD _3187_ sky130_fd_sc_hd__nand2_1
X_7279_ _3186_ _3187_ VSS VSS VDD VDD _3188_ sky130_fd_sc_hd__nand2_1
X_7280_ net702 net746 net749 _3188_ net685 VSS VSS VDD VDD
+ _3189_ sky130_fd_sc_hd__a221oi_1
X_7281_ _0104_ _3171_ VSS VSS VDD VDD _3190_ sky130_fd_sc_hd__xnor2_1
X_7282_ net748 _3190_ VSS VSS VDD VDD _3191_ sky130_fd_sc_hd__nand2_1
X_7283_ net155 _2870_ _3143_ net169 VSS VSS VDD VDD _3192_
+ sky130_fd_sc_hd__a22o_1
X_7284_ _3134_ _3192_ _2880_ VSS VSS VDD VDD _3193_ sky130_fd_sc_hd__a21oi_1
X_7285_ _3189_ _3191_ _3193_ VSS VSS VDD VDD _0035_ sky130_fd_sc_hd__a21oi_1
X_7286_ count_instr\[8\] net741 net740 count_instr\[40\] count_cycle\[40\]
+ net742 VSS VSS VDD VDD _3194_ sky130_fd_sc_hd__a222oi_1
X_7287_ count_cycle\[8\] net686 VSS VSS VDD VDD _3195_ sky130_fd_sc_hd__nand2_1
X_7288_ _3194_ _3195_ VSS VSS VDD VDD _3196_ sky130_fd_sc_hd__nand2_1
X_7289_ net703 net746 net749 _3196_ net685 VSS VSS VDD VDD
+ _3197_ sky130_fd_sc_hd__a221oi_1
X_7290_ _0495_ _2892_ VSS VSS VDD VDD _3198_ sky130_fd_sc_hd__xor2_1
X_7291_ net748 _3198_ VSS VSS VDD VDD _3199_ sky130_fd_sc_hd__nand2_1
X_7292_ net154 _2870_ _3143_ net168 VSS VSS VDD VDD _3200_
+ sky130_fd_sc_hd__a22o_1
X_7293_ _3134_ _3200_ _2880_ VSS VSS VDD VDD _3201_ sky130_fd_sc_hd__a21oi_1
X_7294_ _3197_ _3199_ _3201_ VSS VSS VDD VDD _0034_ sky130_fd_sc_hd__a21oi_1
X_7295_ _0356_ VSS VSS VDD VDD _3202_ sky130_fd_sc_hd__inv_1
X_7296_ _0067_ _0364_ _0363_ VSS VSS VDD VDD _3203_ sky130_fd_sc_hd__a21oi_1
X_7297_ _2883_ _3203_ VSS VSS VDD VDD _3204_ sky130_fd_sc_hd__nor2_1
X_7298_ _0437_ _3204_ _0357_ VSS VSS VDD VDD _3205_ sky130_fd_sc_hd__o21ai_0
X_7299_ _3202_ _3205_ VSS VSS VDD VDD _3206_ sky130_fd_sc_hd__nand2_1
X_7300_ _0362_ _3206_ _0361_ VSS VSS VDD VDD _3207_ sky130_fd_sc_hd__a21oi_1
X_7301_ _0410_ _3207_ VSS VSS VDD VDD _3208_ sky130_fd_sc_hd__xnor2_1
X_7302_ net748 _3208_ VSS VSS VDD VDD _3209_ sky130_fd_sc_hd__nand2_1
X_7303_ count_instr\[7\] net741 net740 count_instr\[39\] count_cycle\[39\]
+ net742 VSS VSS VDD VDD _3210_ sky130_fd_sc_hd__a222oi_1
X_7304_ count_cycle\[7\] net686 VSS VSS VDD VDD _3211_ sky130_fd_sc_hd__nand2_1
X_7305_ _3210_ _3211_ VSS VSS VDD VDD _3212_ sky130_fd_sc_hd__nand2_1
X_7306_ net704 net746 net749 _3212_ net685 VSS VSS VDD VDD
+ _3213_ sky130_fd_sc_hd__a221oi_1
X_7307_ _3209_ _3213_ _2878_ VSS VSS VDD VDD _0033_ sky130_fd_sc_hd__a21oi_1
Xoutput346 net344 VSS VSS VDD VDD pcpi_rs2[14] sky130_fd_sc_hd__clkdlybuf4s50_1
X_7309_ count_instr\[6\] net741 net740 count_instr\[38\] count_cycle\[38\]
+ net742 VSS VSS VDD VDD _3215_ sky130_fd_sc_hd__a222oi_1
X_7310_ count_cycle\[6\] net686 VSS VSS VDD VDD _3216_ sky130_fd_sc_hd__nand2_1
X_7311_ _3215_ _3216_ VSS VSS VDD VDD _3217_ sky130_fd_sc_hd__nand2_1
X_7312_ net705 net746 net749 _3217_ net685 VSS VSS VDD VDD
+ _3218_ sky130_fd_sc_hd__a221oi_1
X_7313_ _2883_ _2885_ VSS VSS VDD VDD _3219_ sky130_fd_sc_hd__nor2_1
X_7314_ _0437_ _3219_ _0357_ VSS VSS VDD VDD _3220_ sky130_fd_sc_hd__o21ai_0
X_7315_ _3202_ _3220_ VSS VSS VDD VDD _3221_ sky130_fd_sc_hd__nand2_1
X_7316_ _0362_ _3221_ VSS VSS VDD VDD _3222_ sky130_fd_sc_hd__xor2_1
X_7317_ net748 _3222_ VSS VSS VDD VDD _3223_ sky130_fd_sc_hd__nand2_1
X_7318_ _0485_ net734 mem_wordsize\[2\] VSS VSS VDD VDD _3224_
+ sky130_fd_sc_hd__a21oi_1
X_7319_ _0055_ _3224_ VSS VSS VDD VDD _3225_ sky130_fd_sc_hd__nor2_1
X_7320_ net308 net734 VSS VSS VDD VDD _3226_ sky130_fd_sc_hd__nand2_1
X_7321_ net143 net161 net721 VSS VSS VDD VDD _3227_ sky130_fd_sc_hd__mux2i_1
X_7322_ _3226_ _3227_ _2936_ VSS VSS VDD VDD _3228_ sky130_fd_sc_hd__o21ai_0
X_7323_ net166 net267 _3225_ net152 _3228_ VSS VSS VDD VDD
+ _3229_ sky130_fd_sc_hd__a221oi_1
X_7324_ _3218_ _3223_ _3229_ VSS VSS VDD VDD _0032_ sky130_fd_sc_hd__a21oi_1
X_7325_ net706 net746 net685 VSS VSS VDD VDD _3230_ sky130_fd_sc_hd__a21oi_1
X_7326_ _0357_ _0437_ _3204_ VSS VSS VDD VDD _3231_ sky130_fd_sc_hd__or3_1
X_7327_ count_instr\[5\] net741 net740 count_instr\[37\] count_cycle\[37\]
+ net742 VSS VSS VDD VDD _3232_ sky130_fd_sc_hd__a222oi_1
X_7328_ count_cycle\[5\] net686 VSS VSS VDD VDD _3233_ sky130_fd_sc_hd__nand2_1
X_7329_ _3232_ _3233_ VSS VSS VDD VDD _3234_ sky130_fd_sc_hd__nand2_1
X_7330_ net748 _3205_ _3231_ _3234_ net749 VSS VSS VDD VDD
+ _3235_ sky130_fd_sc_hd__a32oi_1
X_7331_ net142 net159 net721 VSS VSS VDD VDD _3236_ sky130_fd_sc_hd__mux2i_1
X_7332_ _3226_ _3236_ _2936_ VSS VSS VDD VDD _3237_ sky130_fd_sc_hd__o21ai_0
X_7333_ net165 net267 _3225_ net151 _3237_ VSS VSS VDD VDD
+ _3238_ sky130_fd_sc_hd__a221oi_1
X_7334_ _3230_ _3235_ _3238_ VSS VSS VDD VDD _0031_ sky130_fd_sc_hd__a21oi_1
X_7335_ count_instr\[4\] net741 net740 count_instr\[36\] count_cycle\[36\]
+ net742 VSS VSS VDD VDD _3239_ sky130_fd_sc_hd__a222oi_1
X_7336_ count_cycle\[4\] net686 VSS VSS VDD VDD _3240_ sky130_fd_sc_hd__nand2_1
X_7337_ _3239_ _3240_ VSS VSS VDD VDD _3241_ sky130_fd_sc_hd__nand2_1
X_7338_ net707 net746 net749 _3241_ net685 VSS VSS VDD VDD
+ _3242_ sky130_fd_sc_hd__a221oi_1
X_7339_ _0438_ _2885_ VSS VSS VDD VDD _3243_ sky130_fd_sc_hd__xnor2_1
X_7340_ net748 _3243_ VSS VSS VDD VDD _3244_ sky130_fd_sc_hd__nand2_1
X_7341_ net141 net158 net721 VSS VSS VDD VDD _3245_ sky130_fd_sc_hd__mux2i_1
X_7342_ _3226_ _3245_ _2936_ VSS VSS VDD VDD _3246_ sky130_fd_sc_hd__o21ai_0
X_7343_ net164 net267 _3225_ net150 _3246_ VSS VSS VDD VDD
+ _3247_ sky130_fd_sc_hd__a221oi_1
X_7344_ _3242_ _3244_ _3247_ VSS VSS VDD VDD _0030_ sky130_fd_sc_hd__a21oi_1
X_7345_ net140 net157 net721 VSS VSS VDD VDD _3248_ sky130_fd_sc_hd__mux2i_1
X_7346_ _3226_ _3248_ VSS VSS VDD VDD _3249_ sky130_fd_sc_hd__nor2_1
X_7347_ net163 net267 _3225_ net148 _3249_ VSS VSS VDD VDD
+ _3250_ sky130_fd_sc_hd__a221oi_1
X_7348_ count_instr\[3\] net741 net740 count_instr\[35\] count_cycle\[35\]
+ net742 VSS VSS VDD VDD _3251_ sky130_fd_sc_hd__a222oi_1
X_7349_ count_cycle\[3\] net686 VSS VSS VDD VDD _3252_ sky130_fd_sc_hd__nand2_1
X_7350_ _3251_ _3252_ VSS VSS VDD VDD _3253_ sky130_fd_sc_hd__nand2_1
X_7351_ _0067_ _0364_ VSS VSS VDD VDD _3254_ sky130_fd_sc_hd__xor2_1
X_7352_ net708 net746 net749 _3253_ _3254_ net748 VSS VSS
+ VDD VDD _3255_ sky130_fd_sc_hd__a222oi_1
X_7353_ _2876_ _3250_ _3255_ VSS VSS VDD VDD _0029_ sky130_fd_sc_hd__o21ai_0
X_7354_ net139 net156 net721 VSS VSS VDD VDD _3256_ sky130_fd_sc_hd__mux2i_1
X_7355_ _3226_ _3256_ VSS VSS VDD VDD _3257_ sky130_fd_sc_hd__nor2_1
X_7356_ net160 net267 _3225_ net147 _3257_ VSS VSS VDD VDD
+ _3258_ sky130_fd_sc_hd__a221oi_1
X_7357_ count_instr\[2\] net741 net740 count_instr\[34\] count_cycle\[34\]
+ net742 VSS VSS VDD VDD _3259_ sky130_fd_sc_hd__a222oi_1
X_7358_ count_cycle\[2\] net686 VSS VSS VDD VDD _3260_ sky130_fd_sc_hd__nand2_1
X_7359_ _3259_ _3260_ VSS VSS VDD VDD _3261_ sky130_fd_sc_hd__nand2_1
X_7360_ net711 net746 net749 _3261_ _0068_ net748 VSS VSS
+ VDD VDD _3262_ sky130_fd_sc_hd__a222oi_1
X_7361_ _2876_ _3258_ _3262_ VSS VSS VDD VDD _0026_ sky130_fd_sc_hd__o21ai_0
X_7362_ net169 net155 net721 VSS VSS VDD VDD _3263_ sky130_fd_sc_hd__mux2i_1
X_7363_ _3226_ _3263_ VSS VSS VDD VDD _3264_ sky130_fd_sc_hd__nor2_1
X_7364_ net149 net267 _3225_ net146 _3264_ VSS VSS VDD VDD
+ _3265_ sky130_fd_sc_hd__a221oi_1
X_7365_ count_instr\[1\] net741 net740 count_instr\[33\] count_cycle\[33\]
+ net742 VSS VSS VDD VDD _3266_ sky130_fd_sc_hd__a222oi_1
X_7366_ count_cycle\[1\] net686 VSS VSS VDD VDD _3267_ sky130_fd_sc_hd__nand2_1
X_7367_ _3266_ _3267_ VSS VSS VDD VDD _3268_ sky130_fd_sc_hd__nand2_1
X_7368_ net319 net746 net749 _3268_ _0358_ net748 VSS VSS
+ VDD VDD _3269_ sky130_fd_sc_hd__a222oi_1
X_7369_ _2876_ _3265_ _3269_ VSS VSS VDD VDD _0015_ sky130_fd_sc_hd__o21ai_0
X_7370_ net168 net154 net721 VSS VSS VDD VDD _3270_ sky130_fd_sc_hd__mux2i_1
X_7371_ _3226_ _3270_ VSS VSS VDD VDD _3271_ sky130_fd_sc_hd__nor2_1
X_7372_ net138 net267 _3225_ net145 _3271_ VSS VSS VDD VDD
+ _3272_ sky130_fd_sc_hd__a221oi_1
X_7373_ count_instr\[0\] net741 net740 count_instr\[32\] count_cycle\[32\]
+ net742 VSS VSS VDD VDD _3273_ sky130_fd_sc_hd__a222oi_1
X_7374_ count_cycle\[0\] net686 VSS VSS VDD VDD _3274_ sky130_fd_sc_hd__nand2_1
X_7375_ _3273_ _3274_ VSS VSS VDD VDD _3275_ sky130_fd_sc_hd__nand2_1
X_7376_ net732 net747 net749 _3275_ decoded_imm\[0\] net748
+ VSS VSS VDD VDD _3276_ sky130_fd_sc_hd__a222oi_1
X_7377_ _2876_ _3272_ _3276_ VSS VSS VDD VDD _0004_ sky130_fd_sc_hd__o21ai_0
X_7378_ net346 VSS VSS VDD VDD _0341_ sky130_fd_sc_hd__inv_1
X_7379_ mem_state\[1\] VSS VSS VDD VDD _0499_ sky130_fd_sc_hd__inv_1
X_7380_ net712 VSS VSS VDD VDD _0475_ sky130_fd_sc_hd__inv_1
X_7381_ net329 VSS VSS VDD VDD _0269_ sky130_fd_sc_hd__inv_1
X_7382_ net725 VSS VSS VDD VDD _0340_ sky130_fd_sc_hd__inv_1
X_7383_ mem_rdata_q\[14\] VSS VSS VDD VDD _3277_ sky130_fd_sc_hd__inv_1
X_7384_ net698 VSS VSS VDD VDD _3278_ sky130_fd_sc_hd__inv_2
X_7385_ net143 _3278_ VSS VSS VDD VDD _3279_ sky130_fd_sc_hd__nand2_1
X_7386_ _3277_ _3278_ _3279_ VSS VSS VDD VDD mem_rdata_latched\[14\]
+ sky130_fd_sc_hd__o21ai_0
X_7387_ net141 _3278_ VSS VSS VDD VDD _3280_ sky130_fd_sc_hd__nand2_1
Xoutput345 net343 VSS VSS VDD VDD pcpi_rs2[13] sky130_fd_sc_hd__clkdlybuf4s50_1
X_7389_ mem_rdata_q\[12\] net698 VSS VSS VDD VDD _3282_ sky130_fd_sc_hd__nand2_1
X_7390_ _3280_ _3282_ VSS VSS VDD VDD mem_rdata_latched\[12\]
+ sky130_fd_sc_hd__nand2_1
X_7391_ net142 _3278_ VSS VSS VDD VDD _3283_ sky130_fd_sc_hd__nand2_1
Xoutput344 net342 VSS VSS VDD VDD pcpi_rs2[12] sky130_fd_sc_hd__clkdlybuf4s50_1
Xoutput343 net341 VSS VSS VDD VDD pcpi_rs2[11] sky130_fd_sc_hd__clkdlybuf4s50_1
X_7394_ mem_rdata_q\[13\] net698 VSS VSS VDD VDD _3286_ sky130_fd_sc_hd__nand2_1
X_7395_ _3283_ _3286_ VSS VSS VDD VDD mem_rdata_latched\[13\]
+ sky130_fd_sc_hd__nand2_1
Xoutput342 net340 VSS VSS VDD VDD pcpi_rs2[10] sky130_fd_sc_hd__clkdlybuf4s50_1
Xoutput341 net234 VSS VSS VDD VDD pcpi_rs2[0] sky130_fd_sc_hd__clkdlybuf4s50_1
Xoutput340 net702 VSS VSS VDD VDD pcpi_rs1[9] sky130_fd_sc_hd__clkdlybuf4s50_1
X_7399_ net161 net677 VSS VSS VDD VDD _3289_ sky130_fd_sc_hd__nand2_1
Xoutput339 net703 VSS VSS VDD VDD pcpi_rs1[8] sky130_fd_sc_hd__clkdlybuf4s50_1
Xoutput338 net704 VSS VSS VDD VDD pcpi_rs1[7] sky130_fd_sc_hd__clkdlybuf4s50_1
X_7402_ mem_rdata_q\[30\] net698 VSS VSS VDD VDD _3292_ sky130_fd_sc_hd__nand2_1
X_7403_ _3289_ _3292_ VSS VSS VDD VDD mem_rdata_latched\[30\]
+ sky130_fd_sc_hd__nand2_1
X_7404_ net159 net677 VSS VSS VDD VDD _3293_ sky130_fd_sc_hd__nand2_1
Xoutput337 net705 VSS VSS VDD VDD pcpi_rs1[6] sky130_fd_sc_hd__clkdlybuf4s50_1
X_7406_ mem_rdata_q\[29\] net698 VSS VSS VDD VDD _3295_ sky130_fd_sc_hd__nand2_1
X_7407_ _3293_ _3295_ VSS VSS VDD VDD mem_rdata_latched\[29\]
+ sky130_fd_sc_hd__nand2_1
X_7408_ net158 net677 VSS VSS VDD VDD _3296_ sky130_fd_sc_hd__nand2_1
X_7409_ mem_rdata_q\[28\] net698 VSS VSS VDD VDD _3297_ sky130_fd_sc_hd__nand2_1
X_7410_ _3296_ _3297_ VSS VSS VDD VDD mem_rdata_latched\[28\]
+ sky130_fd_sc_hd__nand2_1
X_7411_ net157 net677 VSS VSS VDD VDD _3298_ sky130_fd_sc_hd__nand2_1
Xoutput336 net706 VSS VSS VDD VDD pcpi_rs1[5] sky130_fd_sc_hd__clkdlybuf4s50_1
X_7413_ net735 net698 VSS VSS VDD VDD _3300_ sky130_fd_sc_hd__nand2_1
X_7414_ _3298_ _3300_ VSS VSS VDD VDD mem_rdata_latched\[27\]
+ sky130_fd_sc_hd__nand2_1
X_7415_ net156 net677 VSS VSS VDD VDD _3301_ sky130_fd_sc_hd__nand2_1
X_7416_ mem_rdata_q\[26\] net698 VSS VSS VDD VDD _3302_ sky130_fd_sc_hd__nand2_1
X_7417_ _3301_ _3302_ VSS VSS VDD VDD mem_rdata_latched\[26\]
+ sky130_fd_sc_hd__nand2_1
X_7418_ net155 net677 VSS VSS VDD VDD _3303_ sky130_fd_sc_hd__nand2_1
X_7419_ mem_rdata_q\[25\] net698 VSS VSS VDD VDD _3304_ sky130_fd_sc_hd__nand2_1
X_7420_ _3303_ _3304_ VSS VSS VDD VDD mem_rdata_latched\[25\]
+ sky130_fd_sc_hd__nand2_1
X_7421_ net154 net677 VSS VSS VDD VDD _3305_ sky130_fd_sc_hd__nand2_1
X_7422_ mem_rdata_q\[24\] net698 VSS VSS VDD VDD _3306_ sky130_fd_sc_hd__nand2_1
X_7423_ _3305_ _3306_ VSS VSS VDD VDD mem_rdata_latched\[24\]
+ sky130_fd_sc_hd__nand2_1
X_7424_ net153 net677 VSS VSS VDD VDD _3307_ sky130_fd_sc_hd__nand2_1
X_7425_ mem_rdata_q\[23\] net698 VSS VSS VDD VDD _3308_ sky130_fd_sc_hd__nand2_1
X_7426_ _3307_ _3308_ VSS VSS VDD VDD mem_rdata_latched\[23\]
+ sky130_fd_sc_hd__nand2_1
X_7427_ net152 net677 VSS VSS VDD VDD _3309_ sky130_fd_sc_hd__nand2_1
X_7428_ mem_rdata_q\[22\] net698 VSS VSS VDD VDD _3310_ sky130_fd_sc_hd__nand2_1
X_7429_ _3309_ _3310_ VSS VSS VDD VDD mem_rdata_latched\[22\]
+ sky130_fd_sc_hd__nand2_1
X_7430_ net151 net677 VSS VSS VDD VDD _3311_ sky130_fd_sc_hd__nand2_1
X_7431_ mem_rdata_q\[21\] net698 VSS VSS VDD VDD _3312_ sky130_fd_sc_hd__nand2_1
X_7432_ _3311_ _3312_ VSS VSS VDD VDD mem_rdata_latched\[21\]
+ sky130_fd_sc_hd__nand2_1
X_7433_ net150 net677 VSS VSS VDD VDD _3313_ sky130_fd_sc_hd__nand2_1
X_7434_ mem_rdata_q\[20\] net698 VSS VSS VDD VDD _3314_ sky130_fd_sc_hd__nand2_1
X_7435_ _3313_ _3314_ VSS VSS VDD VDD mem_rdata_latched\[20\]
+ sky130_fd_sc_hd__nand2_1
X_7436_ net148 net677 VSS VSS VDD VDD _3315_ sky130_fd_sc_hd__nand2_1
X_7437_ mem_rdata_q\[19\] net698 VSS VSS VDD VDD _3316_ sky130_fd_sc_hd__nand2_1
X_7438_ _3315_ _3316_ VSS VSS VDD VDD mem_rdata_latched\[19\]
+ sky130_fd_sc_hd__nand2_1
X_7439_ net147 net677 VSS VSS VDD VDD _3317_ sky130_fd_sc_hd__nand2_1
X_7440_ mem_rdata_q\[18\] net698 VSS VSS VDD VDD _3318_ sky130_fd_sc_hd__nand2_1
X_7441_ _3317_ _3318_ VSS VSS VDD VDD mem_rdata_latched\[18\]
+ sky130_fd_sc_hd__nand2_1
X_7442_ net146 net677 VSS VSS VDD VDD _3319_ sky130_fd_sc_hd__nand2_1
X_7443_ mem_rdata_q\[17\] net698 VSS VSS VDD VDD _3320_ sky130_fd_sc_hd__nand2_1
X_7444_ _3319_ _3320_ VSS VSS VDD VDD mem_rdata_latched\[17\]
+ sky130_fd_sc_hd__nand2_1
X_7445_ net145 net677 VSS VSS VDD VDD _3321_ sky130_fd_sc_hd__nand2_1
X_7446_ mem_rdata_q\[16\] net698 VSS VSS VDD VDD _3322_ sky130_fd_sc_hd__nand2_1
X_7447_ _3321_ _3322_ VSS VSS VDD VDD mem_rdata_latched\[16\]
+ sky130_fd_sc_hd__nand2_1
X_7448_ net144 net677 VSS VSS VDD VDD _3323_ sky130_fd_sc_hd__nand2_1
X_7449_ mem_rdata_q\[15\] net698 VSS VSS VDD VDD _3324_ sky130_fd_sc_hd__nand2_1
X_7450_ _3323_ _3324_ VSS VSS VDD VDD mem_rdata_latched\[15\]
+ sky130_fd_sc_hd__nand2_1
X_7451_ net140 net677 VSS VSS VDD VDD _3325_ sky130_fd_sc_hd__nand2_1
X_7452_ mem_rdata_q\[11\] net698 VSS VSS VDD VDD _3326_ sky130_fd_sc_hd__nand2_1
X_7453_ _3325_ _3326_ VSS VSS VDD VDD mem_rdata_latched\[11\]
+ sky130_fd_sc_hd__nand2_1
X_7454_ net139 net677 VSS VSS VDD VDD _3327_ sky130_fd_sc_hd__nand2_1
X_7455_ mem_rdata_q\[10\] net698 VSS VSS VDD VDD _3328_ sky130_fd_sc_hd__nand2_1
X_7456_ _3327_ _3328_ VSS VSS VDD VDD mem_rdata_latched\[10\]
+ sky130_fd_sc_hd__nand2_1
X_7457_ net169 net677 VSS VSS VDD VDD _3329_ sky130_fd_sc_hd__nand2_1
X_7458_ mem_rdata_q\[9\] net698 VSS VSS VDD VDD _3330_ sky130_fd_sc_hd__nand2_1
X_7459_ _3329_ _3330_ VSS VSS VDD VDD mem_rdata_latched\[9\]
+ sky130_fd_sc_hd__nand2_1
X_7460_ net168 net677 VSS VSS VDD VDD _3331_ sky130_fd_sc_hd__nand2_1
X_7461_ mem_rdata_q\[8\] net698 VSS VSS VDD VDD _3332_ sky130_fd_sc_hd__nand2_1
X_7462_ _3331_ _3332_ VSS VSS VDD VDD mem_rdata_latched\[8\]
+ sky130_fd_sc_hd__nand2_1
X_7463_ net167 net677 VSS VSS VDD VDD _3333_ sky130_fd_sc_hd__nand2_1
X_7464_ mem_rdata_q\[7\] net698 VSS VSS VDD VDD _3334_ sky130_fd_sc_hd__nand2_1
X_7465_ _3333_ _3334_ VSS VSS VDD VDD mem_rdata_latched\[7\]
+ sky130_fd_sc_hd__nand2_1
Xoutput335 net707 VSS VSS VDD VDD pcpi_rs1[4] sky130_fd_sc_hd__clkdlybuf4s50_1
Xoutput334 net708 VSS VSS VDD VDD pcpi_rs1[3] sky130_fd_sc_hd__clkdlybuf4s50_1
X_7468_ reg_out\[30\] _0886_ VSS VSS VDD VDD _3337_ sky130_fd_sc_hd__nand2_1
Xoutput333 net709 VSS VSS VDD VDD pcpi_rs1[31] sky130_fd_sc_hd__clkdlybuf4s50_1
X_7470_ net331 net695 VSS VSS VDD VDD _3339_ sky130_fd_sc_hd__nor2_1
X_7471_ _0957_ net695 _3337_ _3339_ VSS VSS VDD VDD net224
+ sky130_fd_sc_hd__a31oi_1
X_7472_ reg_out\[29\] _0886_ VSS VSS VDD VDD _3340_ sky130_fd_sc_hd__nand2_1
Xoutput332 net710 VSS VSS VDD VDD pcpi_rs1[30] sky130_fd_sc_hd__clkdlybuf4s50_1
X_7474_ net329 net695 VSS VSS VDD VDD _3342_ sky130_fd_sc_hd__nor2_1
X_7475_ _0954_ net695 _3340_ _3342_ VSS VSS VDD VDD net222
+ sky130_fd_sc_hd__a31oi_1
X_7476_ reg_out\[28\] _0886_ VSS VSS VDD VDD _3343_ sky130_fd_sc_hd__nand2_1
X_7477_ net328 net695 VSS VSS VDD VDD _3344_ sky130_fd_sc_hd__nor2_1
X_7478_ _0951_ net695 _3343_ _3344_ VSS VSS VDD VDD net221
+ sky130_fd_sc_hd__a31oi_1
X_7479_ reg_out\[27\] _0886_ VSS VSS VDD VDD _3345_ sky130_fd_sc_hd__nand2_1
X_7480_ net327 net695 VSS VSS VDD VDD _3346_ sky130_fd_sc_hd__nor2_1
X_7481_ _0949_ net695 _3345_ _3346_ VSS VSS VDD VDD net220
+ sky130_fd_sc_hd__a31oi_1
Xoutput331 net711 VSS VSS VDD VDD pcpi_rs1[2] sky130_fd_sc_hd__clkdlybuf4s50_1
X_7483_ reg_next_pc\[26\] net697 VSS VSS VDD VDD _3348_ sky130_fd_sc_hd__nand2_1
Xoutput330 net329 VSS VSS VDD VDD pcpi_rs1[29] sky130_fd_sc_hd__clkdlybuf4s50_1
X_7485_ reg_out\[26\] _0886_ VSS VSS VDD VDD _3350_ sky130_fd_sc_hd__nand2_1
X_7486_ net326 net695 VSS VSS VDD VDD _3351_ sky130_fd_sc_hd__nor2_1
X_7487_ _3348_ net695 _3350_ _3351_ VSS VSS VDD VDD net219
+ sky130_fd_sc_hd__a31oi_1
Xoutput329 net712 VSS VSS VDD VDD pcpi_rs1[28] sky130_fd_sc_hd__clkdlybuf4s50_1
X_7489_ reg_out\[25\] _0886_ VSS VSS VDD VDD _3353_ sky130_fd_sc_hd__nand2_1
X_7490_ net325 net695 VSS VSS VDD VDD _3354_ sky130_fd_sc_hd__nor2_1
X_7491_ _0945_ net695 _3353_ _3354_ VSS VSS VDD VDD net218
+ sky130_fd_sc_hd__a31oi_1
Xoutput328 net713 VSS VSS VDD VDD pcpi_rs1[27] sky130_fd_sc_hd__clkdlybuf4s50_1
Xoutput327 net714 VSS VSS VDD VDD pcpi_rs1[26] sky130_fd_sc_hd__clkdlybuf4s50_1
X_7494_ reg_out\[24\] _0886_ VSS VSS VDD VDD _3357_ sky130_fd_sc_hd__nand2_1
Xoutput326 net715 VSS VSS VDD VDD pcpi_rs1[25] sky130_fd_sc_hd__clkdlybuf4s50_1
X_7496_ net324 net695 VSS VSS VDD VDD _3359_ sky130_fd_sc_hd__nor2_1
X_7497_ _0942_ net695 _3357_ _3359_ VSS VSS VDD VDD net217
+ sky130_fd_sc_hd__a31oi_1
X_7498_ reg_out\[23\] _0886_ VSS VSS VDD VDD _3360_ sky130_fd_sc_hd__nand2_1
X_7499_ net323 net695 VSS VSS VDD VDD _3361_ sky130_fd_sc_hd__nor2_1
X_7500_ _0940_ net695 _3360_ _3361_ VSS VSS VDD VDD net216
+ sky130_fd_sc_hd__a31oi_1
X_7501_ reg_next_pc\[22\] net697 VSS VSS VDD VDD _3362_ sky130_fd_sc_hd__nand2_1
X_7502_ reg_out\[22\] _0886_ VSS VSS VDD VDD _3363_ sky130_fd_sc_hd__nand2_1
X_7503_ net322 net695 VSS VSS VDD VDD _3364_ sky130_fd_sc_hd__nor2_1
X_7504_ _3362_ net695 _3363_ _3364_ VSS VSS VDD VDD net215
+ sky130_fd_sc_hd__a31oi_1
X_7505_ reg_next_pc\[21\] net697 VSS VSS VDD VDD _3365_ sky130_fd_sc_hd__nand2_1
X_7506_ reg_out\[21\] _0886_ VSS VSS VDD VDD _3366_ sky130_fd_sc_hd__nand2_1
X_7507_ net321 net695 VSS VSS VDD VDD _3367_ sky130_fd_sc_hd__nor2_1
X_7508_ _3365_ net695 _3366_ _3367_ VSS VSS VDD VDD net214
+ sky130_fd_sc_hd__a31oi_1
X_7509_ reg_next_pc\[20\] net697 VSS VSS VDD VDD _3368_ sky130_fd_sc_hd__nand2_1
X_7510_ reg_out\[20\] _0886_ VSS VSS VDD VDD _3369_ sky130_fd_sc_hd__nand2_1
X_7511_ net720 net695 VSS VSS VDD VDD _3370_ sky130_fd_sc_hd__nor2_1
X_7512_ _3368_ net695 _3369_ _3370_ VSS VSS VDD VDD net213
+ sky130_fd_sc_hd__a31oi_1
X_7513_ reg_next_pc\[19\] net697 VSS VSS VDD VDD _3371_ sky130_fd_sc_hd__nand2_1
X_7514_ reg_out\[19\] _0886_ VSS VSS VDD VDD _3372_ sky130_fd_sc_hd__nand2_1
X_7515_ net318 net695 VSS VSS VDD VDD _3373_ sky130_fd_sc_hd__nor2_1
X_7516_ _3371_ net695 _3372_ _3373_ VSS VSS VDD VDD net212
+ sky130_fd_sc_hd__a31oi_1
X_7517_ reg_out\[18\] _0886_ VSS VSS VDD VDD _3374_ sky130_fd_sc_hd__nand2_1
X_7518_ net317 net695 VSS VSS VDD VDD _3375_ sky130_fd_sc_hd__nor2_1
X_7519_ _0929_ net695 _3374_ _3375_ VSS VSS VDD VDD net211
+ sky130_fd_sc_hd__a31oi_1
X_7520_ reg_out\[17\] _0886_ VSS VSS VDD VDD _3376_ sky130_fd_sc_hd__nand2_1
X_7521_ net316 net695 VSS VSS VDD VDD _3377_ sky130_fd_sc_hd__nor2_1
X_7522_ _0925_ net695 _3376_ _3377_ VSS VSS VDD VDD net210
+ sky130_fd_sc_hd__a31oi_1
X_7523_ reg_out\[16\] _0886_ VSS VSS VDD VDD _3378_ sky130_fd_sc_hd__nand2_1
X_7524_ net315 net695 VSS VSS VDD VDD _3379_ sky130_fd_sc_hd__nor2_1
X_7525_ _0922_ net695 _3378_ _3379_ VSS VSS VDD VDD net209
+ sky130_fd_sc_hd__a31oi_1
X_7526_ reg_out\[15\] _0886_ VSS VSS VDD VDD _3380_ sky130_fd_sc_hd__nand2_1
X_7527_ net314 net695 VSS VSS VDD VDD _3381_ sky130_fd_sc_hd__nor2_1
X_7528_ _0919_ net695 _3380_ _3381_ VSS VSS VDD VDD net208
+ sky130_fd_sc_hd__a31oi_1
X_7529_ reg_out\[14\] _0886_ VSS VSS VDD VDD _3382_ sky130_fd_sc_hd__nand2_1
X_7530_ net313 net695 VSS VSS VDD VDD _3383_ sky130_fd_sc_hd__nor2_1
X_7531_ _0915_ net695 _3382_ _3383_ VSS VSS VDD VDD net207
+ sky130_fd_sc_hd__a31oi_1
X_7532_ reg_next_pc\[13\] net697 VSS VSS VDD VDD _3384_ sky130_fd_sc_hd__nand2_1
X_7533_ reg_out\[13\] _0886_ VSS VSS VDD VDD _3385_ sky130_fd_sc_hd__nand2_1
X_7534_ net312 net695 VSS VSS VDD VDD _3386_ sky130_fd_sc_hd__nor2_1
X_7535_ _3384_ net695 _3385_ _3386_ VSS VSS VDD VDD net206
+ sky130_fd_sc_hd__a31oi_1
X_7536_ reg_next_pc\[12\] net697 VSS VSS VDD VDD _3387_ sky130_fd_sc_hd__nand2_1
X_7537_ reg_out\[12\] _0886_ VSS VSS VDD VDD _3388_ sky130_fd_sc_hd__nand2_1
X_7538_ net311 net695 VSS VSS VDD VDD _3389_ sky130_fd_sc_hd__nor2_1
X_7539_ _3387_ net695 _3388_ _3389_ VSS VSS VDD VDD net205
+ sky130_fd_sc_hd__a31oi_1
X_7540_ reg_next_pc\[11\] net697 VSS VSS VDD VDD _3390_ sky130_fd_sc_hd__nand2_1
X_7541_ reg_out\[11\] _0886_ VSS VSS VDD VDD _3391_ sky130_fd_sc_hd__nand2_1
X_7542_ net310 net695 VSS VSS VDD VDD _3392_ sky130_fd_sc_hd__nor2_1
X_7543_ _3390_ net695 _3391_ _3392_ VSS VSS VDD VDD net204
+ sky130_fd_sc_hd__a31oi_1
X_7544_ reg_next_pc\[10\] net697 VSS VSS VDD VDD _3393_ sky130_fd_sc_hd__nand2_1
X_7545_ reg_out\[10\] _0886_ VSS VSS VDD VDD _3394_ sky130_fd_sc_hd__nand2_1
X_7546_ net309 net695 VSS VSS VDD VDD _3395_ sky130_fd_sc_hd__nor2_1
X_7547_ _3393_ net695 _3394_ _3395_ VSS VSS VDD VDD net203
+ sky130_fd_sc_hd__a31oi_1
X_7548_ reg_next_pc\[9\] net697 VSS VSS VDD VDD _3396_ sky130_fd_sc_hd__nand2_1
X_7549_ reg_out\[9\] _0886_ VSS VSS VDD VDD _3397_ sky130_fd_sc_hd__nand2_1
X_7550_ net339 net695 VSS VSS VDD VDD _3398_ sky130_fd_sc_hd__nor2_1
X_7551_ _3396_ net695 _3397_ _3398_ VSS VSS VDD VDD net232
+ sky130_fd_sc_hd__a31oi_1
X_7552_ reg_next_pc\[8\] net697 VSS VSS VDD VDD _3399_ sky130_fd_sc_hd__nand2_1
X_7553_ reg_out\[8\] _0886_ VSS VSS VDD VDD _3400_ sky130_fd_sc_hd__nand2_1
X_7554_ net338 net695 VSS VSS VDD VDD _3401_ sky130_fd_sc_hd__nor2_1
X_7555_ _3399_ net695 _3400_ _3401_ VSS VSS VDD VDD net231
+ sky130_fd_sc_hd__a31oi_1
X_7556_ reg_next_pc\[7\] net697 VSS VSS VDD VDD _3402_ sky130_fd_sc_hd__nand2_1
X_7557_ reg_out\[7\] _0886_ VSS VSS VDD VDD _3403_ sky130_fd_sc_hd__nand2_1
X_7558_ net337 net695 VSS VSS VDD VDD _3404_ sky130_fd_sc_hd__nor2_1
X_7559_ _3402_ net695 _3403_ _3404_ VSS VSS VDD VDD net230
+ sky130_fd_sc_hd__a31oi_1
X_7560_ reg_next_pc\[6\] net697 VSS VSS VDD VDD _3405_ sky130_fd_sc_hd__nand2_1
X_7561_ reg_out\[6\] _0886_ VSS VSS VDD VDD _3406_ sky130_fd_sc_hd__nand2_1
X_7562_ net336 net695 VSS VSS VDD VDD _3407_ sky130_fd_sc_hd__nor2_1
X_7563_ _3405_ net695 _3406_ _3407_ VSS VSS VDD VDD net229
+ sky130_fd_sc_hd__a31oi_1
X_7564_ reg_next_pc\[5\] net697 VSS VSS VDD VDD _3408_ sky130_fd_sc_hd__nand2_1
X_7565_ reg_out\[5\] _0886_ VSS VSS VDD VDD _3409_ sky130_fd_sc_hd__nand2_1
X_7566_ net335 net695 VSS VSS VDD VDD _3410_ sky130_fd_sc_hd__nor2_1
X_7567_ _3408_ net695 _3409_ _3410_ VSS VSS VDD VDD net228
+ sky130_fd_sc_hd__a31oi_1
X_7568_ reg_next_pc\[4\] net697 VSS VSS VDD VDD _3411_ sky130_fd_sc_hd__nand2_1
X_7569_ reg_out\[4\] _0886_ VSS VSS VDD VDD _3412_ sky130_fd_sc_hd__nand2_1
X_7570_ net334 net695 VSS VSS VDD VDD _3413_ sky130_fd_sc_hd__nor2_1
X_7571_ _3411_ net695 _3412_ _3413_ VSS VSS VDD VDD net227
+ sky130_fd_sc_hd__a31oi_1
X_7572_ reg_next_pc\[3\] net697 VSS VSS VDD VDD _3414_ sky130_fd_sc_hd__nand2_1
X_7573_ reg_out\[3\] _0886_ VSS VSS VDD VDD _3415_ sky130_fd_sc_hd__nand2_1
X_7574_ net333 net695 VSS VSS VDD VDD _3416_ sky130_fd_sc_hd__nor2_1
X_7575_ _3414_ net695 _3415_ _3416_ VSS VSS VDD VDD net226
+ sky130_fd_sc_hd__a31oi_1
X_7576_ reg_next_pc\[2\] net697 VSS VSS VDD VDD _3417_ sky130_fd_sc_hd__nand2_1
X_7577_ reg_out\[2\] _0886_ VSS VSS VDD VDD _3418_ sky130_fd_sc_hd__nand2_1
X_7578_ net330 net695 VSS VSS VDD VDD _3419_ sky130_fd_sc_hd__nor2_1
X_7579_ _3417_ net695 _3418_ _3419_ VSS VSS VDD VDD net223
+ sky130_fd_sc_hd__a31oi_1
X_7580_ net343 VSS VSS VDD VDD _0142_ sky130_fd_sc_hd__inv_1
X_7581_ net363 VSS VSS VDD VDD _0412_ sky130_fd_sc_hd__inv_1
X_7582_ net722 VSS VSS VDD VDD _0309_ sky130_fd_sc_hd__inv_1
X_7583_ net710 VSS VSS VDD VDD _0293_ sky130_fd_sc_hd__inv_1
X_7584_ net700 VSS VSS VDD VDD _0481_ sky130_fd_sc_hd__inv_1
X_7585_ net364 net776 VSS VSS VDD VDD _3420_ sky130_fd_sc_hd__nand2b_1
X_7586_ _3420_ VSS VSS VDD VDD _0528_ sky130_fd_sc_hd__inv_1
X_7587_ net345 VSS VSS VDD VDD _0139_ sky130_fd_sc_hd__inv_1
X_7588_ instr_lui instr_auipc VSS VSS VDD VDD _3421_ sky130_fd_sc_hd__or2_2
Xoutput325 net716 VSS VSS VDD VDD pcpi_rs1[24] sky130_fd_sc_hd__clkdlybuf4s50_1
X_7590_ is_beq_bne_blt_bge_bltu_bgeu is_sb_sh_sw _1010_ VSS
+ VSS VDD VDD _3423_ sky130_fd_sc_hd__or3_1
Xoutput324 net717 VSS VSS VDD VDD pcpi_rs1[23] sky130_fd_sc_hd__clkdlybuf4s50_1
X_7592_ mem_rdata_q\[31\] _3423_ VSS VSS VDD VDD _3425_ sky130_fd_sc_hd__and2_1
Xoutput323 net718 VSS VSS VDD VDD pcpi_rs1[22] sky130_fd_sc_hd__clkdlybuf4s50_1
Xoutput322 net719 VSS VSS VDD VDD pcpi_rs1[21] sky130_fd_sc_hd__clkdlybuf4s50_1
X_7595_ net745 net743 VSS VSS VDD VDD _3428_ sky130_fd_sc_hd__nand2_1
X_7596_ _3425_ _3428_ VSS VSS VDD VDD _3429_ sky130_fd_sc_hd__nand2b_1
Xoutput321 net720 VSS VSS VDD VDD pcpi_rs1[20] sky130_fd_sc_hd__clkdlybuf4s50_1
X_7598_ mem_rdata_q\[30\] _3421_ _3429_ VSS VSS VDD VDD _0539_
+ sky130_fd_sc_hd__a21o_1
X_7599_ mem_rdata_q\[29\] _3421_ _3429_ VSS VSS VDD VDD _0540_
+ sky130_fd_sc_hd__a21o_1
X_7600_ mem_rdata_q\[28\] _3421_ _3429_ VSS VSS VDD VDD _0541_
+ sky130_fd_sc_hd__a21o_1
X_7601_ net735 _3421_ _3429_ VSS VSS VDD VDD _0542_ sky130_fd_sc_hd__a21o_1
X_7602_ mem_rdata_q\[26\] _3421_ _3429_ VSS VSS VDD VDD _0543_
+ sky130_fd_sc_hd__a21o_1
X_7603_ mem_rdata_q\[25\] _3421_ _3429_ VSS VSS VDD VDD _0544_
+ sky130_fd_sc_hd__a21o_1
X_7604_ mem_rdata_q\[24\] _3421_ _3429_ VSS VSS VDD VDD _0545_
+ sky130_fd_sc_hd__a21o_1
X_7605_ mem_rdata_q\[23\] _3421_ _3429_ VSS VSS VDD VDD _0546_
+ sky130_fd_sc_hd__a21o_1
X_7606_ mem_rdata_q\[22\] _3421_ _3429_ VSS VSS VDD VDD _0547_
+ sky130_fd_sc_hd__a21o_1
X_7607_ mem_rdata_q\[21\] _3421_ _3429_ VSS VSS VDD VDD _0548_
+ sky130_fd_sc_hd__a21o_1
Xoutput320 net721 VSS VSS VDD VDD pcpi_rs1[1] sky130_fd_sc_hd__clkdlybuf4s50_1
X_7609_ mem_rdata_q\[20\] _3421_ _3429_ VSS VSS VDD VDD _0549_
+ sky130_fd_sc_hd__a21o_1
Xoutput319 net722 VSS VSS VDD VDD pcpi_rs1[19] sky130_fd_sc_hd__clkdlybuf4s50_1
Xoutput318 net723 VSS VSS VDD VDD pcpi_rs1[18] sky130_fd_sc_hd__clkdlybuf4s50_1
X_7612_ net743 decoded_imm_j\[19\] mem_rdata_q\[19\] _3421_
+ _3425_ VSS VSS VDD VDD _0550_ sky130_fd_sc_hd__a221o_1
X_7613_ net743 decoded_imm_j\[18\] mem_rdata_q\[18\] _3421_
+ _3425_ VSS VSS VDD VDD _0551_ sky130_fd_sc_hd__a221o_1
Xoutput317 net724 VSS VSS VDD VDD pcpi_rs1[17] sky130_fd_sc_hd__clkdlybuf4s50_1
X_7615_ net743 decoded_imm_j\[17\] mem_rdata_q\[17\] _3421_
+ _3425_ VSS VSS VDD VDD _0552_ sky130_fd_sc_hd__a221o_1
X_7616_ net743 decoded_imm_j\[16\] mem_rdata_q\[16\] _3421_
+ _3425_ VSS VSS VDD VDD _0553_ sky130_fd_sc_hd__a221o_1
X_7617_ net743 decoded_imm_j\[15\] mem_rdata_q\[15\] _3421_
+ _3425_ VSS VSS VDD VDD _0554_ sky130_fd_sc_hd__a221o_1
X_7618_ net743 decoded_imm_j\[14\] mem_rdata_q\[14\] _3421_
+ _3425_ VSS VSS VDD VDD _0555_ sky130_fd_sc_hd__a221o_1
X_7619_ net743 decoded_imm_j\[13\] mem_rdata_q\[13\] _3421_
+ _3425_ VSS VSS VDD VDD _0556_ sky130_fd_sc_hd__a221o_1
X_7620_ net743 decoded_imm_j\[12\] mem_rdata_q\[12\] _3421_
+ _3425_ VSS VSS VDD VDD _0557_ sky130_fd_sc_hd__a221o_1
Xoutput316 net725 VSS VSS VDD VDD pcpi_rs1[16] sky130_fd_sc_hd__clkdlybuf4s50_1
Xoutput315 net726 VSS VSS VDD VDD pcpi_rs1[15] sky130_fd_sc_hd__clkdlybuf4s50_1
X_7623_ net743 decoded_imm_j\[11\] mem_rdata_q\[7\] is_beq_bne_blt_bge_bltu_bgeu
+ VSS VSS VDD VDD _3437_ sky130_fd_sc_hd__a22oi_1
X_7624_ is_sb_sh_sw _1010_ mem_rdata_q\[31\] VSS VSS VDD VDD
+ _3438_ sky130_fd_sc_hd__o21ai_0
X_7625_ _3437_ _3438_ VSS VSS VDD VDD _0558_ sky130_fd_sc_hd__nand2_1
X_7626_ net743 decoded_imm_j\[10\] _3423_ mem_rdata_q\[30\]
+ VSS VSS VDD VDD _0559_ sky130_fd_sc_hd__a22o_1
X_7627_ net743 decoded_imm_j\[9\] _3423_ mem_rdata_q\[29\]
+ VSS VSS VDD VDD _0560_ sky130_fd_sc_hd__a22o_1
X_7628_ net743 decoded_imm_j\[8\] _3423_ mem_rdata_q\[28\]
+ VSS VSS VDD VDD _0561_ sky130_fd_sc_hd__a22o_1
X_7629_ net743 decoded_imm_j\[7\] _3423_ net735 VSS VSS VDD
+ VDD _0562_ sky130_fd_sc_hd__a22o_1
X_7630_ net743 decoded_imm_j\[6\] _3423_ mem_rdata_q\[26\]
+ VSS VSS VDD VDD _0563_ sky130_fd_sc_hd__a22o_1
X_7631_ net743 decoded_imm_j\[5\] _3423_ mem_rdata_q\[25\]
+ VSS VSS VDD VDD _0564_ sky130_fd_sc_hd__a22o_1
X_7632_ is_beq_bne_blt_bge_bltu_bgeu VSS VSS VDD VDD _3439_
+ sky130_fd_sc_hd__inv_1
X_7633_ is_sb_sh_sw VSS VSS VDD VDD _3440_ sky130_fd_sc_hd__inv_1
X_7634_ _3439_ _3440_ VSS VSS VDD VDD _3441_ sky130_fd_sc_hd__nand2_1
X_7635_ net743 decoded_imm_j\[4\] mem_rdata_q\[11\] _3441_
+ _1010_ mem_rdata_q\[24\] VSS VSS VDD VDD _3442_ sky130_fd_sc_hd__a222oi_1
X_7636_ _3442_ VSS VSS VDD VDD _0565_ sky130_fd_sc_hd__inv_1
X_7637_ net743 decoded_imm_j\[3\] mem_rdata_q\[10\] _3441_
+ _1010_ mem_rdata_q\[23\] VSS VSS VDD VDD _3443_ sky130_fd_sc_hd__a222oi_1
X_7638_ _3443_ VSS VSS VDD VDD _0566_ sky130_fd_sc_hd__inv_1
X_7639_ net743 decoded_imm_j\[2\] mem_rdata_q\[9\] _3441_
+ _1010_ mem_rdata_q\[22\] VSS VSS VDD VDD _3444_ sky130_fd_sc_hd__a222oi_1
X_7640_ _3444_ VSS VSS VDD VDD _0567_ sky130_fd_sc_hd__inv_1
X_7641_ net743 decoded_imm_j\[1\] mem_rdata_q\[8\] _3441_
+ _1010_ mem_rdata_q\[21\] VSS VSS VDD VDD _3445_ sky130_fd_sc_hd__a222oi_1
X_7642_ _3445_ VSS VSS VDD VDD _0568_ sky130_fd_sc_hd__inv_1
Xoutput314 net727 VSS VSS VDD VDD pcpi_rs1[14] sky130_fd_sc_hd__clkdlybuf4s50_1
Xoutput313 net728 VSS VSS VDD VDD pcpi_rs1[13] sky130_fd_sc_hd__clkdlybuf4s50_1
X_7645_ count_instr\[60\] VSS VSS VDD VDD _3448_ sky130_fd_sc_hd__inv_1
X_7646_ count_instr\[53\] count_instr\[54\] count_instr\[55\]
+ VSS VSS VDD VDD _3449_ sky130_fd_sc_hd__and3_1
X_7647_ count_instr\[56\] count_instr\[57\] _3449_ VSS VSS
+ VDD VDD _3450_ sky130_fd_sc_hd__and3_1
X_7648_ count_instr\[58\] count_instr\[59\] _3450_ VSS VSS
+ VDD VDD _3451_ sky130_fd_sc_hd__nand3_1
X_7649_ _3448_ _3451_ VSS VSS VDD VDD _3452_ sky130_fd_sc_hd__nor2_1
X_7650_ count_instr\[33\] count_instr\[34\] count_instr\[35\]
+ VSS VSS VDD VDD _3453_ sky130_fd_sc_hd__and3_1
X_7651_ count_instr\[36\] count_instr\[37\] _3453_ VSS VSS
+ VDD VDD _3454_ sky130_fd_sc_hd__nand3_1
X_7652_ count_instr\[25\] count_instr\[26\] count_instr\[27\]
+ VSS VSS VDD VDD _3455_ sky130_fd_sc_hd__and3_1
X_7653_ count_instr\[28\] count_instr\[29\] _3455_ VSS VSS
+ VDD VDD _3456_ sky130_fd_sc_hd__and3_1
X_7654_ count_instr\[30\] count_instr\[31\] count_instr\[32\]
+ _3456_ VSS VSS VDD VDD _3457_ sky130_fd_sc_hd__nand4_1
X_7655_ count_instr\[22\] count_instr\[23\] count_instr\[24\]
+ VSS VSS VDD VDD _3458_ sky130_fd_sc_hd__nand3_1
X_7656_ count_instr\[10\] count_instr\[11\] count_instr\[12\]
+ count_instr\[13\] VSS VSS VDD VDD _3459_ sky130_fd_sc_hd__and4_1
X_7657_ count_instr\[14\] count_instr\[15\] count_instr\[16\]
+ _3459_ VSS VSS VDD VDD _3460_ sky130_fd_sc_hd__nand4_2
X_7658_ count_instr\[17\] count_instr\[18\] count_instr\[19\]
+ VSS VSS VDD VDD _3461_ sky130_fd_sc_hd__and3_1
X_7659_ count_instr\[20\] count_instr\[21\] _3461_ VSS VSS
+ VDD VDD _3462_ sky130_fd_sc_hd__nand3_1
X_7660_ count_instr\[2\] count_instr\[3\] count_instr\[4\]
+ VSS VSS VDD VDD _3463_ sky130_fd_sc_hd__and3_1
Xoutput312 net729 VSS VSS VDD VDD pcpi_rs1[12] sky130_fd_sc_hd__clkdlybuf4s50_1
X_7662_ cpu_state\[1\] _0359_ decoder_trigger VSS VSS VDD
+ VDD _3465_ sky130_fd_sc_hd__and3_1
X_7663_ _3463_ _3465_ VSS VSS VDD VDD _3466_ sky130_fd_sc_hd__and2_1
X_7664_ count_instr\[5\] count_instr\[6\] count_instr\[7\]
+ count_instr\[8\] VSS VSS VDD VDD _3467_ sky130_fd_sc_hd__and4_1
X_7665_ count_instr\[9\] _3466_ _3467_ VSS VSS VDD VDD _3468_
+ sky130_fd_sc_hd__nand3_1
X_7666_ _3458_ _3460_ _3462_ _3468_ VSS VSS VDD VDD _3469_
+ sky130_fd_sc_hd__or4_1
X_7667_ _3454_ _3457_ _3469_ VSS VSS VDD VDD _3470_ sky130_fd_sc_hd__or3_1
Xoutput311 net730 VSS VSS VDD VDD pcpi_rs1[11] sky130_fd_sc_hd__clkdlybuf4s50_1
X_7669_ count_instr\[46\] VSS VSS VDD VDD _3472_ sky130_fd_sc_hd__inv_1
X_7670_ count_instr\[38\] count_instr\[39\] count_instr\[40\]
+ count_instr\[41\] VSS VSS VDD VDD _3473_ sky130_fd_sc_hd__and4_1
X_7671_ count_instr\[42\] count_instr\[43\] _3473_ VSS VSS
+ VDD VDD _3474_ sky130_fd_sc_hd__and3_1
X_7672_ count_instr\[44\] count_instr\[45\] _3474_ VSS VSS
+ VDD VDD _3475_ sky130_fd_sc_hd__nand3_1
X_7673_ _3472_ _3475_ VSS VSS VDD VDD _3476_ sky130_fd_sc_hd__nor2_1
X_7674_ count_instr\[47\] count_instr\[48\] count_instr\[49\]
+ _3476_ VSS VSS VDD VDD _3477_ sky130_fd_sc_hd__and4_1
X_7675_ count_instr\[50\] count_instr\[51\] count_instr\[52\]
+ _3477_ VSS VSS VDD VDD _3478_ sky130_fd_sc_hd__nand4_1
X_7676_ _3470_ _3478_ VSS VSS VDD VDD _3479_ sky130_fd_sc_hd__nor2_1
X_7677_ count_instr\[61\] _3452_ _3479_ VSS VSS VDD VDD _3480_
+ sky130_fd_sc_hd__nand3_1
X_7678_ count_instr\[62\] _3480_ VSS VSS VDD VDD _3481_ sky130_fd_sc_hd__xnor2_1
X_7679_ net775 _3481_ VSS VSS VDD VDD _0569_ sky130_fd_sc_hd__and2_1
Xoutput310 net731 VSS VSS VDD VDD pcpi_rs1[10] sky130_fd_sc_hd__clkdlybuf4s50_1
Xoutput309 net308 VSS VSS VDD VDD pcpi_rs1[0] sky130_fd_sc_hd__clkdlybuf4s50_1
X_7682_ count_instr\[9\] _3467_ VSS VSS VDD VDD _3484_ sky130_fd_sc_hd__nand2_1
X_7683_ net750 VSS VSS VDD VDD _3485_ sky130_fd_sc_hd__inv_2
X_7684_ _3485_ _0864_ VSS VSS VDD VDD _3486_ sky130_fd_sc_hd__nor2_1
X_7685_ count_instr\[0\] count_instr\[1\] _3463_ _3486_ VSS
+ VSS VDD VDD _3487_ sky130_fd_sc_hd__nand4_1
X_7686_ _3460_ _3462_ _3484_ _3487_ VSS VSS VDD VDD _3488_
+ sky130_fd_sc_hd__nor4_1
X_7687_ _3458_ _3488_ VSS VSS VDD VDD _3489_ sky130_fd_sc_hd__and2b_1
X_7688_ _3457_ _3489_ VSS VSS VDD VDD _3490_ sky130_fd_sc_hd__nand2b_1
X_7689_ _3454_ _3478_ _3490_ VSS VSS VDD VDD _3491_ sky130_fd_sc_hd__or3_1
Xoutput308 net307 VSS VSS VDD VDD mem_wstrb[3] sky130_fd_sc_hd__clkdlybuf4s50_1
X_7691_ _3448_ _3451_ _3491_ VSS VSS VDD VDD _3493_ sky130_fd_sc_hd__nor3_1
X_7692_ count_instr\[61\] _3493_ VSS VSS VDD VDD _3494_ sky130_fd_sc_hd__xor2_1
X_7693_ net775 _3494_ VSS VSS VDD VDD _0570_ sky130_fd_sc_hd__and2_1
X_7694_ _3470_ _3478_ VSS VSS VDD VDD _3495_ sky130_fd_sc_hd__or2_2
X_7695_ _3451_ _3495_ count_instr\[60\] VSS VSS VDD VDD _3496_
+ sky130_fd_sc_hd__o21ai_0
X_7696_ count_instr\[60\] _3451_ _3495_ VSS VSS VDD VDD _3497_
+ sky130_fd_sc_hd__or3_1
Xoutput307 net306 VSS VSS VDD VDD mem_wstrb[2] sky130_fd_sc_hd__clkdlybuf4s50_1
Xoutput306 net305 VSS VSS VDD VDD mem_wstrb[1] sky130_fd_sc_hd__clkdlybuf4s50_1
X_7699_ _3496_ _3497_ net775 VSS VSS VDD VDD _0571_ sky130_fd_sc_hd__a21boi_1
X_7700_ count_instr\[58\] _3450_ VSS VSS VDD VDD _3500_ sky130_fd_sc_hd__nand2_1
X_7701_ _3500_ _3491_ count_instr\[59\] VSS VSS VDD VDD _3501_
+ sky130_fd_sc_hd__o21ai_0
X_7702_ count_instr\[59\] _3500_ _3491_ VSS VSS VDD VDD _3502_
+ sky130_fd_sc_hd__or3_1
X_7703_ _3501_ _3502_ net775 VSS VSS VDD VDD _0572_ sky130_fd_sc_hd__a21boi_0
X_7704_ _3450_ _3479_ VSS VSS VDD VDD _3503_ sky130_fd_sc_hd__nand2_1
X_7705_ count_instr\[58\] _3503_ VSS VSS VDD VDD _3504_ sky130_fd_sc_hd__xnor2_1
X_7706_ net775 _3504_ VSS VSS VDD VDD _0573_ sky130_fd_sc_hd__and2_1
X_7707_ count_instr\[56\] _3449_ VSS VSS VDD VDD _3505_ sky130_fd_sc_hd__nand2_1
X_7708_ _3505_ _3491_ count_instr\[57\] VSS VSS VDD VDD _3506_
+ sky130_fd_sc_hd__o21ai_0
X_7709_ count_instr\[57\] _3505_ _3491_ VSS VSS VDD VDD _3507_
+ sky130_fd_sc_hd__or3_1
Xoutput305 net304 VSS VSS VDD VDD mem_wstrb[0] sky130_fd_sc_hd__clkdlybuf4s50_1
X_7711_ _3506_ _3507_ net775 VSS VSS VDD VDD _0574_ sky130_fd_sc_hd__a21boi_0
Xoutput304 net303 VSS VSS VDD VDD mem_wdata[9] sky130_fd_sc_hd__clkdlybuf4s50_1
X_7713_ _3449_ _3479_ VSS VSS VDD VDD _3510_ sky130_fd_sc_hd__nand2_1
X_7714_ count_instr\[56\] _3510_ VSS VSS VDD VDD _3511_ sky130_fd_sc_hd__xnor2_1
X_7715_ net775 _3511_ VSS VSS VDD VDD _0575_ sky130_fd_sc_hd__and2_1
X_7716_ count_instr\[53\] count_instr\[54\] VSS VSS VDD VDD
+ _3512_ sky130_fd_sc_hd__nand2_1
X_7717_ _3512_ _3491_ count_instr\[55\] VSS VSS VDD VDD _3513_
+ sky130_fd_sc_hd__o21ai_0
X_7718_ count_instr\[55\] _3512_ _3491_ VSS VSS VDD VDD _3514_
+ sky130_fd_sc_hd__or3_1
X_7719_ _3513_ _3514_ net775 VSS VSS VDD VDD _0576_ sky130_fd_sc_hd__a21boi_0
X_7720_ count_instr\[53\] _3479_ VSS VSS VDD VDD _3515_ sky130_fd_sc_hd__nand2_1
X_7721_ count_instr\[54\] _3515_ VSS VSS VDD VDD _3516_ sky130_fd_sc_hd__xnor2_1
X_7722_ net775 _3516_ VSS VSS VDD VDD _0577_ sky130_fd_sc_hd__and2_1
X_7723_ count_instr\[53\] _3491_ VSS VSS VDD VDD _3517_ sky130_fd_sc_hd__xnor2_1
X_7724_ net775 _3517_ VSS VSS VDD VDD _0578_ sky130_fd_sc_hd__and2_1
Xoutput303 net302 VSS VSS VDD VDD mem_wdata[8] sky130_fd_sc_hd__clkdlybuf4s50_1
X_7726_ _3460_ _3462_ _3468_ VSS VSS VDD VDD _3519_ sky130_fd_sc_hd__nor3_1
X_7727_ _3458_ _3519_ VSS VSS VDD VDD _3520_ sky130_fd_sc_hd__nand2b_1
X_7728_ _3454_ _3457_ _3520_ VSS VSS VDD VDD _3521_ sky130_fd_sc_hd__nor3_1
X_7729_ count_instr\[47\] count_instr\[48\] count_instr\[49\]
+ _3476_ VSS VSS VDD VDD _3522_ sky130_fd_sc_hd__and4_1
X_7730_ count_instr\[50\] count_instr\[51\] _3521_ _3522_
+ VSS VSS VDD VDD _3523_ sky130_fd_sc_hd__nand4_1
X_7731_ count_instr\[52\] _3523_ VSS VSS VDD VDD _3524_ sky130_fd_sc_hd__xnor2_1
X_7732_ net775 _3524_ VSS VSS VDD VDD _0579_ sky130_fd_sc_hd__and2_1
X_7733_ _3454_ _3490_ VSS VSS VDD VDD _3525_ sky130_fd_sc_hd__nor2_1
X_7734_ count_instr\[50\] _3522_ _3525_ VSS VSS VDD VDD _3526_
+ sky130_fd_sc_hd__nand3_1
X_7735_ count_instr\[51\] _3526_ VSS VSS VDD VDD _3527_ sky130_fd_sc_hd__xnor2_1
X_7736_ net775 _3527_ VSS VSS VDD VDD _0580_ sky130_fd_sc_hd__and2_1
X_7737_ _3470_ _3477_ VSS VSS VDD VDD _3528_ sky130_fd_sc_hd__nand2b_1
X_7738_ count_instr\[50\] _3528_ VSS VSS VDD VDD _3529_ sky130_fd_sc_hd__xnor2_1
X_7739_ net775 _3529_ VSS VSS VDD VDD _0581_ sky130_fd_sc_hd__and2_1
X_7740_ count_instr\[47\] count_instr\[48\] _3476_ _3525_
+ VSS VSS VDD VDD _3530_ sky130_fd_sc_hd__nand4_1
X_7741_ count_instr\[49\] _3530_ VSS VSS VDD VDD _3531_ sky130_fd_sc_hd__xnor2_1
X_7742_ net775 _3531_ VSS VSS VDD VDD _0582_ sky130_fd_sc_hd__and2_1
X_7743_ count_instr\[47\] _3476_ VSS VSS VDD VDD _3532_ sky130_fd_sc_hd__nand2_1
X_7744_ _3470_ _3532_ count_instr\[48\] VSS VSS VDD VDD _3533_
+ sky130_fd_sc_hd__o21ai_0
X_7745_ count_instr\[48\] _3470_ _3532_ VSS VSS VDD VDD _3534_
+ sky130_fd_sc_hd__or3_1
X_7746_ _3533_ _3534_ net775 VSS VSS VDD VDD _0583_ sky130_fd_sc_hd__a21boi_0
Xoutput302 net301 VSS VSS VDD VDD mem_wdata[7] sky130_fd_sc_hd__clkdlybuf4s50_1
X_7748_ _3476_ _3525_ VSS VSS VDD VDD _3536_ sky130_fd_sc_hd__nand2_1
X_7749_ count_instr\[47\] _3536_ VSS VSS VDD VDD _3537_ sky130_fd_sc_hd__xnor2_1
X_7750_ net775 _3537_ VSS VSS VDD VDD _0584_ sky130_fd_sc_hd__and2_1
X_7751_ _3470_ _3475_ count_instr\[46\] VSS VSS VDD VDD _3538_
+ sky130_fd_sc_hd__o21ai_0
X_7752_ count_instr\[46\] _3470_ _3475_ VSS VSS VDD VDD _3539_
+ sky130_fd_sc_hd__or3_1
Xoutput301 net300 VSS VSS VDD VDD mem_wdata[6] sky130_fd_sc_hd__clkdlybuf4s50_1
X_7754_ _3538_ _3539_ net775 VSS VSS VDD VDD _0585_ sky130_fd_sc_hd__a21boi_0
Xoutput300 net299 VSS VSS VDD VDD mem_wdata[5] sky130_fd_sc_hd__clkdlybuf4s50_1
X_7756_ count_instr\[44\] _3474_ _3525_ VSS VSS VDD VDD _3542_
+ sky130_fd_sc_hd__nand3_1
X_7757_ count_instr\[45\] _3542_ VSS VSS VDD VDD _3543_ sky130_fd_sc_hd__xnor2_1
X_7758_ net775 _3543_ VSS VSS VDD VDD _0586_ sky130_fd_sc_hd__and2_1
Xoutput299 net298 VSS VSS VDD VDD mem_wdata[4] sky130_fd_sc_hd__clkdlybuf4s50_1
X_7760_ _3474_ _3521_ VSS VSS VDD VDD _3545_ sky130_fd_sc_hd__nand2_1
X_7761_ count_instr\[44\] _3545_ VSS VSS VDD VDD _3546_ sky130_fd_sc_hd__xnor2_1
X_7762_ net775 _3546_ VSS VSS VDD VDD _0587_ sky130_fd_sc_hd__and2_1
X_7763_ count_instr\[42\] _3473_ _3525_ VSS VSS VDD VDD _3547_
+ sky130_fd_sc_hd__nand3_1
X_7764_ count_instr\[43\] _3547_ VSS VSS VDD VDD _3548_ sky130_fd_sc_hd__xnor2_1
X_7765_ net775 _3548_ VSS VSS VDD VDD _0588_ sky130_fd_sc_hd__and2_1
X_7766_ _3473_ _3521_ VSS VSS VDD VDD _3549_ sky130_fd_sc_hd__nand2_1
X_7767_ count_instr\[42\] _3549_ VSS VSS VDD VDD _3550_ sky130_fd_sc_hd__xor2_1
X_7768_ _3550_ net775 VSS VSS VDD VDD _0589_ sky130_fd_sc_hd__nor2b_1
X_7769_ count_instr\[38\] count_instr\[39\] count_instr\[40\]
+ _3525_ VSS VSS VDD VDD _3551_ sky130_fd_sc_hd__nand4_1
X_7770_ count_instr\[41\] _3551_ VSS VSS VDD VDD _3552_ sky130_fd_sc_hd__xnor2_1
X_7771_ net775 _3552_ VSS VSS VDD VDD _0590_ sky130_fd_sc_hd__and2_1
X_7772_ count_instr\[38\] count_instr\[39\] _3521_ VSS VSS
+ VDD VDD _3553_ sky130_fd_sc_hd__nand3_1
X_7773_ count_instr\[40\] _3553_ VSS VSS VDD VDD _3554_ sky130_fd_sc_hd__xnor2_1
X_7774_ net775 _3554_ VSS VSS VDD VDD _0591_ sky130_fd_sc_hd__and2_1
X_7775_ count_instr\[38\] _3525_ VSS VSS VDD VDD _3555_ sky130_fd_sc_hd__nand2_1
X_7776_ count_instr\[39\] _3555_ VSS VSS VDD VDD _3556_ sky130_fd_sc_hd__xnor2_1
X_7777_ net775 _3556_ VSS VSS VDD VDD _0592_ sky130_fd_sc_hd__and2_1
Xoutput298 net297 VSS VSS VDD VDD mem_wdata[3] sky130_fd_sc_hd__clkdlybuf4s50_1
X_7779_ count_instr\[38\] _3470_ VSS VSS VDD VDD _3558_ sky130_fd_sc_hd__xnor2_1
X_7780_ net775 _3558_ VSS VSS VDD VDD _0593_ sky130_fd_sc_hd__and2_1
X_7781_ count_instr\[36\] _3453_ VSS VSS VDD VDD _3559_ sky130_fd_sc_hd__nand2_1
X_7782_ _3559_ _3490_ count_instr\[37\] VSS VSS VDD VDD _3560_
+ sky130_fd_sc_hd__o21ai_0
X_7783_ count_instr\[37\] _3559_ _3490_ VSS VSS VDD VDD _3561_
+ sky130_fd_sc_hd__or3_1
X_7784_ _3560_ _3561_ net775 VSS VSS VDD VDD _0594_ sky130_fd_sc_hd__a21boi_0
X_7785_ _3457_ _3520_ VSS VSS VDD VDD _3562_ sky130_fd_sc_hd__nor2_1
X_7786_ _3453_ _3562_ VSS VSS VDD VDD _3563_ sky130_fd_sc_hd__nand2_1
X_7787_ count_instr\[36\] _3563_ VSS VSS VDD VDD _3564_ sky130_fd_sc_hd__xnor2_1
X_7788_ net775 _3564_ VSS VSS VDD VDD _0595_ sky130_fd_sc_hd__and2_1
X_7789_ count_instr\[33\] count_instr\[34\] VSS VSS VDD VDD
+ _3565_ sky130_fd_sc_hd__nand2_1
X_7790_ _3565_ _3490_ count_instr\[35\] VSS VSS VDD VDD _3566_
+ sky130_fd_sc_hd__o21ai_0
X_7791_ count_instr\[35\] _3565_ _3490_ VSS VSS VDD VDD _3567_
+ sky130_fd_sc_hd__or3_1
X_7792_ _3566_ _3567_ net775 VSS VSS VDD VDD _0596_ sky130_fd_sc_hd__a21boi_0
X_7793_ count_instr\[33\] _3562_ VSS VSS VDD VDD _3568_ sky130_fd_sc_hd__nand2_1
X_7794_ count_instr\[34\] _3568_ VSS VSS VDD VDD _3569_ sky130_fd_sc_hd__xnor2_1
X_7795_ net775 _3569_ VSS VSS VDD VDD _0597_ sky130_fd_sc_hd__and2_1
X_7796_ count_instr\[33\] _3490_ VSS VSS VDD VDD _3570_ sky130_fd_sc_hd__xnor2_1
X_7797_ net775 _3570_ VSS VSS VDD VDD _0598_ sky130_fd_sc_hd__and2_1
X_7798_ _3460_ _3462_ _3468_ VSS VSS VDD VDD _3571_ sky130_fd_sc_hd__or3_1
X_7799_ _3458_ _3571_ VSS VSS VDD VDD _3572_ sky130_fd_sc_hd__nor2_1
X_7800_ count_instr\[30\] count_instr\[31\] _3456_ _3572_
+ VSS VSS VDD VDD _3573_ sky130_fd_sc_hd__nand4_1
X_7801_ count_instr\[32\] _3573_ VSS VSS VDD VDD _3574_ sky130_fd_sc_hd__xnor2_1
X_7802_ net775 _3574_ VSS VSS VDD VDD _0599_ sky130_fd_sc_hd__and2_1
X_7803_ count_instr\[30\] _3456_ _3489_ VSS VSS VDD VDD _3575_
+ sky130_fd_sc_hd__nand3_1
X_7804_ count_instr\[31\] _3575_ VSS VSS VDD VDD _3576_ sky130_fd_sc_hd__xnor2_1
X_7805_ net775 _3576_ VSS VSS VDD VDD _0600_ sky130_fd_sc_hd__and2_1
X_7806_ _3456_ _3572_ VSS VSS VDD VDD _3577_ sky130_fd_sc_hd__nand2_1
X_7807_ count_instr\[30\] _3577_ VSS VSS VDD VDD _3578_ sky130_fd_sc_hd__xnor2_1
X_7808_ net775 _3578_ VSS VSS VDD VDD _0601_ sky130_fd_sc_hd__and2_1
X_7809_ count_instr\[28\] _3455_ _3489_ VSS VSS VDD VDD _3579_
+ sky130_fd_sc_hd__nand3_1
X_7810_ count_instr\[29\] _3579_ VSS VSS VDD VDD _3580_ sky130_fd_sc_hd__xnor2_1
X_7811_ net776 _3580_ VSS VSS VDD VDD _0602_ sky130_fd_sc_hd__and2_1
X_7812_ _3455_ _3572_ VSS VSS VDD VDD _3581_ sky130_fd_sc_hd__nand2_1
X_7813_ count_instr\[28\] _3581_ VSS VSS VDD VDD _3582_ sky130_fd_sc_hd__xnor2_1
X_7814_ net776 _3582_ VSS VSS VDD VDD _0603_ sky130_fd_sc_hd__and2_1
X_7815_ count_instr\[25\] count_instr\[26\] _3489_ VSS VSS
+ VDD VDD _3583_ sky130_fd_sc_hd__nand3_1
X_7816_ count_instr\[27\] _3583_ VSS VSS VDD VDD _3584_ sky130_fd_sc_hd__xnor2_1
X_7817_ net775 _3584_ VSS VSS VDD VDD _0604_ sky130_fd_sc_hd__and2_1
X_7818_ count_instr\[25\] _3572_ VSS VSS VDD VDD _3585_ sky130_fd_sc_hd__nand2_1
X_7819_ count_instr\[26\] _3585_ VSS VSS VDD VDD _3586_ sky130_fd_sc_hd__xnor2_1
X_7820_ net776 _3586_ VSS VSS VDD VDD _0605_ sky130_fd_sc_hd__and2_1
X_7821_ count_instr\[25\] _3489_ VSS VSS VDD VDD _3587_ sky130_fd_sc_hd__xor2_1
X_7822_ net776 _3587_ VSS VSS VDD VDD _0606_ sky130_fd_sc_hd__and2_1
X_7823_ count_instr\[22\] count_instr\[23\] _3519_ VSS VSS
+ VDD VDD _3588_ sky130_fd_sc_hd__nand3_1
X_7824_ count_instr\[24\] _3588_ VSS VSS VDD VDD _3589_ sky130_fd_sc_hd__xnor2_1
X_7825_ net775 _3589_ VSS VSS VDD VDD _0607_ sky130_fd_sc_hd__and2_1
X_7826_ count_instr\[22\] _3488_ VSS VSS VDD VDD _3590_ sky130_fd_sc_hd__nand2_1
X_7827_ count_instr\[23\] _3590_ VSS VSS VDD VDD _3591_ sky130_fd_sc_hd__xnor2_1
X_7828_ net775 _3591_ VSS VSS VDD VDD _0608_ sky130_fd_sc_hd__and2_1
X_7829_ count_instr\[22\] _3571_ VSS VSS VDD VDD _3592_ sky130_fd_sc_hd__xnor2_1
X_7830_ net775 _3592_ VSS VSS VDD VDD _0609_ sky130_fd_sc_hd__and2_1
X_7831_ _3460_ _3484_ _3487_ VSS VSS VDD VDD _3593_ sky130_fd_sc_hd__nor3_1
X_7832_ count_instr\[20\] _3461_ _3593_ VSS VSS VDD VDD _3594_
+ sky130_fd_sc_hd__nand3_1
X_7833_ count_instr\[21\] _3594_ VSS VSS VDD VDD _3595_ sky130_fd_sc_hd__xnor2_1
X_7834_ net775 _3595_ VSS VSS VDD VDD _0610_ sky130_fd_sc_hd__and2_1
X_7835_ _3460_ _3468_ VSS VSS VDD VDD _3596_ sky130_fd_sc_hd__nor2_1
X_7836_ _3461_ _3596_ VSS VSS VDD VDD _3597_ sky130_fd_sc_hd__nand2_1
X_7837_ count_instr\[20\] _3597_ VSS VSS VDD VDD _3598_ sky130_fd_sc_hd__xnor2_1
X_7838_ net775 _3598_ VSS VSS VDD VDD _0611_ sky130_fd_sc_hd__and2_1
X_7839_ count_instr\[17\] count_instr\[18\] _3593_ VSS VSS
+ VDD VDD _3599_ sky130_fd_sc_hd__nand3_1
X_7840_ count_instr\[19\] _3599_ VSS VSS VDD VDD _3600_ sky130_fd_sc_hd__xnor2_1
X_7841_ net775 _3600_ VSS VSS VDD VDD _0612_ sky130_fd_sc_hd__and2_1
X_7842_ count_instr\[17\] _3596_ VSS VSS VDD VDD _3601_ sky130_fd_sc_hd__nand2_1
X_7843_ count_instr\[18\] _3601_ VSS VSS VDD VDD _3602_ sky130_fd_sc_hd__xor2_1
Xoutput297 net296 VSS VSS VDD VDD mem_wdata[31] sky130_fd_sc_hd__clkdlybuf4s50_1
X_7845_ _3602_ net775 VSS VSS VDD VDD _0613_ sky130_fd_sc_hd__nor2b_1
X_7846_ count_instr\[17\] _3593_ VSS VSS VDD VDD _3604_ sky130_fd_sc_hd__xor2_1
X_7847_ net775 _3604_ VSS VSS VDD VDD _0614_ sky130_fd_sc_hd__and2_1
X_7848_ count_instr\[14\] count_instr\[15\] _3459_ VSS VSS
+ VDD VDD _3605_ sky130_fd_sc_hd__nand3_1
X_7849_ _3605_ _3468_ count_instr\[16\] VSS VSS VDD VDD _3606_
+ sky130_fd_sc_hd__o21ai_0
X_7850_ count_instr\[16\] _3605_ _3468_ VSS VSS VDD VDD _3607_
+ sky130_fd_sc_hd__or3_1
Xoutput296 net295 VSS VSS VDD VDD mem_wdata[30] sky130_fd_sc_hd__clkdlybuf4s50_1
X_7852_ _3606_ _3607_ net775 VSS VSS VDD VDD _0615_ sky130_fd_sc_hd__a21boi_0
Xoutput295 net294 VSS VSS VDD VDD mem_wdata[2] sky130_fd_sc_hd__clkdlybuf4s50_1
X_7854_ _3484_ _3487_ VSS VSS VDD VDD _3610_ sky130_fd_sc_hd__nor2_1
X_7855_ count_instr\[14\] _3459_ _3610_ VSS VSS VDD VDD _3611_
+ sky130_fd_sc_hd__nand3_1
X_7856_ count_instr\[15\] _3611_ VSS VSS VDD VDD _3612_ sky130_fd_sc_hd__xnor2_1
X_7857_ net775 _3612_ VSS VSS VDD VDD _0616_ sky130_fd_sc_hd__and2_1
X_7858_ count_instr\[10\] count_instr\[11\] count_instr\[12\]
+ count_instr\[13\] VSS VSS VDD VDD _3613_ sky130_fd_sc_hd__nand4_1
X_7859_ _3613_ _3468_ count_instr\[14\] VSS VSS VDD VDD _3614_
+ sky130_fd_sc_hd__o21ai_0
X_7860_ count_instr\[14\] _3613_ _3468_ VSS VSS VDD VDD _3615_
+ sky130_fd_sc_hd__or3_1
X_7861_ _3614_ _3615_ net775 VSS VSS VDD VDD _0617_ sky130_fd_sc_hd__a21boi_0
Xoutput294 net293 VSS VSS VDD VDD mem_wdata[29] sky130_fd_sc_hd__clkdlybuf4s50_1
X_7863_ count_instr\[10\] count_instr\[11\] count_instr\[12\]
+ _3610_ VSS VSS VDD VDD _3617_ sky130_fd_sc_hd__nand4_1
X_7864_ count_instr\[13\] _3617_ VSS VSS VDD VDD _3618_ sky130_fd_sc_hd__xnor2_1
X_7865_ net775 _3618_ VSS VSS VDD VDD _0618_ sky130_fd_sc_hd__and2_1
X_7866_ count_instr\[10\] count_instr\[11\] VSS VSS VDD VDD
+ _3619_ sky130_fd_sc_hd__nand2_1
X_7867_ _3619_ _3468_ count_instr\[12\] VSS VSS VDD VDD _3620_
+ sky130_fd_sc_hd__o21ai_0
X_7868_ count_instr\[12\] _3619_ _3468_ VSS VSS VDD VDD _3621_
+ sky130_fd_sc_hd__or3_1
X_7869_ _3620_ _3621_ net775 VSS VSS VDD VDD _0619_ sky130_fd_sc_hd__a21boi_0
X_7870_ count_instr\[10\] _3610_ VSS VSS VDD VDD _3622_ sky130_fd_sc_hd__nand2_1
X_7871_ count_instr\[11\] _3622_ VSS VSS VDD VDD _3623_ sky130_fd_sc_hd__xor2_1
X_7872_ _3623_ net775 VSS VSS VDD VDD _0620_ sky130_fd_sc_hd__nor2b_1
X_7873_ count_instr\[10\] _3468_ VSS VSS VDD VDD _3624_ sky130_fd_sc_hd__xnor2_1
X_7874_ net775 _3624_ VSS VSS VDD VDD _0621_ sky130_fd_sc_hd__and2_1
X_7875_ count_instr\[5\] count_instr\[6\] count_instr\[7\]
+ count_instr\[8\] VSS VSS VDD VDD _3625_ sky130_fd_sc_hd__nand4_1
X_7876_ _3625_ _3487_ VSS VSS VDD VDD _3626_ sky130_fd_sc_hd__nor2_1
X_7877_ count_instr\[9\] _3626_ VSS VSS VDD VDD _3627_ sky130_fd_sc_hd__xor2_1
X_7878_ net775 _3627_ VSS VSS VDD VDD _0622_ sky130_fd_sc_hd__and2_1
Xoutput293 net292 VSS VSS VDD VDD mem_wdata[28] sky130_fd_sc_hd__clkdlybuf4s50_1
X_7880_ count_instr\[5\] count_instr\[6\] count_instr\[7\]
+ _3466_ VSS VSS VDD VDD _3629_ sky130_fd_sc_hd__nand4_1
X_7881_ count_instr\[8\] _3629_ VSS VSS VDD VDD _3630_ sky130_fd_sc_hd__xnor2_1
X_7882_ net775 _3630_ VSS VSS VDD VDD _0623_ sky130_fd_sc_hd__and2_1
X_7883_ count_instr\[5\] count_instr\[6\] VSS VSS VDD VDD
+ _3631_ sky130_fd_sc_hd__nand2_1
X_7884_ _3631_ _3487_ VSS VSS VDD VDD _3632_ sky130_fd_sc_hd__nor2_1
X_7885_ count_instr\[7\] _3632_ VSS VSS VDD VDD _3633_ sky130_fd_sc_hd__xor2_1
X_7886_ net775 _3633_ VSS VSS VDD VDD _0624_ sky130_fd_sc_hd__and2_1
X_7887_ count_instr\[5\] _3466_ VSS VSS VDD VDD _3634_ sky130_fd_sc_hd__nand2_1
X_7888_ count_instr\[6\] _3634_ VSS VSS VDD VDD _3635_ sky130_fd_sc_hd__xnor2_1
X_7889_ net775 _3635_ VSS VSS VDD VDD _0625_ sky130_fd_sc_hd__and2_1
X_7890_ count_instr\[5\] _3487_ VSS VSS VDD VDD _3636_ sky130_fd_sc_hd__xnor2_1
X_7891_ net775 _3636_ VSS VSS VDD VDD _0626_ sky130_fd_sc_hd__and2_1
X_7892_ count_instr\[2\] count_instr\[3\] _3465_ VSS VSS VDD
+ VDD _3637_ sky130_fd_sc_hd__nand3_1
X_7893_ count_instr\[4\] _3637_ VSS VSS VDD VDD _3638_ sky130_fd_sc_hd__xnor2_1
X_7894_ net775 _3638_ VSS VSS VDD VDD _0627_ sky130_fd_sc_hd__and2_1
X_7895_ count_instr\[0\] count_instr\[1\] count_instr\[2\]
+ _3486_ VSS VSS VDD VDD _3639_ sky130_fd_sc_hd__nand4_1
X_7896_ count_instr\[3\] _3639_ VSS VSS VDD VDD _3640_ sky130_fd_sc_hd__xnor2_1
X_7897_ net775 _3640_ VSS VSS VDD VDD _0628_ sky130_fd_sc_hd__and2_1
X_7898_ count_instr\[2\] _3465_ VSS VSS VDD VDD _3641_ sky130_fd_sc_hd__xor2_1
X_7899_ net775 _3641_ VSS VSS VDD VDD _0629_ sky130_fd_sc_hd__and2_1
X_7900_ _0360_ _3486_ VSS VSS VDD VDD _3642_ sky130_fd_sc_hd__nand2_1
Xoutput292 net291 VSS VSS VDD VDD mem_wdata[27] sky130_fd_sc_hd__clkdlybuf4s50_1
Xoutput291 net290 VSS VSS VDD VDD mem_wdata[26] sky130_fd_sc_hd__clkdlybuf4s50_1
Xoutput290 net289 VSS VSS VDD VDD mem_wdata[25] sky130_fd_sc_hd__clkdlybuf4s50_1
X_7904_ cpu_state\[1\] decoder_trigger VSS VSS VDD VDD _3646_
+ sky130_fd_sc_hd__nand2_1
X_7905_ count_instr\[1\] _3646_ VSS VSS VDD VDD _3647_ sky130_fd_sc_hd__nand2_1
X_7906_ _3642_ _3647_ net775 VSS VSS VDD VDD _0630_ sky130_fd_sc_hd__a21boi_0
X_7907_ count_instr\[0\] _3646_ VSS VSS VDD VDD _3648_ sky130_fd_sc_hd__xnor2_1
X_7908_ net775 _3648_ VSS VSS VDD VDD _0631_ sky130_fd_sc_hd__and2_1
Xoutput289 net288 VSS VSS VDD VDD mem_wdata[24] sky130_fd_sc_hd__clkdlybuf4s50_1
Xoutput288 net287 VSS VSS VDD VDD mem_wdata[23] sky130_fd_sc_hd__clkdlybuf4s50_1
X_7911_ cpu_state\[1\] reg_next_pc\[30\] net776 VSS VSS VDD
+ VDD _3651_ sky130_fd_sc_hd__o21ai_0
X_7912_ net743 net744 VSS VSS VDD VDD _3652_ sky130_fd_sc_hd__and2_1
Xoutput287 net286 VSS VSS VDD VDD mem_wdata[22] sky130_fd_sc_hd__clkdlybuf4s50_1
Xoutput286 net285 VSS VSS VDD VDD mem_wdata[21] sky130_fd_sc_hd__clkdlybuf4s50_1
X_7915_ _0423_ VSS VSS VDD VDD _3655_ sky130_fd_sc_hd__inv_1
X_7916_ _0389_ _3655_ VSS VSS VDD VDD _3656_ sky130_fd_sc_hd__nand2_1
X_7917_ _0096_ _0074_ _0430_ _0398_ VSS VSS VDD VDD _3657_
+ sky130_fd_sc_hd__nand4_1
Xoutput285 net284 VSS VSS VDD VDD mem_wdata[20] sky130_fd_sc_hd__clkdlybuf4s50_1
X_7919_ _0263_ _0400_ _0262_ VSS VSS VDD VDD _3659_ sky130_fd_sc_hd__a21o_1
X_7920_ _0099_ _3659_ _0098_ VSS VSS VDD VDD _3660_ sky130_fd_sc_hd__a21o_1
X_7921_ _0419_ _3660_ _0418_ VSS VSS VDD VDD _3661_ sky130_fd_sc_hd__a21oi_1
X_7922_ _0430_ _0397_ _0429_ VSS VSS VDD VDD _3662_ sky130_fd_sc_hd__a21o_1
X_7923_ _0074_ _3662_ _0073_ VSS VSS VDD VDD _3663_ sky130_fd_sc_hd__a21o_1
X_7924_ _0096_ _3663_ _0095_ VSS VSS VDD VDD _3664_ sky130_fd_sc_hd__a21oi_1
X_7925_ _3657_ _3661_ _3664_ VSS VSS VDD VDD _3665_ sky130_fd_sc_hd__o21a_1
X_7926_ _0051_ _0069_ _0408_ _0267_ VSS VSS VDD VDD _3666_
+ sky130_fd_sc_hd__a211oi_1
X_7927_ _0268_ _0267_ _0459_ VSS VSS VDD VDD _3667_ sky130_fd_sc_hd__o21ai_0
X_7928_ _0406_ _0274_ _0458_ VSS VSS VDD VDD _3668_ sky130_fd_sc_hd__nor3_1
X_7929_ _3666_ _3667_ _3668_ VSS VSS VDD VDD _3669_ sky130_fd_sc_hd__o21a_1
X_7930_ _0275_ _0274_ _0407_ VSS VSS VDD VDD _3670_ sky130_fd_sc_hd__o21a_1
X_7931_ _0406_ _3670_ _0436_ _0367_ VSS VSS VDD VDD _3671_
+ sky130_fd_sc_hd__o211ai_1
X_7932_ _0367_ _0435_ _0366_ VSS VSS VDD VDD _3672_ sky130_fd_sc_hd__a21oi_1
X_7933_ _0462_ _0403_ _0461_ VSS VSS VDD VDD _3673_ sky130_fd_sc_hd__a21o_1
X_7934_ _0122_ _0462_ _0404_ VSS VSS VDD VDD _3674_ sky130_fd_sc_hd__and3_1
X_7935_ _0122_ _3673_ _3674_ _0118_ _0121_ VSS VSS VDD VDD
+ _3675_ sky130_fd_sc_hd__a221oi_2
X_7936_ _0426_ VSS VSS VDD VDD _3676_ sky130_fd_sc_hd__inv_1
X_7937_ _3669_ _3671_ _3672_ _3675_ _3676_ VSS VSS VDD VDD
+ _3677_ sky130_fd_sc_hd__o2111ai_1
X_7938_ _0119_ _0122_ _0462_ _0404_ VSS VSS VDD VDD _3678_
+ sky130_fd_sc_hd__nand4_1
X_7939_ _0426_ _0427_ VSS VSS VDD VDD _3679_ sky130_fd_sc_hd__nor2_1
X_7940_ _3676_ _3675_ _3678_ _3679_ VSS VSS VDD VDD _3680_
+ sky130_fd_sc_hd__a31oi_1
Xoutput284 net283 VSS VSS VDD VDD mem_wdata[1] sky130_fd_sc_hd__clkdlybuf4s50_1
X_7942_ _0099_ _0263_ _0401_ VSS VSS VDD VDD _3682_ sky130_fd_sc_hd__nand3_1
X_7943_ _3657_ _3682_ VSS VSS VDD VDD _3683_ sky130_fd_sc_hd__nor2_1
X_7944_ _0419_ _3677_ _3680_ _3683_ VSS VSS VDD VDD _3684_
+ sky130_fd_sc_hd__nand4_1
X_7945_ _0433_ _0395_ VSS VSS VDD VDD _3685_ sky130_fd_sc_hd__nand2_1
X_7946_ _3665_ _3684_ _3685_ VSS VSS VDD VDD _3686_ sky130_fd_sc_hd__a21oi_1
X_7947_ _0433_ _0394_ _0432_ VSS VSS VDD VDD _3687_ sky130_fd_sc_hd__a21o_1
X_7948_ _0260_ _0259_ _0076_ VSS VSS VDD VDD _3688_ sky130_fd_sc_hd__nor3_1
X_7949_ _0077_ _0076_ VSS VSS VDD VDD _3689_ sky130_fd_sc_hd__nor2_1
X_7950_ _3688_ _3689_ VSS VSS VDD VDD _3690_ sky130_fd_sc_hd__nor2_1
X_7951_ _0259_ _0076_ _3686_ _3687_ _3690_ VSS VSS VDD VDD
+ _3691_ sky130_fd_sc_hd__o41ai_1
X_7952_ _0382_ _0339_ VSS VSS VDD VDD _3692_ sky130_fd_sc_hd__nand2_1
X_7953_ _3692_ VSS VSS VDD VDD _3693_ sky130_fd_sc_hd__inv_1
X_7954_ _0424_ _0392_ _3693_ VSS VSS VDD VDD _3694_ sky130_fd_sc_hd__nand3_1
X_7955_ _0382_ _0391_ _0381_ VSS VSS VDD VDD _3695_ sky130_fd_sc_hd__a21oi_1
X_7956_ _3695_ _0339_ VSS VSS VDD VDD _3696_ sky130_fd_sc_hd__nor2b_1
X_7957_ _0338_ _3696_ _0424_ VSS VSS VDD VDD _3697_ sky130_fd_sc_hd__o21ai_0
X_7958_ _3691_ _3694_ _3697_ VSS VSS VDD VDD _3698_ sky130_fd_sc_hd__o21ai_0
X_7959_ _3656_ _0389_ _3698_ VSS VSS VDD VDD _3699_ sky130_fd_sc_hd__mux2i_1
Xoutput283 net282 VSS VSS VDD VDD mem_wdata[19] sky130_fd_sc_hd__clkdlybuf4s50_1
X_7961_ _0932_ _0934_ _0094_ _0393_ VSS VSS VDD VDD _3701_
+ sky130_fd_sc_hd__and4bb_2
X_7962_ _0944_ _0945_ _0947_ VSS VSS VDD VDD _3702_ sky130_fd_sc_hd__a21oi_1
X_7963_ _0431_ _0258_ _3701_ _3702_ VSS VSS VDD VDD _3703_
+ sky130_fd_sc_hd__nand4_1
X_7964_ _0952_ _3703_ _0955_ _0380_ VSS VSS VDD VDD _3704_
+ sky130_fd_sc_hd__nor4b_2
X_7965_ _0895_ _0897_ _0899_ _0901_ VSS VSS VDD VDD _3705_
+ sky130_fd_sc_hd__nor4_2
X_7966_ _0276_ _0457_ _3705_ VSS VSS VDD VDD _3706_ sky130_fd_sc_hd__nand3_1
X_7967_ _0907_ _0909_ _0911_ VSS VSS VDD VDD _3707_ sky130_fd_sc_hd__nor3_2
X_7968_ _0399_ _0261_ _0097_ _3707_ VSS VSS VDD VDD _3708_
+ sky130_fd_sc_hd__nand4_1
X_7969_ _0903_ _0905_ VSS VSS VDD VDD _3709_ sky130_fd_sc_hd__or2_0
Xoutput282 net281 VSS VSS VDD VDD mem_wdata[18] sky130_fd_sc_hd__clkdlybuf4s50_1
X_7971_ _0926_ _0930_ _3709_ VSS VSS VDD VDD _3711_ sky130_fd_sc_hd__or3_4
X_7972_ _3706_ _3708_ _3711_ VSS VSS VDD VDD _3712_ sky130_fd_sc_hd__nor3_1
Xoutput281 net280 VSS VSS VDD VDD mem_wdata[17] sky130_fd_sc_hd__clkdlybuf4s50_1
X_7974_ _3704_ net612 _0958_ VSS VSS VDD VDD _3714_ sky130_fd_sc_hd__a21oi_1
X_7975_ net744 _0958_ _3704_ net612 _3714_ VSS VSS VDD VDD
+ _3715_ sky130_fd_sc_hd__a41oi_1
X_7976_ net743 decoder_trigger VSS VSS VDD VDD _3716_ sky130_fd_sc_hd__nand2_1
X_7977_ _0389_ _3655_ _3716_ cpu_state\[1\] VSS VSS VDD VDD
+ _3717_ sky130_fd_sc_hd__o31a_1
X_7978_ net744 _0958_ _3715_ net743 _3717_ VSS VSS VDD VDD
+ _3718_ sky130_fd_sc_hd__o221ai_1
X_7979_ net684 _3699_ _3718_ VSS VSS VDD VDD _3719_ sky130_fd_sc_hd__a21oi_1
X_7980_ _3651_ _3719_ VSS VSS VDD VDD _0632_ sky130_fd_sc_hd__nor2_1
Xoutput280 net279 VSS VSS VDD VDD mem_wdata[16] sky130_fd_sc_hd__clkdlybuf4s50_1
X_7982_ cpu_state\[1\] net171 VSS VSS VDD VDD _3721_ sky130_fd_sc_hd__and2_1
Xoutput279 net278 VSS VSS VDD VDD mem_wdata[15] sky130_fd_sc_hd__clkdlybuf4s50_1
X_7984_ net744 _0422_ net683 net743 VSS VSS VDD VDD _3723_
+ sky130_fd_sc_hd__o211ai_1
X_7985_ _0339_ _0381_ _0338_ VSS VSS VDD VDD _3724_ sky130_fd_sc_hd__a21o_1
X_7986_ _0099_ _0263_ _0401_ _0427_ VSS VSS VDD VDD _3725_
+ sky130_fd_sc_hd__nand4_1
X_7987_ _0401_ _0426_ _0400_ VSS VSS VDD VDD _3726_ sky130_fd_sc_hd__a21o_1
X_7988_ _0263_ _3726_ _0262_ VSS VSS VDD VDD _3727_ sky130_fd_sc_hd__a21o_1
X_7989_ _0099_ _3727_ _0098_ VSS VSS VDD VDD _3728_ sky130_fd_sc_hd__a21oi_1
X_7990_ _0053_ _0268_ _0458_ _0267_ VSS VSS VDD VDD _3729_
+ sky130_fd_sc_hd__a211oi_1
X_7991_ _0459_ _0458_ _0275_ VSS VSS VDD VDD _3730_ sky130_fd_sc_hd__o21ai_0
X_7992_ _0406_ _0274_ VSS VSS VDD VDD _3731_ sky130_fd_sc_hd__nor2_1
X_7993_ _3729_ _3730_ _3731_ _3672_ VSS VSS VDD VDD _3732_
+ sky130_fd_sc_hd__o211ai_1
X_7994_ _0366_ VSS VSS VDD VDD _3733_ sky130_fd_sc_hd__inv_1
X_7995_ _0436_ _0435_ _0367_ VSS VSS VDD VDD _3734_ sky130_fd_sc_hd__o21ai_0
X_7996_ _0406_ _0407_ VSS VSS VDD VDD _3735_ sky130_fd_sc_hd__nor2_1
X_7997_ _3733_ _3734_ _3735_ _3672_ VSS VSS VDD VDD _3736_
+ sky130_fd_sc_hd__a22oi_1
X_7998_ _3678_ _3725_ VSS VSS VDD VDD _3737_ sky130_fd_sc_hd__nor2_1
X_7999_ _3732_ _3736_ _3737_ VSS VSS VDD VDD _3738_ sky130_fd_sc_hd__nand3_1
X_8000_ _3675_ _3725_ _3728_ _3738_ VSS VSS VDD VDD _3739_
+ sky130_fd_sc_hd__o211ai_1
X_8001_ _0398_ _0418_ _0397_ VSS VSS VDD VDD _3740_ sky130_fd_sc_hd__a21o_1
X_8002_ _0430_ _3740_ _0429_ VSS VSS VDD VDD _3741_ sky130_fd_sc_hd__a21oi_1
X_8003_ _3741_ _0074_ VSS VSS VDD VDD _3742_ sky130_fd_sc_hd__nor2b_1
X_8004_ _0419_ _0418_ _0398_ VSS VSS VDD VDD _3743_ sky130_fd_sc_hd__o21a_1
X_8005_ _0397_ _3743_ _0430_ VSS VSS VDD VDD _3744_ sky130_fd_sc_hd__o21a_1
X_8006_ _0429_ _3744_ _0074_ VSS VSS VDD VDD _3745_ sky130_fd_sc_hd__o21ai_0
X_8007_ _0095_ _0073_ VSS VSS VDD VDD _3746_ sky130_fd_sc_hd__nor2_1
X_8008_ _0096_ _0095_ VSS VSS VDD VDD _3747_ sky130_fd_sc_hd__nor2_1
X_8009_ _3745_ _3746_ _3747_ VSS VSS VDD VDD _3748_ sky130_fd_sc_hd__a21oi_1
X_8010_ _0095_ _0073_ _3739_ _3742_ _3748_ VSS VSS VDD VDD
+ _3749_ sky130_fd_sc_hd__o41a_1
X_8011_ _0077_ _0260_ VSS VSS VDD VDD _3750_ sky130_fd_sc_hd__nand2_1
X_8012_ _3685_ _3750_ VSS VSS VDD VDD _3751_ sky130_fd_sc_hd__nor2_1
X_8013_ _3750_ _3687_ VSS VSS VDD VDD _3752_ sky130_fd_sc_hd__nor2b_1
X_8014_ _0077_ _0259_ _3749_ _3751_ _3752_ VSS VSS VDD VDD
+ _3753_ sky130_fd_sc_hd__a221oi_2
X_8015_ _0391_ _0076_ VSS VSS VDD VDD _3754_ sky130_fd_sc_hd__nor2_1
X_8016_ _0392_ _0391_ VSS VSS VDD VDD _3755_ sky130_fd_sc_hd__nor2_1
X_8017_ _3753_ _3754_ _3755_ _3692_ VSS VSS VDD VDD _3756_
+ sky130_fd_sc_hd__a211oi_1
X_8018_ _3724_ _3756_ VSS VSS VDD VDD _3757_ sky130_fd_sc_hd__nor2_1
X_8019_ _0424_ _3757_ VSS VSS VDD VDD _3758_ sky130_fd_sc_hd__xor2_1
Xoutput278 net277 VSS VSS VDD VDD mem_wdata[14] sky130_fd_sc_hd__clkdlybuf4s50_1
Xoutput277 net276 VSS VSS VDD VDD mem_wdata[13] sky130_fd_sc_hd__clkdlybuf4s50_1
X_8022_ _3703_ _0952_ _0380_ VSS VSS VDD VDD _3761_ sky130_fd_sc_hd__nor3b_1
X_8023_ _0888_ _0266_ _0457_ VSS VSS VDD VDD _3762_ sky130_fd_sc_hd__and3b_1
X_8024_ _3705_ _3762_ VSS VSS VDD VDD _3763_ sky130_fd_sc_hd__nand2_1
X_8025_ _3708_ _3711_ _3763_ VSS VSS VDD VDD _3764_ sky130_fd_sc_hd__nor3_4
X_8026_ _3761_ _3764_ _0955_ VSS VSS VDD VDD _3765_ sky130_fd_sc_hd__a21oi_1
X_8027_ net744 _0955_ _3761_ _3764_ _3765_ VSS VSS VDD VDD
+ _3766_ sky130_fd_sc_hd__a41oi_1
Xoutput276 net275 VSS VSS VDD VDD mem_wdata[12] sky130_fd_sc_hd__clkdlybuf4s50_1
Xoutput275 net274 VSS VSS VDD VDD mem_wdata[11] sky130_fd_sc_hd__clkdlybuf4s50_1
X_8030_ net744 _0955_ _3766_ net743 cpu_state\[1\] VSS VSS
+ VDD VDD _3769_ sky130_fd_sc_hd__o221ai_1
X_8031_ cpu_state\[1\] reg_next_pc\[29\] net776 _3769_ VSS
+ VSS VDD VDD _3770_ sky130_fd_sc_hd__o211ai_1
X_8032_ _3723_ _3758_ _3770_ VSS VSS VDD VDD _0633_ sky130_fd_sc_hd__o21ai_0
X_8033_ cpu_state\[1\] net776 VSS VSS VDD VDD _3771_ sky130_fd_sc_hd__nor2b_2
Xoutput274 net273 VSS VSS VDD VDD mem_wdata[10] sky130_fd_sc_hd__clkdlybuf4s50_1
X_8035_ reg_next_pc\[28\] net682 VSS VSS VDD VDD _3773_ sky130_fd_sc_hd__nand2_1
Xoutput273 net272 VSS VSS VDD VDD mem_wdata[0] sky130_fd_sc_hd__clkdlybuf4s50_1
X_8037_ _0339_ _0381_ VSS VSS VDD VDD _3775_ sky130_fd_sc_hd__nor2_1
X_8038_ _0392_ VSS VSS VDD VDD _3776_ sky130_fd_sc_hd__inv_1
X_8039_ _3776_ _3691_ _0391_ VSS VSS VDD VDD _3777_ sky130_fd_sc_hd__o21bai_1
X_8040_ _3775_ _3693_ _3777_ VSS VSS VDD VDD _3778_ sky130_fd_sc_hd__mux2i_1
Xoutput272 net271 VSS VSS VDD VDD mem_valid sky130_fd_sc_hd__clkdlybuf4s50_1
X_8042_ net743 net699 VSS VSS VDD VDD _3780_ sky130_fd_sc_hd__nor2_1
X_8043_ _0382_ _0339_ _0381_ VSS VSS VDD VDD _3781_ sky130_fd_sc_hd__nor3_1
X_8044_ _0339_ _0381_ _3781_ VSS VSS VDD VDD _3782_ sky130_fd_sc_hd__a21oi_1
X_8045_ _3716_ _3782_ net683 VSS VSS VDD VDD _3783_ sky130_fd_sc_hd__o21ai_0
X_8046_ _3761_ net612 _3780_ _3783_ VSS VSS VDD VDD _3784_
+ sky130_fd_sc_hd__a31oi_1
X_8047_ _0431_ _0258_ _3701_ VSS VSS VDD VDD _3785_ sky130_fd_sc_hd__and3_1
X_8048_ _0075_ _3785_ VSS VSS VDD VDD _3786_ sky130_fd_sc_hd__and2_1
X_8049_ net743 net744 VSS VSS VDD VDD _3787_ sky130_fd_sc_hd__nand2b_1
X_8050_ _0390_ _0380_ _3786_ net612 _3787_ VSS VSS VDD VDD
+ _3788_ sky130_fd_sc_hd__a41oi_1
X_8051_ _3646_ _3788_ _0952_ VSS VSS VDD VDD _3789_ sky130_fd_sc_hd__o21ai_0
X_8052_ _3716_ _3778_ _3784_ _3789_ VSS VSS VDD VDD _3790_
+ sky130_fd_sc_hd__o211ai_1
X_8053_ _3773_ _3790_ VSS VSS VDD VDD _0634_ sky130_fd_sc_hd__nand2_1
X_8054_ _0390_ _3786_ _3764_ VSS VSS VDD VDD _3791_ sky130_fd_sc_hd__nand3_1
X_8055_ _0380_ _3791_ VSS VSS VDD VDD _3792_ sky130_fd_sc_hd__xnor2_1
X_8056_ net744 _0380_ _3787_ _3792_ net683 VSS VSS VDD VDD
+ _3793_ sky130_fd_sc_hd__o221ai_1
X_8057_ _3753_ _3754_ _3755_ VSS VSS VDD VDD _3794_ sky130_fd_sc_hd__a21oi_1
X_8058_ _0382_ _3794_ VSS VSS VDD VDD _3795_ sky130_fd_sc_hd__xor2_1
X_8059_ _3716_ _3795_ VSS VSS VDD VDD _3796_ sky130_fd_sc_hd__nor2_1
X_8060_ reg_next_pc\[27\] net682 VSS VSS VDD VDD _3797_ sky130_fd_sc_hd__nand2_1
X_8061_ _3793_ _3796_ _3797_ VSS VSS VDD VDD _0635_ sky130_fd_sc_hd__o21ai_0
Xoutput271 net270 VSS VSS VDD VDD mem_la_wstrb[3] sky130_fd_sc_hd__clkdlybuf4s50_1
X_8063_ _0392_ _3691_ VSS VSS VDD VDD _3799_ sky130_fd_sc_hd__xnor2_1
X_8064_ net743 _3799_ VSS VSS VDD VDD _3800_ sky130_fd_sc_hd__nand2_1
X_8065_ _0390_ _3786_ net612 net743 VSS VSS VDD VDD _3801_
+ sky130_fd_sc_hd__a31o_2
X_8066_ net744 _3800_ _3801_ VSS VSS VDD VDD _3802_ sky130_fd_sc_hd__nand3_1
X_8067_ _3786_ net612 _3787_ VSS VSS VDD VDD _3803_ sky130_fd_sc_hd__a21oi_1
X_8068_ _3646_ _3803_ _0947_ VSS VSS VDD VDD _3804_ sky130_fd_sc_hd__o21ai_0
Xoutput270 net269 VSS VSS VDD VDD mem_la_wstrb[2] sky130_fd_sc_hd__clkdlybuf4s50_1
X_8070_ net683 _3802_ _3804_ net682 reg_next_pc\[26\] VSS
+ VSS VDD VDD _0636_ sky130_fd_sc_hd__a32o_1
X_8071_ _3785_ _3764_ _0075_ VSS VSS VDD VDD _3806_ sky130_fd_sc_hd__a21oi_1
X_8072_ net744 _3786_ _3764_ _3806_ VSS VSS VDD VDD _3807_
+ sky130_fd_sc_hd__a31oi_1
X_8073_ net744 _0075_ _3807_ net743 net683 VSS VSS VDD VDD
+ _3808_ sky130_fd_sc_hd__o221ai_1
X_8074_ _0433_ _0395_ _3749_ _3687_ VSS VSS VDD VDD _3809_
+ sky130_fd_sc_hd__a31o_2
X_8075_ _0260_ _3809_ _0259_ _0077_ VSS VSS VDD VDD _3810_
+ sky130_fd_sc_hd__a211o_1
X_8076_ _3753_ _3810_ _3716_ VSS VSS VDD VDD _3811_ sky130_fd_sc_hd__a21oi_1
X_8077_ reg_next_pc\[25\] net682 VSS VSS VDD VDD _3812_ sky130_fd_sc_hd__nand2_1
X_8078_ _3808_ _3811_ _3812_ VSS VSS VDD VDD _0637_ sky130_fd_sc_hd__o21ai_0
X_8079_ _3686_ _3687_ VSS VSS VDD VDD _3813_ sky130_fd_sc_hd__nor2_1
X_8080_ _0260_ _3813_ VSS VSS VDD VDD _3814_ sky130_fd_sc_hd__xor2_1
X_8081_ _0431_ _3701_ net612 _0258_ VSS VSS VDD VDD _3815_
+ sky130_fd_sc_hd__a31oi_1
X_8082_ net744 _3785_ net612 _3815_ VSS VSS VDD VDD _3816_
+ sky130_fd_sc_hd__a31oi_1
X_8083_ net744 _0258_ _3816_ net743 VSS VSS VDD VDD _3817_
+ sky130_fd_sc_hd__o22ai_1
X_8084_ net684 _3814_ _3817_ VSS VSS VDD VDD _3818_ sky130_fd_sc_hd__a21oi_1
X_8085_ reg_next_pc\[24\] net682 _3818_ net683 VSS VSS VDD
+ VDD _0638_ sky130_fd_sc_hd__a22o_1
X_8086_ _0395_ _3749_ _0394_ VSS VSS VDD VDD _3819_ sky130_fd_sc_hd__a21oi_1
X_8087_ _0433_ _3819_ VSS VSS VDD VDD _3820_ sky130_fd_sc_hd__xnor2_1
X_8088_ _3701_ _3764_ VSS VSS VDD VDD _3821_ sky130_fd_sc_hd__nand2_2
X_8089_ net699 _0431_ _3821_ VSS VSS VDD VDD _3822_ sky130_fd_sc_hd__or3_1
X_8090_ _0431_ _3821_ VSS VSS VDD VDD _3823_ sky130_fd_sc_hd__nand2_1
X_8091_ _3822_ _3823_ net743 VSS VSS VDD VDD _3824_ sky130_fd_sc_hd__a21oi_1
X_8092_ net699 _0431_ net684 _3820_ _3824_ VSS VSS VDD VDD
+ _3825_ sky130_fd_sc_hd__a221o_1
X_8093_ reg_next_pc\[23\] net682 _3825_ net683 VSS VSS VDD
+ VDD _0639_ sky130_fd_sc_hd__a22o_1
X_8094_ net744 _0393_ VSS VSS VDD VDD _3826_ sky130_fd_sc_hd__nand2_1
X_8095_ _0932_ _0934_ VSS VSS VDD VDD _3827_ sky130_fd_sc_hd__nor2_1
X_8096_ _0094_ _3827_ net612 VSS VSS VDD VDD _3828_ sky130_fd_sc_hd__nand3_1
X_8097_ _3826_ _0393_ _3828_ VSS VSS VDD VDD _3829_ sky130_fd_sc_hd__mux2_2
X_8098_ net744 _0393_ _3829_ net743 net683 VSS VSS VDD VDD
+ _3830_ sky130_fd_sc_hd__o221ai_1
X_8099_ _3665_ _3684_ VSS VSS VDD VDD _3831_ sky130_fd_sc_hd__nand2_1
X_8100_ _0395_ _3831_ VSS VSS VDD VDD _3832_ sky130_fd_sc_hd__xor2_1
X_8101_ _3716_ _3832_ VSS VSS VDD VDD _3833_ sky130_fd_sc_hd__nor2_1
X_8102_ reg_next_pc\[22\] net682 VSS VSS VDD VDD _3834_ sky130_fd_sc_hd__nand2_1
X_8103_ _3830_ _3833_ _3834_ VSS VSS VDD VDD _0640_ sky130_fd_sc_hd__o21ai_0
Xoutput269 net268 VSS VSS VDD VDD mem_la_wstrb[1] sky130_fd_sc_hd__clkdlybuf4s50_1
X_8105_ net744 _0094_ VSS VSS VDD VDD _3836_ sky130_fd_sc_hd__nand2_1
X_8106_ _3827_ _3764_ VSS VSS VDD VDD _3837_ sky130_fd_sc_hd__nand2_1
X_8107_ _3836_ _0094_ _3837_ VSS VSS VDD VDD _3838_ sky130_fd_sc_hd__mux2_2
X_8108_ _3739_ _3742_ VSS VSS VDD VDD _3839_ sky130_fd_sc_hd__nor2_1
X_8109_ _3745_ _3839_ _0073_ VSS VSS VDD VDD _3840_ sky130_fd_sc_hd__o21bai_1
X_8110_ _0096_ _3840_ VSS VSS VDD VDD _3841_ sky130_fd_sc_hd__xnor2_1
X_8111_ net684 _3841_ VSS VSS VDD VDD _3842_ sky130_fd_sc_hd__nand2_1
X_8112_ net744 _0094_ _3838_ net743 _3842_ VSS VSS VDD VDD
+ _3843_ sky130_fd_sc_hd__o221ai_1
X_8113_ net750 reg_next_pc\[21\] net171 VSS VSS VDD VDD _3844_
+ sky130_fd_sc_hd__o21ai_0
X_8114_ net750 _3843_ _3844_ VSS VSS VDD VDD _0641_ sky130_fd_sc_hd__a21oi_1
X_8115_ _0428_ net612 _0072_ VSS VSS VDD VDD _3845_ sky130_fd_sc_hd__a21oi_1
X_8116_ net744 _3827_ net612 _3845_ VSS VSS VDD VDD _3846_
+ sky130_fd_sc_hd__a31oi_1
X_8117_ net744 _0072_ _3846_ net743 net683 VSS VSS VDD VDD
+ _3847_ sky130_fd_sc_hd__o221ai_1
X_8118_ _3677_ _3680_ VSS VSS VDD VDD _3848_ sky130_fd_sc_hd__nand2_1
X_8119_ _0099_ _0263_ _0401_ _0419_ VSS VSS VDD VDD _3849_
+ sky130_fd_sc_hd__nand4_1
X_8120_ _3848_ _3849_ _3661_ VSS VSS VDD VDD _3850_ sky130_fd_sc_hd__o21ai_0
X_8121_ _0398_ _3850_ _0397_ VSS VSS VDD VDD _3851_ sky130_fd_sc_hd__a21o_1
X_8122_ _0430_ _3851_ _0429_ VSS VSS VDD VDD _3852_ sky130_fd_sc_hd__a21oi_1
X_8123_ _0074_ _3852_ VSS VSS VDD VDD _3853_ sky130_fd_sc_hd__xnor2_1
X_8124_ _3716_ _3853_ VSS VSS VDD VDD _3854_ sky130_fd_sc_hd__nor2_1
X_8125_ reg_next_pc\[20\] net682 VSS VSS VDD VDD _3855_ sky130_fd_sc_hd__nand2_1
X_8126_ _3847_ _3854_ _3855_ VSS VSS VDD VDD _0642_ sky130_fd_sc_hd__o21ai_0
X_8127_ _0419_ _3739_ _0418_ VSS VSS VDD VDD _3856_ sky130_fd_sc_hd__a21o_1
X_8128_ _0398_ _3856_ _0397_ VSS VSS VDD VDD _3857_ sky130_fd_sc_hd__a21oi_1
X_8129_ _0430_ _3857_ VSS VSS VDD VDD _3858_ sky130_fd_sc_hd__xnor2_1
X_8130_ _0932_ _3764_ VSS VSS VDD VDD _3859_ sky130_fd_sc_hd__nor2_1
X_8131_ net744 _0932_ _3764_ _3859_ VSS VSS VDD VDD _3860_
+ sky130_fd_sc_hd__a31oi_1
X_8132_ net744 _0932_ _3860_ net743 VSS VSS VDD VDD _3861_
+ sky130_fd_sc_hd__o22ai_1
X_8133_ net684 _3858_ _3861_ VSS VSS VDD VDD _3862_ sky130_fd_sc_hd__a21oi_1
Xoutput268 net267 VSS VSS VDD VDD mem_la_wstrb[0] sky130_fd_sc_hd__clkdlybuf4s50_1
X_8135_ net750 reg_next_pc\[19\] net171 VSS VSS VDD VDD _3864_
+ sky130_fd_sc_hd__o21ai_0
X_8136_ net750 _3862_ _3864_ VSS VSS VDD VDD _0643_ sky130_fd_sc_hd__a21oi_1
X_8137_ _0398_ _3850_ VSS VSS VDD VDD _3865_ sky130_fd_sc_hd__xnor2_1
X_8138_ net699 _0930_ VSS VSS VDD VDD _3866_ sky130_fd_sc_hd__nor2_1
X_8139_ _0926_ _3706_ _3708_ _3709_ VSS VSS VDD VDD _3867_
+ sky130_fd_sc_hd__nor4_1
X_8140_ _0930_ _3866_ _3867_ VSS VSS VDD VDD _3868_ sky130_fd_sc_hd__mux2i_1
X_8141_ net744 _0396_ _3868_ net743 VSS VSS VDD VDD _3869_
+ sky130_fd_sc_hd__o22ai_1
X_8142_ net684 _3865_ _3869_ VSS VSS VDD VDD _3870_ sky130_fd_sc_hd__a21oi_1
X_8143_ reg_next_pc\[18\] _3870_ net750 VSS VSS VDD VDD _3871_
+ sky130_fd_sc_hd__mux2i_1
Xoutput267 net266 VSS VSS VDD VDD mem_la_write sky130_fd_sc_hd__clkdlybuf4s50_1
X_8145_ _3871_ net171 VSS VSS VDD VDD _0644_ sky130_fd_sc_hd__nor2b_1
X_8146_ _0419_ _3739_ VSS VSS VDD VDD _3873_ sky130_fd_sc_hd__xor2_1
X_8147_ net744 _0926_ VSS VSS VDD VDD _3874_ sky130_fd_sc_hd__nand2_1
X_8148_ _3708_ _3709_ _3763_ VSS VSS VDD VDD _3875_ sky130_fd_sc_hd__or3_1
X_8149_ _3874_ _0926_ _3875_ VSS VSS VDD VDD _3876_ sky130_fd_sc_hd__mux2_2
X_8150_ net744 _0926_ _3876_ net743 net750 VSS VSS VDD VDD
+ _3877_ sky130_fd_sc_hd__o221ai_1
X_8151_ net684 _3873_ _3877_ VSS VSS VDD VDD _3878_ sky130_fd_sc_hd__a21oi_1
Xoutput266 net265 VSS VSS VDD VDD mem_la_wdata[9] sky130_fd_sc_hd__clkdlybuf4s50_1
X_8153_ net750 reg_next_pc\[17\] net171 VSS VSS VDD VDD _3880_
+ sky130_fd_sc_hd__o21ai_0
X_8154_ _3878_ _3880_ VSS VSS VDD VDD _0645_ sky130_fd_sc_hd__nor2_1
X_8155_ cpu_state\[1\] net776 VSS VSS VDD VDD _3881_ sky130_fd_sc_hd__nand2_1
X_8156_ _0401_ _3677_ _3680_ _0400_ VSS VSS VDD VDD _3882_
+ sky130_fd_sc_hd__a31o_2
X_8157_ _0263_ _3882_ _0262_ VSS VSS VDD VDD _3883_ sky130_fd_sc_hd__a21oi_1
X_8158_ _0099_ _3883_ VSS VSS VDD VDD _3884_ sky130_fd_sc_hd__xnor2_1
X_8159_ net744 _0923_ VSS VSS VDD VDD _3885_ sky130_fd_sc_hd__nand2_1
X_8160_ _0399_ _3707_ VSS VSS VDD VDD _3886_ sky130_fd_sc_hd__and2_1
X_8161_ _0261_ _3886_ VSS VSS VDD VDD _3887_ sky130_fd_sc_hd__nand2_1
X_8162_ _3706_ _3887_ _3709_ VSS VSS VDD VDD _3888_ sky130_fd_sc_hd__nor3_1
X_8163_ _0923_ _3885_ _3888_ VSS VSS VDD VDD _3889_ sky130_fd_sc_hd__mux2_2
X_8164_ net744 _0923_ _3889_ net743 VSS VSS VDD VDD _3890_
+ sky130_fd_sc_hd__o22ai_1
X_8165_ net684 _3884_ _3890_ VSS VSS VDD VDD _3891_ sky130_fd_sc_hd__a21oi_1
X_8166_ reg_next_pc\[16\] net682 VSS VSS VDD VDD _3892_ sky130_fd_sc_hd__nand2_1
X_8167_ _3881_ _3891_ _3892_ VSS VSS VDD VDD _0646_ sky130_fd_sc_hd__o21ai_0
X_8168_ _3709_ _3763_ VSS VSS VDD VDD _3893_ sky130_fd_sc_hd__nor2_1
X_8169_ _3886_ _3893_ _0261_ VSS VSS VDD VDD _3894_ sky130_fd_sc_hd__a21oi_1
X_8170_ net744 _3893_ VSS VSS VDD VDD _3895_ sky130_fd_sc_hd__nand2_1
X_8171_ _3887_ _3895_ VSS VSS VDD VDD _3896_ sky130_fd_sc_hd__nor2_1
X_8172_ _3894_ _3896_ VSS VSS VDD VDD _3897_ sky130_fd_sc_hd__nor2_1
X_8173_ net744 _0261_ _3897_ net743 net683 VSS VSS VDD VDD
+ _3898_ sky130_fd_sc_hd__o221ai_1
X_8174_ _3732_ _3736_ VSS VSS VDD VDD _3899_ sky130_fd_sc_hd__nand2_1
X_8175_ _3678_ _3899_ _3675_ VSS VSS VDD VDD _3900_ sky130_fd_sc_hd__o21ai_0
X_8176_ _0427_ _3900_ VSS VSS VDD VDD _3901_ sky130_fd_sc_hd__nand2_1
X_8177_ _3676_ _3901_ VSS VSS VDD VDD _3902_ sky130_fd_sc_hd__nand2_1
X_8178_ _0401_ _3902_ _0400_ VSS VSS VDD VDD _3903_ sky130_fd_sc_hd__a21oi_1
X_8179_ _0263_ _3903_ VSS VSS VDD VDD _3904_ sky130_fd_sc_hd__xnor2_1
X_8180_ _3716_ _3904_ VSS VSS VDD VDD _3905_ sky130_fd_sc_hd__nor2_1
X_8181_ reg_next_pc\[15\] net682 VSS VSS VDD VDD _3906_ sky130_fd_sc_hd__nand2_1
X_8182_ _3898_ _3905_ _3906_ VSS VSS VDD VDD _0647_ sky130_fd_sc_hd__o21ai_0
X_8183_ _0401_ _3848_ VSS VSS VDD VDD _3907_ sky130_fd_sc_hd__xnor2_1
X_8184_ _3706_ _3709_ VSS VSS VDD VDD _3908_ sky130_fd_sc_hd__nor2_1
X_8185_ net699 _0399_ VSS VSS VDD VDD _3909_ sky130_fd_sc_hd__nor2_1
X_8186_ _3707_ _3908_ _0916_ VSS VSS VDD VDD _3910_ sky130_fd_sc_hd__a21oi_1
X_8187_ _3707_ _3908_ _3909_ _3910_ VSS VSS VDD VDD _3911_
+ sky130_fd_sc_hd__a31oi_1
X_8188_ net744 _0916_ _3911_ net743 net750 VSS VSS VDD VDD
+ _3912_ sky130_fd_sc_hd__o221ai_1
X_8189_ net684 _3907_ _3912_ VSS VSS VDD VDD _3913_ sky130_fd_sc_hd__a21oi_1
X_8190_ net750 reg_next_pc\[14\] net171 VSS VSS VDD VDD _3914_
+ sky130_fd_sc_hd__o21ai_0
X_8191_ _3913_ _3914_ VSS VSS VDD VDD _0648_ sky130_fd_sc_hd__nor2_1
X_8192_ _0907_ _0909_ VSS VSS VDD VDD _3915_ sky130_fd_sc_hd__nor2_1
X_8193_ _3915_ _3893_ _0425_ VSS VSS VDD VDD _3916_ sky130_fd_sc_hd__a21oi_1
X_8194_ net744 _3707_ _3893_ _3916_ VSS VSS VDD VDD _3917_
+ sky130_fd_sc_hd__a31oi_1
X_8195_ net744 _0425_ _3917_ net743 net683 VSS VSS VDD VDD
+ _3918_ sky130_fd_sc_hd__o221ai_1
X_8196_ _0427_ _3900_ VSS VSS VDD VDD _3919_ sky130_fd_sc_hd__xor2_1
X_8197_ _3716_ _3919_ VSS VSS VDD VDD _3920_ sky130_fd_sc_hd__nor2_1
X_8198_ reg_next_pc\[13\] net682 VSS VSS VDD VDD _3921_ sky130_fd_sc_hd__nand2_1
X_8199_ _3918_ _3920_ _3921_ VSS VSS VDD VDD _0649_ sky130_fd_sc_hd__o21ai_0
X_8200_ _0460_ _3908_ _0120_ VSS VSS VDD VDD _3922_ sky130_fd_sc_hd__a21oi_1
X_8201_ decoder_trigger _3915_ _3908_ _3922_ VSS VSS VDD VDD
+ _3923_ sky130_fd_sc_hd__a31oi_1
X_8202_ decoder_trigger _0120_ _3923_ net743 net683 VSS VSS
+ VDD VDD _3924_ sky130_fd_sc_hd__o221ai_1
X_8203_ _0404_ VSS VSS VDD VDD _3925_ sky130_fd_sc_hd__inv_1
X_8204_ _3669_ _3671_ _3672_ VSS VSS VDD VDD _3926_ sky130_fd_sc_hd__o21ai_0
X_8205_ _0119_ _3926_ _0118_ VSS VSS VDD VDD _3927_ sky130_fd_sc_hd__a21oi_1
X_8206_ _3925_ _3927_ _0403_ VSS VSS VDD VDD _3928_ sky130_fd_sc_hd__o21bai_1
X_8207_ _0462_ _3928_ _0461_ VSS VSS VDD VDD _3929_ sky130_fd_sc_hd__a21oi_1
X_8208_ _0122_ _3929_ VSS VSS VDD VDD _3930_ sky130_fd_sc_hd__xnor2_1
X_8209_ _3716_ _3930_ VSS VSS VDD VDD _3931_ sky130_fd_sc_hd__nor2_1
X_8210_ reg_next_pc\[12\] net682 VSS VSS VDD VDD _3932_ sky130_fd_sc_hd__nand2_1
X_8211_ _3924_ _3931_ _3932_ VSS VSS VDD VDD _0650_ sky130_fd_sc_hd__o21ai_0
X_8212_ _3893_ _3895_ _0460_ VSS VSS VDD VDD _3933_ sky130_fd_sc_hd__mux2_2
X_8213_ _3732_ _3736_ VSS VSS VDD VDD _3934_ sky130_fd_sc_hd__and2_1
X_8214_ _0119_ _3934_ _0118_ VSS VSS VDD VDD _3935_ sky130_fd_sc_hd__a21oi_1
X_8215_ _3925_ _3935_ _0403_ VSS VSS VDD VDD _3936_ sky130_fd_sc_hd__o21bai_1
X_8216_ _0462_ _3936_ VSS VSS VDD VDD _3937_ sky130_fd_sc_hd__xnor2_1
X_8217_ net684 _3937_ VSS VSS VDD VDD _3938_ sky130_fd_sc_hd__nand2_1
X_8218_ decoder_trigger _0460_ _3933_ net743 _3938_ VSS VSS
+ VDD VDD _3939_ sky130_fd_sc_hd__o221ai_1
X_8219_ net750 reg_next_pc\[11\] net171 VSS VSS VDD VDD _3940_
+ sky130_fd_sc_hd__o21ai_0
X_8220_ net750 _3939_ _3940_ VSS VSS VDD VDD _0651_ sky130_fd_sc_hd__a21oi_1
X_8221_ _0404_ _3927_ VSS VSS VDD VDD _3941_ sky130_fd_sc_hd__xnor2_1
X_8222_ decoder_trigger _0905_ VSS VSS VDD VDD _3942_ sky130_fd_sc_hd__nand2_1
X_8223_ _0276_ _0457_ _0117_ _3705_ VSS VSS VDD VDD _3943_
+ sky130_fd_sc_hd__nand4_1
X_8224_ _3942_ _0905_ _3943_ VSS VSS VDD VDD _3944_ sky130_fd_sc_hd__mux2_2
X_8225_ decoder_trigger _0905_ _3944_ net743 net750 VSS VSS
+ VDD VDD _3945_ sky130_fd_sc_hd__o221ai_1
X_8226_ net684 _3941_ _3945_ VSS VSS VDD VDD _3946_ sky130_fd_sc_hd__a21oi_1
X_8227_ net750 reg_next_pc\[10\] net171 VSS VSS VDD VDD _3947_
+ sky130_fd_sc_hd__o21ai_0
X_8228_ _3946_ _3947_ VSS VSS VDD VDD _0652_ sky130_fd_sc_hd__nor2_1
X_8229_ net699 _0903_ VSS VSS VDD VDD _3948_ sky130_fd_sc_hd__nor2_1
X_8230_ _3948_ _0903_ _3763_ VSS VSS VDD VDD _3949_ sky130_fd_sc_hd__mux2i_1
X_8231_ _0119_ _3934_ VSS VSS VDD VDD _3950_ sky130_fd_sc_hd__xnor2_1
X_8232_ net684 _3950_ VSS VSS VDD VDD _3951_ sky130_fd_sc_hd__nand2_1
X_8233_ decoder_trigger _0117_ _3949_ net743 _3951_ VSS VSS
+ VDD VDD _3952_ sky130_fd_sc_hd__o221ai_1
X_8234_ net750 reg_next_pc\[9\] net171 VSS VSS VDD VDD _3953_
+ sky130_fd_sc_hd__o21ai_0
X_8235_ net750 _3952_ _3953_ VSS VSS VDD VDD _0653_ sky130_fd_sc_hd__a21oi_1
X_8236_ _0406_ _3670_ _0436_ VSS VSS VDD VDD _3954_ sky130_fd_sc_hd__o21ai_0
X_8237_ _3669_ _3954_ _0435_ VSS VSS VDD VDD _3955_ sky130_fd_sc_hd__o21bai_1
X_8238_ _0367_ _3955_ VSS VSS VDD VDD _3956_ sky130_fd_sc_hd__xor2_1
X_8239_ _0895_ _0897_ VSS VSS VDD VDD _3957_ sky130_fd_sc_hd__nor2_1
X_8240_ _0276_ _0457_ _0434_ _3957_ VSS VSS VDD VDD _3958_
+ sky130_fd_sc_hd__nand4_1
X_8241_ net699 _0365_ _3958_ VSS VSS VDD VDD _3959_ sky130_fd_sc_hd__nor3_1
X_8242_ _0365_ _3958_ _3959_ VSS VSS VDD VDD _3960_ sky130_fd_sc_hd__a21oi_1
X_8243_ decoder_trigger _0901_ _3960_ net743 net750 VSS VSS
+ VDD VDD _3961_ sky130_fd_sc_hd__o221ai_1
X_8244_ net684 _3956_ _3961_ VSS VSS VDD VDD _3962_ sky130_fd_sc_hd__a21oi_1
X_8245_ net750 reg_next_pc\[8\] net171 VSS VSS VDD VDD _3963_
+ sky130_fd_sc_hd__o21ai_0
X_8246_ _3962_ _3963_ VSS VSS VDD VDD _0654_ sky130_fd_sc_hd__nor2_1
X_8247_ _3729_ _3730_ _0274_ VSS VSS VDD VDD _3964_ sky130_fd_sc_hd__o21bai_1
X_8248_ _0407_ _3964_ _0406_ VSS VSS VDD VDD _3965_ sky130_fd_sc_hd__a21oi_1
X_8249_ _0436_ _3965_ VSS VSS VDD VDD _3966_ sky130_fd_sc_hd__xor2_1
X_8250_ decoder_trigger _0434_ _3957_ _3762_ VSS VSS VDD VDD
+ _3967_ sky130_fd_sc_hd__nand4_1
X_8251_ _3957_ _3762_ VSS VSS VDD VDD _3968_ sky130_fd_sc_hd__nand2_1
X_8252_ _0899_ _3968_ VSS VSS VDD VDD _3969_ sky130_fd_sc_hd__nand2_1
X_8253_ _3967_ _3969_ net743 VSS VSS VDD VDD _3970_ sky130_fd_sc_hd__a21oi_1
X_8254_ net684 _3966_ _3970_ VSS VSS VDD VDD _3971_ sky130_fd_sc_hd__a21oi_1
X_8255_ decoder_trigger _0434_ _3971_ VSS VSS VDD VDD _3972_
+ sky130_fd_sc_hd__o21ai_0
X_8256_ net750 reg_next_pc\[7\] net171 VSS VSS VDD VDD _3973_
+ sky130_fd_sc_hd__o21ai_0
X_8257_ net750 _3972_ _3973_ VSS VSS VDD VDD _0655_ sky130_fd_sc_hd__a21oi_1
X_8258_ _0051_ _0069_ _0408_ VSS VSS VDD VDD _3974_ sky130_fd_sc_hd__a21oi_1
X_8259_ _3974_ _0268_ VSS VSS VDD VDD _3975_ sky130_fd_sc_hd__nor2b_1
X_8260_ _0267_ _3975_ _0459_ VSS VSS VDD VDD _3976_ sky130_fd_sc_hd__o21ai_0
X_8261_ _0458_ _3976_ VSS VSS VDD VDD _3977_ sky130_fd_sc_hd__nand2b_1
X_8262_ _0275_ _3977_ _0274_ VSS VSS VDD VDD _3978_ sky130_fd_sc_hd__a21oi_1
X_8263_ _0407_ _3978_ VSS VSS VDD VDD _3979_ sky130_fd_sc_hd__xnor2_1
X_8264_ _0276_ _0457_ _0273_ VSS VSS VDD VDD _3980_ sky130_fd_sc_hd__nand3_1
X_8265_ net699 _0405_ _3980_ VSS VSS VDD VDD _3981_ sky130_fd_sc_hd__nor3_1
X_8266_ _0405_ _3980_ _3981_ VSS VSS VDD VDD _3982_ sky130_fd_sc_hd__a21oi_1
X_8267_ decoder_trigger _0897_ _3982_ net743 VSS VSS VDD VDD
+ _3983_ sky130_fd_sc_hd__o22ai_1
X_8268_ net684 _3979_ _3983_ VSS VSS VDD VDD _3984_ sky130_fd_sc_hd__a21oi_1
X_8269_ net750 _3984_ VSS VSS VDD VDD _3985_ sky130_fd_sc_hd__nand2_1
X_8270_ net750 reg_next_pc\[6\] net171 _3985_ VSS VSS VDD
+ VDD _0656_ sky130_fd_sc_hd__o211a_1
X_8271_ _0053_ _0268_ _0267_ VSS VSS VDD VDD _3986_ sky130_fd_sc_hd__a21o_1
X_8272_ _0459_ _3986_ _0458_ _0275_ VSS VSS VDD VDD _3987_
+ sky130_fd_sc_hd__a211oi_1
X_8273_ _3729_ _3730_ net684 VSS VSS VDD VDD _3988_ sky130_fd_sc_hd__o21ai_0
X_8274_ decoder_trigger _0895_ _3987_ _3988_ net750 VSS VSS
+ VDD VDD _3989_ sky130_fd_sc_hd__o221ai_1
X_8275_ net699 _0273_ VSS VSS VDD VDD _3990_ sky130_fd_sc_hd__nor2_1
X_8276_ _0895_ _3762_ VSS VSS VDD VDD _3991_ sky130_fd_sc_hd__nor2_1
X_8277_ _3762_ _3990_ _3991_ VSS VSS VDD VDD _3992_ sky130_fd_sc_hd__a21oi_1
X_8278_ net743 _3992_ VSS VSS VDD VDD _3993_ sky130_fd_sc_hd__nor2_1
X_8279_ net750 reg_next_pc\[5\] _3989_ _3993_ net171 VSS VSS
+ VDD VDD _0657_ sky130_fd_sc_hd__o221a_2
X_8280_ _0459_ _0267_ _3975_ VSS VSS VDD VDD _3994_ sky130_fd_sc_hd__or3_1
X_8281_ net684 _3976_ _3994_ VSS VSS VDD VDD _3995_ sky130_fd_sc_hd__nand3_1
X_8282_ _0276_ net743 decoder_trigger VSS VSS VDD VDD _3996_
+ sky130_fd_sc_hd__o21ai_0
X_8283_ _0276_ net676 VSS VSS VDD VDD _3997_ sky130_fd_sc_hd__nand2_1
X_8284_ _0457_ _3997_ VSS VSS VDD VDD _3998_ sky130_fd_sc_hd__nor2_1
X_8285_ _0457_ _3996_ _3998_ VSS VSS VDD VDD _3999_ sky130_fd_sc_hd__a21oi_1
X_8286_ net750 reg_next_pc\[4\] net171 VSS VSS VDD VDD _4000_
+ sky130_fd_sc_hd__o21ai_0
X_8287_ net750 _3995_ _3999_ _4000_ VSS VSS VDD VDD _0658_
+ sky130_fd_sc_hd__a31oi_1
X_8288_ _0053_ _0268_ VSS VSS VDD VDD _4001_ sky130_fd_sc_hd__xnor2_1
X_8289_ net743 _0277_ VSS VSS VDD VDD _4002_ sky130_fd_sc_hd__nor2_1
X_8290_ net743 _4001_ _4002_ net699 VSS VSS VDD VDD _4003_
+ sky130_fd_sc_hd__a211oi_1
Xoutput265 net264 VSS VSS VDD VDD mem_la_wdata[8] sky130_fd_sc_hd__clkdlybuf4s50_1
X_8292_ net699 _0266_ _4003_ _3485_ VSS VSS VDD VDD _4005_
+ sky130_fd_sc_hd__a211o_1
X_8293_ net750 reg_next_pc\[3\] net171 _4005_ VSS VSS VDD
+ VDD _0659_ sky130_fd_sc_hd__o211a_1
X_8294_ net750 reg_next_pc\[2\] VSS VSS VDD VDD _4006_ sky130_fd_sc_hd__nor2b_1
X_8295_ decoder_trigger _0888_ VSS VSS VDD VDD _4007_ sky130_fd_sc_hd__nor2_1
X_8296_ _0888_ net676 _4007_ VSS VSS VDD VDD _4008_ sky130_fd_sc_hd__a21oi_1
X_8297_ _0054_ net684 VSS VSS VDD VDD _4009_ sky130_fd_sc_hd__nand2_1
Xoutput264 net263 VSS VSS VDD VDD mem_la_wdata[7] sky130_fd_sc_hd__clkdlybuf4s50_1
X_8299_ _4008_ _4009_ _3485_ VSS VSS VDD VDD _4011_ sky130_fd_sc_hd__a21oi_1
X_8300_ _4006_ _4011_ net171 VSS VSS VDD VDD _0660_ sky130_fd_sc_hd__o21a_1
X_8301_ _0421_ _0420_ _3716_ VSS VSS VDD VDD _4012_ sky130_fd_sc_hd__mux2i_1
X_8302_ reg_next_pc\[1\] net682 VSS VSS VDD VDD _4013_ sky130_fd_sc_hd__nand2_1
X_8303_ _3881_ _4012_ _4013_ VSS VSS VDD VDD _0661_ sky130_fd_sc_hd__o21ai_0
X_8304_ count_cycle\[59\] VSS VSS VDD VDD _4014_ sky130_fd_sc_hd__inv_1
X_8305_ count_cycle\[56\] VSS VSS VDD VDD _4015_ sky130_fd_sc_hd__inv_1
X_8306_ count_cycle\[50\] count_cycle\[49\] count_cycle\[51\]
+ VSS VSS VDD VDD _4016_ sky130_fd_sc_hd__and3_1
X_8307_ count_cycle\[53\] count_cycle\[52\] _4016_ VSS VSS
+ VDD VDD _4017_ sky130_fd_sc_hd__and3_1
X_8308_ count_cycle\[55\] count_cycle\[54\] _4017_ VSS VSS
+ VDD VDD _4018_ sky130_fd_sc_hd__nand3_1
X_8309_ _4015_ _4018_ VSS VSS VDD VDD _4019_ sky130_fd_sc_hd__nor2_1
X_8310_ count_cycle\[58\] count_cycle\[57\] _4019_ VSS VSS
+ VDD VDD _4020_ sky130_fd_sc_hd__nand3_1
X_8311_ _4014_ _4020_ VSS VSS VDD VDD _4021_ sky130_fd_sc_hd__nor2_1
X_8312_ count_cycle\[61\] count_cycle\[60\] _4021_ VSS VSS
+ VDD VDD _4022_ sky130_fd_sc_hd__nand3_1
X_8313_ count_cycle\[48\] count_cycle\[47\] count_cycle\[46\]
+ VSS VSS VDD VDD _4023_ sky130_fd_sc_hd__nand3_1
X_8314_ count_cycle\[43\] count_cycle\[42\] count_cycle\[41\]
+ VSS VSS VDD VDD _4024_ sky130_fd_sc_hd__and3_1
X_8315_ count_cycle\[45\] count_cycle\[44\] _4024_ VSS VSS
+ VDD VDD _4025_ sky130_fd_sc_hd__nand3_1
X_8316_ count_cycle\[40\] count_cycle\[39\] count_cycle\[38\]
+ count_cycle\[37\] VSS VSS VDD VDD _4026_ sky130_fd_sc_hd__nand4_1
X_8317_ count_cycle\[19\] count_cycle\[18\] count_cycle\[17\]
+ count_cycle\[16\] VSS VSS VDD VDD _4027_ sky130_fd_sc_hd__and4_1
X_8318_ count_cycle\[21\] count_cycle\[20\] _4027_ VSS VSS
+ VDD VDD _4028_ sky130_fd_sc_hd__and3_1
X_8319_ count_cycle\[24\] count_cycle\[23\] count_cycle\[22\]
+ _4028_ VSS VSS VDD VDD _4029_ sky130_fd_sc_hd__nand4_1
X_8320_ count_cycle\[27\] count_cycle\[26\] count_cycle\[25\]
+ VSS VSS VDD VDD _4030_ sky130_fd_sc_hd__and3_1
X_8321_ count_cycle\[30\] count_cycle\[29\] count_cycle\[28\]
+ _4030_ VSS VSS VDD VDD _4031_ sky130_fd_sc_hd__and4_1
X_8322_ count_cycle\[33\] count_cycle\[32\] count_cycle\[31\]
+ VSS VSS VDD VDD _4032_ sky130_fd_sc_hd__and3_1
X_8323_ count_cycle\[35\] count_cycle\[34\] _4032_ VSS VSS
+ VDD VDD _4033_ sky130_fd_sc_hd__and3_1
X_8324_ count_cycle\[36\] _4031_ _4033_ VSS VSS VDD VDD _4034_
+ sky130_fd_sc_hd__nand3_1
X_8325_ count_cycle\[10\] count_cycle\[9\] VSS VSS VDD VDD
+ _4035_ sky130_fd_sc_hd__nand2_1
X_8326_ count_cycle\[12\] count_cycle\[11\] VSS VSS VDD VDD
+ _4036_ sky130_fd_sc_hd__nand2_1
X_8327_ _4035_ _4036_ VSS VSS VDD VDD _4037_ sky130_fd_sc_hd__nor2_1
X_8328_ count_cycle\[15\] count_cycle\[14\] count_cycle\[13\]
+ _4037_ VSS VSS VDD VDD _4038_ sky130_fd_sc_hd__nand4_1
X_8329_ count_cycle\[5\] count_cycle\[4\] count_cycle\[3\]
+ count_cycle\[2\] VSS VSS VDD VDD _4039_ sky130_fd_sc_hd__and4_1
X_8330_ count_cycle\[6\] count_cycle\[7\] _4039_ VSS VSS VDD
+ VDD _4040_ sky130_fd_sc_hd__and3_1
X_8331_ count_cycle\[8\] _0132_ _4040_ VSS VSS VDD VDD _4041_
+ sky130_fd_sc_hd__and3_1
X_8332_ _4038_ _4041_ VSS VSS VDD VDD _4042_ sky130_fd_sc_hd__nand2b_1
X_8333_ _4026_ _4029_ _4034_ _4042_ VSS VSS VDD VDD _4043_
+ sky130_fd_sc_hd__nor4_2
X_8334_ _4025_ _4043_ VSS VSS VDD VDD _4044_ sky130_fd_sc_hd__nand2b_1
X_8335_ _4023_ _4044_ VSS VSS VDD VDD _4045_ sky130_fd_sc_hd__or2_2
Xoutput263 net262 VSS VSS VDD VDD mem_la_wdata[6] sky130_fd_sc_hd__clkdlybuf4s50_1
X_8337_ _4022_ _4045_ count_cycle\[62\] VSS VSS VDD VDD _4047_
+ sky130_fd_sc_hd__o21ai_0
X_8338_ count_cycle\[62\] _4022_ _4045_ VSS VSS VDD VDD _4048_
+ sky130_fd_sc_hd__or3_1
X_8339_ _4047_ _4048_ net775 VSS VSS VDD VDD _0662_ sky130_fd_sc_hd__a21boi_0
X_8340_ count_cycle\[60\] _4021_ VSS VSS VDD VDD _4049_ sky130_fd_sc_hd__nand2_1
X_8341_ count_cycle\[8\] count_cycle\[1\] count_cycle\[0\]
+ _4040_ VSS VSS VDD VDD _4050_ sky130_fd_sc_hd__nand4_4
X_8342_ _4038_ _4050_ VSS VSS VDD VDD _4051_ sky130_fd_sc_hd__or2_1
X_8343_ _4029_ _4034_ _4051_ VSS VSS VDD VDD _4052_ sky130_fd_sc_hd__nor3_4
X_8344_ _4026_ _4052_ VSS VSS VDD VDD _4053_ sky130_fd_sc_hd__nand2b_2
X_8345_ _4023_ _4025_ _4053_ VSS VSS VDD VDD _4054_ sky130_fd_sc_hd__or3_1
Xoutput262 net261 VSS VSS VDD VDD mem_la_wdata[5] sky130_fd_sc_hd__clkdlybuf4s50_1
X_8347_ _4049_ _4054_ count_cycle\[61\] VSS VSS VDD VDD _4056_
+ sky130_fd_sc_hd__o21ai_0
X_8348_ count_cycle\[61\] _4049_ _4054_ VSS VSS VDD VDD _4057_
+ sky130_fd_sc_hd__or3_1
X_8349_ _4056_ _4057_ net775 VSS VSS VDD VDD _0663_ sky130_fd_sc_hd__a21boi_0
X_8350_ _4014_ _4020_ _4045_ VSS VSS VDD VDD _4058_ sky130_fd_sc_hd__nor3_1
X_8351_ count_cycle\[60\] _4058_ VSS VSS VDD VDD _4059_ sky130_fd_sc_hd__xor2_1
X_8352_ net775 _4059_ VSS VSS VDD VDD _0664_ sky130_fd_sc_hd__and2_1
X_8353_ _4020_ _4054_ count_cycle\[59\] VSS VSS VDD VDD _4060_
+ sky130_fd_sc_hd__o21ai_0
X_8354_ count_cycle\[59\] _4020_ _4054_ VSS VSS VDD VDD _4061_
+ sky130_fd_sc_hd__or3_1
X_8355_ _4060_ _4061_ net775 VSS VSS VDD VDD _0665_ sky130_fd_sc_hd__a21boi_0
X_8356_ count_cycle\[57\] _4019_ VSS VSS VDD VDD _4062_ sky130_fd_sc_hd__nand2_1
X_8357_ _4062_ _4045_ count_cycle\[58\] VSS VSS VDD VDD _4063_
+ sky130_fd_sc_hd__o21ai_0
X_8358_ count_cycle\[58\] _4062_ _4045_ VSS VSS VDD VDD _4064_
+ sky130_fd_sc_hd__or3_1
X_8359_ _4063_ _4064_ net775 VSS VSS VDD VDD _0666_ sky130_fd_sc_hd__a21boi_0
X_8360_ _4015_ _4018_ _4054_ VSS VSS VDD VDD _4065_ sky130_fd_sc_hd__nor3_1
X_8361_ count_cycle\[57\] _4065_ VSS VSS VDD VDD _4066_ sky130_fd_sc_hd__xor2_1
X_8362_ net775 _4066_ VSS VSS VDD VDD _0667_ sky130_fd_sc_hd__and2_1
X_8363_ _4018_ _4045_ count_cycle\[56\] VSS VSS VDD VDD _4067_
+ sky130_fd_sc_hd__o21ai_0
X_8364_ count_cycle\[56\] _4018_ _4045_ VSS VSS VDD VDD _4068_
+ sky130_fd_sc_hd__or3_1
X_8365_ _4067_ _4068_ net775 VSS VSS VDD VDD _0668_ sky130_fd_sc_hd__a21boi_0
X_8366_ count_cycle\[54\] _4017_ VSS VSS VDD VDD _4069_ sky130_fd_sc_hd__nand2_1
X_8367_ _4069_ _4054_ count_cycle\[55\] VSS VSS VDD VDD _4070_
+ sky130_fd_sc_hd__o21ai_0
X_8368_ count_cycle\[55\] _4069_ _4054_ VSS VSS VDD VDD _4071_
+ sky130_fd_sc_hd__or3_1
X_8369_ _4070_ _4071_ net775 VSS VSS VDD VDD _0669_ sky130_fd_sc_hd__a21boi_0
X_8370_ count_cycle\[53\] count_cycle\[52\] _4016_ VSS VSS
+ VDD VDD _4072_ sky130_fd_sc_hd__nand3_1
X_8371_ _4072_ _4045_ VSS VSS VDD VDD _4073_ sky130_fd_sc_hd__nor2_1
X_8372_ count_cycle\[54\] _4073_ VSS VSS VDD VDD _4074_ sky130_fd_sc_hd__xor2_1
X_8373_ net775 _4074_ VSS VSS VDD VDD _0670_ sky130_fd_sc_hd__and2_1
X_8374_ count_cycle\[52\] _4016_ VSS VSS VDD VDD _4075_ sky130_fd_sc_hd__nand2_1
X_8375_ _4075_ _4054_ count_cycle\[53\] VSS VSS VDD VDD _4076_
+ sky130_fd_sc_hd__o21ai_0
X_8376_ count_cycle\[53\] _4075_ _4054_ VSS VSS VDD VDD _4077_
+ sky130_fd_sc_hd__or3_1
X_8377_ _4076_ _4077_ net775 VSS VSS VDD VDD _0671_ sky130_fd_sc_hd__a21boi_0
X_8378_ count_cycle\[50\] count_cycle\[49\] count_cycle\[51\]
+ VSS VSS VDD VDD _4078_ sky130_fd_sc_hd__nand3_1
X_8379_ _4078_ _4045_ VSS VSS VDD VDD _4079_ sky130_fd_sc_hd__nor2_1
X_8380_ count_cycle\[52\] _4079_ VSS VSS VDD VDD _4080_ sky130_fd_sc_hd__xor2_1
X_8381_ net775 _4080_ VSS VSS VDD VDD _0672_ sky130_fd_sc_hd__and2_1
X_8382_ count_cycle\[50\] count_cycle\[49\] VSS VSS VDD VDD
+ _4081_ sky130_fd_sc_hd__nand2_1
X_8383_ _4081_ _4054_ count_cycle\[51\] VSS VSS VDD VDD _4082_
+ sky130_fd_sc_hd__o21ai_0
X_8384_ count_cycle\[51\] _4081_ _4054_ VSS VSS VDD VDD _4083_
+ sky130_fd_sc_hd__or3_1
X_8385_ _4082_ _4083_ net775 VSS VSS VDD VDD _0673_ sky130_fd_sc_hd__a21boi_0
X_8386_ count_cycle\[49\] VSS VSS VDD VDD _4084_ sky130_fd_sc_hd__inv_1
X_8387_ _4084_ _4045_ VSS VSS VDD VDD _4085_ sky130_fd_sc_hd__nor2_1
X_8388_ count_cycle\[50\] _4085_ VSS VSS VDD VDD _4086_ sky130_fd_sc_hd__xor2_1
X_8389_ net775 _4086_ VSS VSS VDD VDD _0674_ sky130_fd_sc_hd__and2_1
X_8390_ count_cycle\[49\] _4054_ VSS VSS VDD VDD _4087_ sky130_fd_sc_hd__xnor2_1
X_8391_ net775 _4087_ VSS VSS VDD VDD _0675_ sky130_fd_sc_hd__and2_1
X_8392_ count_cycle\[47\] count_cycle\[46\] VSS VSS VDD VDD
+ _4088_ sky130_fd_sc_hd__nand2_1
X_8393_ _4088_ _4044_ count_cycle\[48\] VSS VSS VDD VDD _4089_
+ sky130_fd_sc_hd__o21ai_0
X_8394_ count_cycle\[48\] _4088_ _4044_ VSS VSS VDD VDD _4090_
+ sky130_fd_sc_hd__or3_1
X_8395_ _4089_ _4090_ net775 VSS VSS VDD VDD _0676_ sky130_fd_sc_hd__a21boi_0
X_8396_ _4025_ _4053_ VSS VSS VDD VDD _4091_ sky130_fd_sc_hd__nor2_1
X_8397_ count_cycle\[46\] _4091_ VSS VSS VDD VDD _4092_ sky130_fd_sc_hd__nand2_1
X_8398_ count_cycle\[47\] _4092_ VSS VSS VDD VDD _4093_ sky130_fd_sc_hd__xnor2_1
X_8399_ net775 _4093_ VSS VSS VDD VDD _0677_ sky130_fd_sc_hd__and2_1
X_8400_ count_cycle\[46\] _4044_ VSS VSS VDD VDD _4094_ sky130_fd_sc_hd__xnor2_1
X_8401_ net775 _4094_ VSS VSS VDD VDD _0678_ sky130_fd_sc_hd__and2_1
X_8402_ count_cycle\[44\] _4024_ VSS VSS VDD VDD _4095_ sky130_fd_sc_hd__nand2_1
X_8403_ _4095_ _4053_ count_cycle\[45\] VSS VSS VDD VDD _4096_
+ sky130_fd_sc_hd__o21ai_0
X_8404_ count_cycle\[45\] _4095_ _4053_ VSS VSS VDD VDD _4097_
+ sky130_fd_sc_hd__or3_1
X_8405_ _4096_ _4097_ net775 VSS VSS VDD VDD _0679_ sky130_fd_sc_hd__a21boi_0
X_8406_ _4024_ _4043_ VSS VSS VDD VDD _4098_ sky130_fd_sc_hd__nand2_1
X_8407_ count_cycle\[44\] _4098_ VSS VSS VDD VDD _4099_ sky130_fd_sc_hd__xnor2_1
X_8408_ net775 _4099_ VSS VSS VDD VDD _0680_ sky130_fd_sc_hd__and2_1
X_8409_ count_cycle\[42\] count_cycle\[41\] VSS VSS VDD VDD
+ _4100_ sky130_fd_sc_hd__nand2_1
X_8410_ _4100_ _4053_ count_cycle\[43\] VSS VSS VDD VDD _4101_
+ sky130_fd_sc_hd__o21ai_0
X_8411_ count_cycle\[43\] _4100_ _4053_ VSS VSS VDD VDD _4102_
+ sky130_fd_sc_hd__or3_1
X_8412_ _4101_ _4102_ net775 VSS VSS VDD VDD _0681_ sky130_fd_sc_hd__a21boi_0
X_8413_ count_cycle\[41\] _4043_ VSS VSS VDD VDD _4103_ sky130_fd_sc_hd__nand2_1
X_8414_ count_cycle\[42\] _4103_ VSS VSS VDD VDD _4104_ sky130_fd_sc_hd__xnor2_1
X_8415_ net775 _4104_ VSS VSS VDD VDD _0682_ sky130_fd_sc_hd__and2_1
X_8416_ count_cycle\[41\] _4053_ VSS VSS VDD VDD _4105_ sky130_fd_sc_hd__xnor2_1
X_8417_ net775 _4105_ VSS VSS VDD VDD _0683_ sky130_fd_sc_hd__and2_1
X_8418_ count_cycle\[39\] count_cycle\[38\] count_cycle\[37\]
+ VSS VSS VDD VDD _4106_ sky130_fd_sc_hd__nand3_1
X_8419_ _4106_ _4029_ _4034_ _4042_ VSS VSS VDD VDD _4107_
+ sky130_fd_sc_hd__nor4_1
X_8420_ count_cycle\[40\] _4107_ VSS VSS VDD VDD _4108_ sky130_fd_sc_hd__xor2_1
X_8421_ net775 _4108_ VSS VSS VDD VDD _0684_ sky130_fd_sc_hd__and2_1
X_8422_ count_cycle\[38\] count_cycle\[37\] _4052_ VSS VSS
+ VDD VDD _4109_ sky130_fd_sc_hd__nand3_1
X_8423_ count_cycle\[39\] _4109_ VSS VSS VDD VDD _4110_ sky130_fd_sc_hd__xnor2_1
X_8424_ net775 _4110_ VSS VSS VDD VDD _0685_ sky130_fd_sc_hd__and2_1
X_8425_ count_cycle\[37\] VSS VSS VDD VDD _4111_ sky130_fd_sc_hd__inv_1
X_8426_ _4111_ _4029_ _4034_ _4042_ VSS VSS VDD VDD _4112_
+ sky130_fd_sc_hd__or4_1
X_8427_ count_cycle\[38\] _4112_ VSS VSS VDD VDD _4113_ sky130_fd_sc_hd__xnor2_1
X_8428_ net775 _4113_ VSS VSS VDD VDD _0686_ sky130_fd_sc_hd__and2_1
X_8429_ count_cycle\[37\] _4052_ VSS VSS VDD VDD _4114_ sky130_fd_sc_hd__xor2_1
X_8430_ net775 _4114_ VSS VSS VDD VDD _0687_ sky130_fd_sc_hd__and2_1
X_8431_ _4029_ _4042_ VSS VSS VDD VDD _4115_ sky130_fd_sc_hd__nor2_1
X_8432_ _4031_ _4033_ _4115_ VSS VSS VDD VDD _4116_ sky130_fd_sc_hd__and3_1
X_8433_ count_cycle\[36\] _4116_ VSS VSS VDD VDD _4117_ sky130_fd_sc_hd__xor2_1
X_8434_ net775 _4117_ VSS VSS VDD VDD _0688_ sky130_fd_sc_hd__and2_1
X_8435_ count_cycle\[34\] _4032_ VSS VSS VDD VDD _4118_ sky130_fd_sc_hd__nand2_1
X_8436_ _4029_ _4051_ VSS VSS VDD VDD _4119_ sky130_fd_sc_hd__nor2_1
X_8437_ _4031_ _4119_ VSS VSS VDD VDD _4120_ sky130_fd_sc_hd__nand2_1
X_8438_ _4118_ _4120_ count_cycle\[35\] VSS VSS VDD VDD _4121_
+ sky130_fd_sc_hd__o21ai_0
X_8439_ count_cycle\[35\] _4118_ _4120_ VSS VSS VDD VDD _4122_
+ sky130_fd_sc_hd__or3_1
X_8440_ _4121_ _4122_ net775 VSS VSS VDD VDD _0689_ sky130_fd_sc_hd__a21boi_0
X_8441_ _4031_ _4032_ _4115_ VSS VSS VDD VDD _4123_ sky130_fd_sc_hd__and3_1
X_8442_ count_cycle\[34\] _4123_ VSS VSS VDD VDD _4124_ sky130_fd_sc_hd__xor2_1
X_8443_ net775 _4124_ VSS VSS VDD VDD _0690_ sky130_fd_sc_hd__and2_1
X_8444_ count_cycle\[32\] count_cycle\[31\] VSS VSS VDD VDD
+ _4125_ sky130_fd_sc_hd__nand2_1
X_8445_ _4125_ _4120_ count_cycle\[33\] VSS VSS VDD VDD _4126_
+ sky130_fd_sc_hd__o21ai_0
X_8446_ count_cycle\[33\] _4125_ _4120_ VSS VSS VDD VDD _4127_
+ sky130_fd_sc_hd__or3_1
X_8447_ _4126_ _4127_ net775 VSS VSS VDD VDD _0691_ sky130_fd_sc_hd__a21boi_0
X_8448_ count_cycle\[31\] _4031_ _4115_ VSS VSS VDD VDD _4128_
+ sky130_fd_sc_hd__nand3_1
X_8449_ count_cycle\[32\] _4128_ VSS VSS VDD VDD _4129_ sky130_fd_sc_hd__xnor2_1
X_8450_ net775 _4129_ VSS VSS VDD VDD _0692_ sky130_fd_sc_hd__and2_1
X_8451_ count_cycle\[31\] _4120_ VSS VSS VDD VDD _4130_ sky130_fd_sc_hd__xnor2_1
X_8452_ net775 _4130_ VSS VSS VDD VDD _0693_ sky130_fd_sc_hd__and2_1
X_8453_ count_cycle\[29\] count_cycle\[28\] _4030_ _4115_
+ VSS VSS VDD VDD _4131_ sky130_fd_sc_hd__nand4_1
X_8454_ count_cycle\[30\] _4131_ VSS VSS VDD VDD _4132_ sky130_fd_sc_hd__xnor2_1
X_8455_ net776 _4132_ VSS VSS VDD VDD _0694_ sky130_fd_sc_hd__and2_1
X_8456_ count_cycle\[26\] count_cycle\[25\] _4119_ VSS VSS
+ VDD VDD _4133_ sky130_fd_sc_hd__and3_1
X_8457_ count_cycle\[28\] count_cycle\[27\] _4133_ VSS VSS
+ VDD VDD _4134_ sky130_fd_sc_hd__nand3_1
X_8458_ count_cycle\[29\] _4134_ VSS VSS VDD VDD _4135_ sky130_fd_sc_hd__xnor2_1
X_8459_ net776 _4135_ VSS VSS VDD VDD _0695_ sky130_fd_sc_hd__and2_1
X_8460_ _4030_ _4115_ VSS VSS VDD VDD _4136_ sky130_fd_sc_hd__nand2_1
X_8461_ count_cycle\[28\] _4136_ VSS VSS VDD VDD _4137_ sky130_fd_sc_hd__xnor2_1
X_8462_ net776 _4137_ VSS VSS VDD VDD _0696_ sky130_fd_sc_hd__and2_1
X_8463_ count_cycle\[27\] _4133_ VSS VSS VDD VDD _4138_ sky130_fd_sc_hd__xor2_1
X_8464_ net776 _4138_ VSS VSS VDD VDD _0697_ sky130_fd_sc_hd__and2_1
X_8465_ count_cycle\[25\] _4115_ VSS VSS VDD VDD _4139_ sky130_fd_sc_hd__nand2_1
X_8466_ count_cycle\[26\] _4139_ VSS VSS VDD VDD _4140_ sky130_fd_sc_hd__xnor2_1
X_8467_ net776 _4140_ VSS VSS VDD VDD _0698_ sky130_fd_sc_hd__and2_1
X_8468_ count_cycle\[25\] _4119_ VSS VSS VDD VDD _4141_ sky130_fd_sc_hd__xor2_1
X_8469_ net776 _4141_ VSS VSS VDD VDD _0699_ sky130_fd_sc_hd__and2_1
X_8470_ count_cycle\[23\] count_cycle\[22\] _4028_ VSS VSS
+ VDD VDD _4142_ sky130_fd_sc_hd__nand3_1
X_8471_ _4142_ _4042_ count_cycle\[24\] VSS VSS VDD VDD _4143_
+ sky130_fd_sc_hd__o21ai_0
X_8472_ count_cycle\[24\] _4142_ _4042_ VSS VSS VDD VDD _4144_
+ sky130_fd_sc_hd__or3_1
X_8473_ _4143_ _4144_ net775 VSS VSS VDD VDD _0700_ sky130_fd_sc_hd__a21boi_0
X_8474_ _4038_ _4050_ VSS VSS VDD VDD _4145_ sky130_fd_sc_hd__nor2_1
X_8475_ count_cycle\[22\] _4028_ _4145_ VSS VSS VDD VDD _4146_
+ sky130_fd_sc_hd__nand3_1
X_8476_ count_cycle\[23\] _4146_ VSS VSS VDD VDD _4147_ sky130_fd_sc_hd__xnor2_1
X_8477_ net775 _4147_ VSS VSS VDD VDD _0701_ sky130_fd_sc_hd__and2_1
X_8478_ _4038_ _4041_ VSS VSS VDD VDD _4148_ sky130_fd_sc_hd__nor2b_1
X_8479_ _4028_ _4148_ VSS VSS VDD VDD _4149_ sky130_fd_sc_hd__nand2_1
X_8480_ count_cycle\[22\] _4149_ VSS VSS VDD VDD _4150_ sky130_fd_sc_hd__xnor2_1
X_8481_ net775 _4150_ VSS VSS VDD VDD _0702_ sky130_fd_sc_hd__and2_1
X_8482_ count_cycle\[20\] _4027_ _4145_ VSS VSS VDD VDD _4151_
+ sky130_fd_sc_hd__nand3_1
X_8483_ count_cycle\[21\] _4151_ VSS VSS VDD VDD _4152_ sky130_fd_sc_hd__xnor2_1
X_8484_ net775 _4152_ VSS VSS VDD VDD _0703_ sky130_fd_sc_hd__and2_1
X_8485_ _4027_ _4148_ VSS VSS VDD VDD _4153_ sky130_fd_sc_hd__and2_1
X_8486_ count_cycle\[20\] _4153_ VSS VSS VDD VDD _4154_ sky130_fd_sc_hd__xor2_1
X_8487_ net775 _4154_ VSS VSS VDD VDD _0704_ sky130_fd_sc_hd__and2_1
X_8488_ count_cycle\[18\] count_cycle\[17\] count_cycle\[16\]
+ _4145_ VSS VSS VDD VDD _4155_ sky130_fd_sc_hd__nand4_1
X_8489_ count_cycle\[19\] _4155_ VSS VSS VDD VDD _4156_ sky130_fd_sc_hd__xnor2_1
X_8490_ net775 _4156_ VSS VSS VDD VDD _0705_ sky130_fd_sc_hd__and2_1
X_8491_ count_cycle\[17\] count_cycle\[16\] _4148_ VSS VSS
+ VDD VDD _4157_ sky130_fd_sc_hd__and3_1
X_8492_ count_cycle\[18\] _4157_ VSS VSS VDD VDD _4158_ sky130_fd_sc_hd__xor2_1
X_8493_ net775 _4158_ VSS VSS VDD VDD _0706_ sky130_fd_sc_hd__and2_1
X_8494_ count_cycle\[16\] _4145_ VSS VSS VDD VDD _4159_ sky130_fd_sc_hd__nand2_1
X_8495_ count_cycle\[17\] _4159_ VSS VSS VDD VDD _4160_ sky130_fd_sc_hd__xnor2_1
X_8496_ net775 _4160_ VSS VSS VDD VDD _0707_ sky130_fd_sc_hd__and2_1
X_8497_ count_cycle\[16\] _4148_ VSS VSS VDD VDD _4161_ sky130_fd_sc_hd__xnor2_1
X_8498_ _4161_ net775 VSS VSS VDD VDD _0708_ sky130_fd_sc_hd__nor2b_1
X_8499_ count_cycle\[14\] count_cycle\[13\] _4037_ VSS VSS
+ VDD VDD _4162_ sky130_fd_sc_hd__nand3_1
X_8500_ _4162_ _4050_ count_cycle\[15\] VSS VSS VDD VDD _4163_
+ sky130_fd_sc_hd__o21ai_0
X_8501_ count_cycle\[15\] _4162_ _4050_ VSS VSS VDD VDD _4164_
+ sky130_fd_sc_hd__or3_1
X_8502_ _4163_ _4164_ net775 VSS VSS VDD VDD _0709_ sky130_fd_sc_hd__a21boi_0
X_8503_ count_cycle\[13\] _4037_ _4041_ VSS VSS VDD VDD _4165_
+ sky130_fd_sc_hd__nand3_1
X_8504_ count_cycle\[14\] _4165_ VSS VSS VDD VDD _4166_ sky130_fd_sc_hd__xnor2_1
X_8505_ net775 _4166_ VSS VSS VDD VDD _0710_ sky130_fd_sc_hd__and2_1
X_8506_ _4035_ _4036_ _4050_ VSS VSS VDD VDD _4167_ sky130_fd_sc_hd__nor3_1
X_8507_ count_cycle\[13\] _4167_ VSS VSS VDD VDD _4168_ sky130_fd_sc_hd__xor2_1
X_8508_ net775 _4168_ VSS VSS VDD VDD _0711_ sky130_fd_sc_hd__and2_1
X_8509_ count_cycle\[11\] count_cycle\[10\] count_cycle\[9\]
+ _4041_ VSS VSS VDD VDD _4169_ sky130_fd_sc_hd__nand4_1
X_8510_ count_cycle\[12\] _4169_ VSS VSS VDD VDD _4170_ sky130_fd_sc_hd__xnor2_1
X_8511_ net775 _4170_ VSS VSS VDD VDD _0712_ sky130_fd_sc_hd__and2_1
X_8512_ _4035_ _4050_ count_cycle\[11\] VSS VSS VDD VDD _4171_
+ sky130_fd_sc_hd__o21ai_0
X_8513_ count_cycle\[11\] _4035_ _4050_ VSS VSS VDD VDD _4172_
+ sky130_fd_sc_hd__or3_1
X_8514_ _4171_ _4172_ net775 VSS VSS VDD VDD _0713_ sky130_fd_sc_hd__a21boi_0
X_8515_ count_cycle\[9\] _4041_ VSS VSS VDD VDD _4173_ sky130_fd_sc_hd__nand2_1
X_8516_ count_cycle\[10\] _4173_ VSS VSS VDD VDD _4174_ sky130_fd_sc_hd__xnor2_1
X_8517_ net775 _4174_ VSS VSS VDD VDD _0714_ sky130_fd_sc_hd__and2_1
X_8518_ count_cycle\[9\] _4050_ VSS VSS VDD VDD _4175_ sky130_fd_sc_hd__xnor2_1
X_8519_ net775 _4175_ VSS VSS VDD VDD _0715_ sky130_fd_sc_hd__and2_1
X_8520_ _0132_ _4040_ VSS VSS VDD VDD _4176_ sky130_fd_sc_hd__nand2_1
X_8521_ count_cycle\[8\] _4176_ VSS VSS VDD VDD _4177_ sky130_fd_sc_hd__xnor2_1
X_8522_ net775 _4177_ VSS VSS VDD VDD _0716_ sky130_fd_sc_hd__and2_1
X_8523_ count_cycle\[6\] count_cycle\[1\] count_cycle\[0\]
+ _4039_ VSS VSS VDD VDD _4178_ sky130_fd_sc_hd__nand4_1
X_8524_ count_cycle\[7\] _4178_ VSS VSS VDD VDD _4179_ sky130_fd_sc_hd__xnor2_1
X_8525_ net775 _4179_ VSS VSS VDD VDD _0717_ sky130_fd_sc_hd__and2_1
X_8526_ _0132_ _4039_ VSS VSS VDD VDD _4180_ sky130_fd_sc_hd__nand2_1
X_8527_ count_cycle\[6\] _4180_ VSS VSS VDD VDD _4181_ sky130_fd_sc_hd__xnor2_1
X_8528_ net775 _4181_ VSS VSS VDD VDD _0718_ sky130_fd_sc_hd__and2_1
X_8529_ count_cycle\[4\] count_cycle\[3\] count_cycle\[2\]
+ VSS VSS VDD VDD _4182_ sky130_fd_sc_hd__and3_1
X_8530_ count_cycle\[1\] count_cycle\[0\] _4182_ VSS VSS VDD
+ VDD _4183_ sky130_fd_sc_hd__nand3_1
X_8531_ count_cycle\[5\] _4183_ VSS VSS VDD VDD _4184_ sky130_fd_sc_hd__xnor2_1
X_8532_ net775 _4184_ VSS VSS VDD VDD _0719_ sky130_fd_sc_hd__and2_1
X_8533_ _0132_ count_cycle\[3\] count_cycle\[2\] VSS VSS VDD
+ VDD _4185_ sky130_fd_sc_hd__nand3_1
X_8534_ count_cycle\[4\] _4185_ VSS VSS VDD VDD _4186_ sky130_fd_sc_hd__xnor2_1
X_8535_ net775 _4186_ VSS VSS VDD VDD _0720_ sky130_fd_sc_hd__and2_1
X_8536_ count_cycle\[2\] count_cycle\[1\] count_cycle\[0\]
+ VSS VSS VDD VDD _4187_ sky130_fd_sc_hd__nand3_1
X_8537_ count_cycle\[3\] _4187_ VSS VSS VDD VDD _4188_ sky130_fd_sc_hd__xnor2_1
X_8538_ net775 _4188_ VSS VSS VDD VDD _0721_ sky130_fd_sc_hd__and2_1
X_8539_ _0132_ count_cycle\[2\] VSS VSS VDD VDD _4189_ sky130_fd_sc_hd__xor2_1
X_8540_ net775 _4189_ VSS VSS VDD VDD _0722_ sky130_fd_sc_hd__and2_1
X_8541_ net775 _0133_ VSS VSS VDD VDD _0723_ sky130_fd_sc_hd__and2_1
X_8542_ count_cycle\[0\] net775 VSS VSS VDD VDD _0724_ sky130_fd_sc_hd__nor2b_1
X_8543_ reg_pc\[30\] net682 VSS VSS VDD VDD _4190_ sky130_fd_sc_hd__nand2_1
X_8544_ _0958_ _3881_ _4190_ VSS VSS VDD VDD _0725_ sky130_fd_sc_hd__o21ai_0
X_8545_ reg_pc\[29\] net682 VSS VSS VDD VDD _4191_ sky130_fd_sc_hd__nand2_1
X_8546_ _0955_ _3881_ _4191_ VSS VSS VDD VDD _0726_ sky130_fd_sc_hd__o21ai_0
X_8547_ reg_pc\[28\] net682 VSS VSS VDD VDD _4192_ sky130_fd_sc_hd__nand2_1
X_8548_ _0952_ _3881_ _4192_ VSS VSS VDD VDD _0727_ sky130_fd_sc_hd__o21ai_0
X_8549_ _0380_ net683 net682 reg_pc\[27\] VSS VSS VDD VDD
+ _0728_ sky130_fd_sc_hd__a22o_1
X_8550_ reg_pc\[26\] net682 VSS VSS VDD VDD _4193_ sky130_fd_sc_hd__nand2_1
X_8551_ _0947_ _3881_ _4193_ VSS VSS VDD VDD _0729_ sky130_fd_sc_hd__o21ai_0
X_8552_ _0075_ net683 net682 reg_pc\[25\] VSS VSS VDD VDD
+ _0730_ sky130_fd_sc_hd__a22o_1
X_8553_ reg_pc\[24\] _0258_ net750 VSS VSS VDD VDD _4194_
+ sky130_fd_sc_hd__mux2i_1
X_8554_ _4194_ net776 VSS VSS VDD VDD _0731_ sky130_fd_sc_hd__nor2b_1
X_8555_ reg_pc\[23\] _0431_ net750 VSS VSS VDD VDD _4195_
+ sky130_fd_sc_hd__mux2i_1
X_8556_ _4195_ net776 VSS VSS VDD VDD _0732_ sky130_fd_sc_hd__nor2b_1
X_8557_ reg_pc\[22\] _0393_ net750 VSS VSS VDD VDD _4196_
+ sky130_fd_sc_hd__mux2i_1
X_8558_ _4196_ net776 VSS VSS VDD VDD _0733_ sky130_fd_sc_hd__nor2b_1
X_8559_ reg_pc\[21\] _0094_ net750 VSS VSS VDD VDD _4197_
+ sky130_fd_sc_hd__mux2i_1
X_8560_ _4197_ net776 VSS VSS VDD VDD _0734_ sky130_fd_sc_hd__nor2b_1
X_8561_ _3485_ _0934_ VSS VSS VDD VDD _4198_ sky130_fd_sc_hd__nor2_1
X_8562_ _3485_ reg_pc\[20\] _4198_ VSS VSS VDD VDD _4199_
+ sky130_fd_sc_hd__a21oi_1
X_8563_ _4199_ net171 VSS VSS VDD VDD _0735_ sky130_fd_sc_hd__nor2b_1
Xoutput261 net260 VSS VSS VDD VDD mem_la_wdata[4] sky130_fd_sc_hd__clkdlybuf4s50_1
X_8565_ _3485_ _0932_ VSS VSS VDD VDD _4201_ sky130_fd_sc_hd__nor2_1
X_8566_ _3485_ reg_pc\[19\] _4201_ VSS VSS VDD VDD _4202_
+ sky130_fd_sc_hd__a21oi_1
X_8567_ _4202_ net776 VSS VSS VDD VDD _0736_ sky130_fd_sc_hd__nor2b_1
X_8568_ reg_pc\[18\] net682 VSS VSS VDD VDD _4203_ sky130_fd_sc_hd__nand2_1
X_8569_ _0930_ _3881_ _4203_ VSS VSS VDD VDD _0737_ sky130_fd_sc_hd__o21ai_0
X_8570_ _3485_ _0926_ VSS VSS VDD VDD _4204_ sky130_fd_sc_hd__nor2_1
X_8571_ _3485_ reg_pc\[17\] _4204_ VSS VSS VDD VDD _4205_
+ sky130_fd_sc_hd__a21oi_1
X_8572_ _4205_ net171 VSS VSS VDD VDD _0738_ sky130_fd_sc_hd__nor2b_1
X_8573_ _3485_ _0923_ VSS VSS VDD VDD _4206_ sky130_fd_sc_hd__nor2_1
X_8574_ _3485_ reg_pc\[16\] _4206_ VSS VSS VDD VDD _4207_
+ sky130_fd_sc_hd__a21oi_1
X_8575_ _4207_ net171 VSS VSS VDD VDD _0739_ sky130_fd_sc_hd__nor2b_1
X_8576_ reg_pc\[15\] _0261_ net750 VSS VSS VDD VDD _4208_
+ sky130_fd_sc_hd__mux2i_1
X_8577_ _4208_ net171 VSS VSS VDD VDD _0740_ sky130_fd_sc_hd__nor2b_1
X_8578_ _3485_ _0916_ VSS VSS VDD VDD _4209_ sky130_fd_sc_hd__nor2_1
X_8579_ _3485_ reg_pc\[14\] _4209_ VSS VSS VDD VDD _4210_
+ sky130_fd_sc_hd__a21oi_1
X_8580_ _4210_ net171 VSS VSS VDD VDD _0741_ sky130_fd_sc_hd__nor2b_1
X_8581_ _3485_ _0911_ VSS VSS VDD VDD _4211_ sky130_fd_sc_hd__nor2_1
X_8582_ _3485_ reg_pc\[13\] _4211_ VSS VSS VDD VDD _4212_
+ sky130_fd_sc_hd__a21oi_1
X_8583_ _4212_ net171 VSS VSS VDD VDD _0742_ sky130_fd_sc_hd__nor2b_1
X_8584_ _3485_ _0909_ VSS VSS VDD VDD _4213_ sky130_fd_sc_hd__nor2_1
X_8585_ _3485_ reg_pc\[12\] _4213_ VSS VSS VDD VDD _4214_
+ sky130_fd_sc_hd__a21oi_1
X_8586_ _4214_ net171 VSS VSS VDD VDD _0743_ sky130_fd_sc_hd__nor2b_1
X_8587_ _3485_ _0907_ VSS VSS VDD VDD _4215_ sky130_fd_sc_hd__nor2_1
X_8588_ _3485_ reg_pc\[11\] _4215_ VSS VSS VDD VDD _4216_
+ sky130_fd_sc_hd__a21oi_1
X_8589_ _4216_ net171 VSS VSS VDD VDD _0744_ sky130_fd_sc_hd__nor2b_1
X_8590_ _3485_ _0905_ VSS VSS VDD VDD _4217_ sky130_fd_sc_hd__nor2_1
X_8591_ _3485_ reg_pc\[10\] _4217_ VSS VSS VDD VDD _4218_
+ sky130_fd_sc_hd__a21oi_1
X_8592_ _4218_ net171 VSS VSS VDD VDD _0745_ sky130_fd_sc_hd__nor2b_1
X_8593_ _3485_ _0903_ VSS VSS VDD VDD _4219_ sky130_fd_sc_hd__nor2_1
X_8594_ _3485_ reg_pc\[9\] _4219_ VSS VSS VDD VDD _4220_ sky130_fd_sc_hd__a21oi_1
X_8595_ _4220_ net171 VSS VSS VDD VDD _0746_ sky130_fd_sc_hd__nor2b_1
X_8596_ _3485_ _0901_ VSS VSS VDD VDD _4221_ sky130_fd_sc_hd__nor2_1
X_8597_ _3485_ reg_pc\[8\] _4221_ VSS VSS VDD VDD _4222_ sky130_fd_sc_hd__a21oi_1
X_8598_ _4222_ net171 VSS VSS VDD VDD _0747_ sky130_fd_sc_hd__nor2b_1
X_8599_ _3485_ _0899_ VSS VSS VDD VDD _4223_ sky130_fd_sc_hd__nor2_1
X_8600_ _3485_ reg_pc\[7\] _4223_ VSS VSS VDD VDD _4224_ sky130_fd_sc_hd__a21oi_1
X_8601_ _4224_ net171 VSS VSS VDD VDD _0748_ sky130_fd_sc_hd__nor2b_1
X_8602_ _3485_ _0897_ VSS VSS VDD VDD _4225_ sky130_fd_sc_hd__nor2_1
X_8603_ _3485_ reg_pc\[6\] _4225_ VSS VSS VDD VDD _4226_ sky130_fd_sc_hd__a21oi_1
X_8604_ _4226_ net171 VSS VSS VDD VDD _0749_ sky130_fd_sc_hd__nor2b_1
X_8605_ _3485_ _0895_ VSS VSS VDD VDD _4227_ sky130_fd_sc_hd__nor2_1
X_8606_ _3485_ reg_pc\[5\] _4227_ VSS VSS VDD VDD _4228_ sky130_fd_sc_hd__a21oi_1
X_8607_ _4228_ net171 VSS VSS VDD VDD _0750_ sky130_fd_sc_hd__nor2b_1
X_8608_ reg_pc\[4\] _0457_ net750 VSS VSS VDD VDD _4229_ sky130_fd_sc_hd__mux2i_1
X_8609_ _4229_ net171 VSS VSS VDD VDD _0751_ sky130_fd_sc_hd__nor2b_1
X_8610_ reg_pc\[3\] _0266_ net750 VSS VSS VDD VDD _4230_ sky130_fd_sc_hd__mux2i_1
X_8611_ _4230_ net171 VSS VSS VDD VDD _0752_ sky130_fd_sc_hd__nor2b_1
X_8612_ _3485_ _0888_ VSS VSS VDD VDD _4231_ sky130_fd_sc_hd__nor2_1
X_8613_ _3485_ reg_pc\[2\] _4231_ VSS VSS VDD VDD _4232_ sky130_fd_sc_hd__a21oi_1
X_8614_ _4232_ net171 VSS VSS VDD VDD _0753_ sky130_fd_sc_hd__nor2b_1
X_8615_ _0420_ net683 net682 reg_pc\[1\] VSS VSS VDD VDD _0754_
+ sky130_fd_sc_hd__a22o_1
X_8616_ net349 VSS VSS VDD VDD _0216_ sky130_fd_sc_hd__inv_1
X_8617_ net718 VSS VSS VDD VDD _0305_ sky130_fd_sc_hd__inv_1
X_8618_ mem_state\[0\] VSS VSS VDD VDD _0498_ sky130_fd_sc_hd__inv_1
X_8619_ net347 VSS VSS VDD VDD _0207_ sky130_fd_sc_hd__inv_1
X_8620_ mem_rdata_latched\[18\] decoded_imm_j\[18\] net618
+ VSS VSS VDD VDD _0532_ sky130_fd_sc_hd__mux2_2
X_8621_ mem_rdata_latched\[17\] decoded_imm_j\[17\] net618
+ VSS VSS VDD VDD _0531_ sky130_fd_sc_hd__mux2_2
X_8622_ mem_rdata_latched\[16\] decoded_imm_j\[16\] net618
+ VSS VSS VDD VDD _0530_ sky130_fd_sc_hd__mux2_2
X_8623_ mem_rdata_latched\[15\] decoded_imm_j\[15\] net618
+ VSS VSS VDD VDD _0529_ sky130_fd_sc_hd__mux2_2
X_8624_ mem_rdata_latched\[23\] decoded_imm_j\[3\] net618
+ VSS VSS VDD VDD _0537_ sky130_fd_sc_hd__mux2_2
X_8625_ mem_rdata_latched\[22\] decoded_imm_j\[2\] net618
+ VSS VSS VDD VDD _0536_ sky130_fd_sc_hd__mux2_2
X_8626_ mem_rdata_latched\[21\] decoded_imm_j\[1\] net618
+ VSS VSS VDD VDD _0535_ sky130_fd_sc_hd__mux2_2
X_8627_ mem_rdata_latched\[20\] decoded_imm_j\[11\] net618
+ VSS VSS VDD VDD _0534_ sky130_fd_sc_hd__mux2_2
X_8628_ mem_do_rinst mem_do_rdata _0500_ _0503_ VSS VSS VDD
+ VDD _4233_ sky130_fd_sc_hd__or4b_2
X_8629_ mem_do_wdata _0500_ VSS VSS VDD VDD _4234_ sky130_fd_sc_hd__nand2b_1
X_8630_ _4233_ _4234_ _3420_ VSS VSS VDD VDD _0755_ sky130_fd_sc_hd__a21oi_1
X_8631_ net750 decoded_rd\[3\] VSS VSS VDD VDD _0756_ sky130_fd_sc_hd__and2_1
X_8632_ net750 decoded_rd\[2\] VSS VSS VDD VDD _0757_ sky130_fd_sc_hd__and2_1
X_8633_ cpu_state\[1\] decoded_rd\[1\] VSS VSS VDD VDD _0758_
+ sky130_fd_sc_hd__and2_1
X_8634_ net750 decoded_rd\[0\] VSS VSS VDD VDD _0759_ sky130_fd_sc_hd__and2_1
X_8635_ latched_rd\[0\] latched_rd\[1\] VSS VSS VDD VDD _4235_
+ sky130_fd_sc_hd__or2_2
Xoutput260 net259 VSS VSS VDD VDD mem_la_wdata[3] sky130_fd_sc_hd__clkdlybuf4s50_1
X_8637_ latched_rd\[2\] VSS VSS VDD VDD _4237_ sky130_fd_sc_hd__inv_1
X_8638_ net736 net738 net683 VSS VSS VDD VDD _4238_ sky130_fd_sc_hd__o21ai_0
X_8639_ _4237_ _4238_ VSS VSS VDD VDD _4239_ sky130_fd_sc_hd__nor2_1
X_8640_ latched_rd\[3\] latched_rd\[4\] VSS VSS VDD VDD _4240_
+ sky130_fd_sc_hd__nor2b_1
X_8641_ _4239_ _4240_ VSS VSS VDD VDD _4241_ sky130_fd_sc_hd__nand2_1
X_8642_ _4235_ _4241_ VSS VSS VDD VDD _0844_ sky130_fd_sc_hd__nor2_4
X_8643_ latched_rd\[0\] latched_rd\[1\] VSS VSS VDD VDD _4242_
+ sky130_fd_sc_hd__nand2_1
X_8644_ latched_rd\[4\] latched_rd\[3\] _4235_ VSS VSS VDD
+ VDD _4243_ sky130_fd_sc_hd__nor3_1
X_8645_ latched_rd\[2\] _4238_ _4243_ VSS VSS VDD VDD _4244_
+ sky130_fd_sc_hd__nor3_1
X_8646_ _4240_ _4244_ VSS VSS VDD VDD _4245_ sky130_fd_sc_hd__nand2_1
X_8647_ _4242_ _4245_ VSS VSS VDD VDD _0842_ sky130_fd_sc_hd__nor2_4
X_8648_ latched_rd\[4\] latched_rd\[3\] _4244_ VSS VSS VDD
+ VDD _4246_ sky130_fd_sc_hd__nand3_1
X_8649_ _4235_ _4246_ VSS VSS VDD VDD _0848_ sky130_fd_sc_hd__nor2_4
X_8650_ latched_rd\[0\] latched_rd\[1\] VSS VSS VDD VDD _4247_
+ sky130_fd_sc_hd__nand2b_1
Xoutput259 net258 VSS VSS VDD VDD mem_la_wdata[31] sky130_fd_sc_hd__clkdlybuf4s50_1
X_8652_ _4245_ net681 VSS VSS VDD VDD _0841_ sky130_fd_sc_hd__nor2_4
X_8653_ latched_rd\[1\] latched_rd\[0\] VSS VSS VDD VDD _4249_
+ sky130_fd_sc_hd__nand2b_1
Xoutput258 net257 VSS VSS VDD VDD mem_la_wdata[30] sky130_fd_sc_hd__clkdlybuf4s50_1
X_8655_ _4245_ _4249_ VSS VSS VDD VDD _0840_ sky130_fd_sc_hd__nor2_4
X_8656_ _4235_ _4245_ VSS VSS VDD VDD _0839_ sky130_fd_sc_hd__nor2_4
X_8657_ latched_rd\[4\] latched_rd\[3\] _4239_ VSS VSS VDD
+ VDD _4251_ sky130_fd_sc_hd__nand3_1
X_8658_ _4242_ _4251_ VSS VSS VDD VDD _0856_ sky130_fd_sc_hd__nor2_4
X_8659_ _4246_ _4249_ VSS VSS VDD VDD _0849_ sky130_fd_sc_hd__nor2_4
X_8660_ latched_rd\[4\] latched_rd\[3\] VSS VSS VDD VDD _4252_
+ sky130_fd_sc_hd__nor2b_1
X_8661_ _4239_ _4252_ VSS VSS VDD VDD _4253_ sky130_fd_sc_hd__nand2_1
X_8662_ _4242_ _4253_ VSS VSS VDD VDD _0838_ sky130_fd_sc_hd__nor2_4
X_8663_ _4241_ _4242_ VSS VSS VDD VDD _0847_ sky130_fd_sc_hd__nor2_4
X_8664_ net681 _4253_ VSS VSS VDD VDD _0837_ sky130_fd_sc_hd__nor2_4
X_8665_ _4249_ _4253_ VSS VSS VDD VDD _0836_ sky130_fd_sc_hd__nor2_4
X_8666_ _4246_ net681 VSS VSS VDD VDD _0850_ sky130_fd_sc_hd__nor2_4
X_8667_ _4235_ _4253_ VSS VSS VDD VDD _0835_ sky130_fd_sc_hd__nor2_4
X_8668_ _4241_ net681 VSS VSS VDD VDD _0846_ sky130_fd_sc_hd__nor2_4
X_8669_ _4244_ _4252_ VSS VSS VDD VDD _4254_ sky130_fd_sc_hd__nand2_1
X_8670_ _4242_ _4254_ VSS VSS VDD VDD _0834_ sky130_fd_sc_hd__nor2_4
X_8671_ net681 _4254_ VSS VSS VDD VDD _0833_ sky130_fd_sc_hd__nor2_4
X_8672_ _4242_ _4246_ VSS VSS VDD VDD _0851_ sky130_fd_sc_hd__nor2_4
X_8673_ _4249_ _4254_ VSS VSS VDD VDD _0863_ sky130_fd_sc_hd__nor2_4
X_8674_ _4235_ _4254_ VSS VSS VDD VDD _0862_ sky130_fd_sc_hd__nor2_4
X_8675_ latched_rd\[4\] latched_rd\[3\] VSS VSS VDD VDD _4255_
+ sky130_fd_sc_hd__nor2_1
X_8676_ _4239_ _4255_ VSS VSS VDD VDD _4256_ sky130_fd_sc_hd__nand2_1
X_8677_ _4242_ _4256_ VSS VSS VDD VDD _0861_ sky130_fd_sc_hd__nor2_4
X_8678_ net681 _4256_ VSS VSS VDD VDD _0860_ sky130_fd_sc_hd__nor2_4
X_8679_ _4235_ _4251_ VSS VSS VDD VDD _0852_ sky130_fd_sc_hd__nor2_4
X_8680_ _4249_ _4256_ VSS VSS VDD VDD _0859_ sky130_fd_sc_hd__nor2_4
X_8681_ _4235_ _4256_ VSS VSS VDD VDD _0858_ sky130_fd_sc_hd__nor2_4
X_8682_ _4255_ _4244_ VSS VSS VDD VDD _4257_ sky130_fd_sc_hd__nand2_1
X_8683_ _4242_ _4257_ VSS VSS VDD VDD _0857_ sky130_fd_sc_hd__nor2_4
X_8684_ _4249_ _4251_ VSS VSS VDD VDD _0853_ sky130_fd_sc_hd__nor2_4
X_8685_ net681 _4257_ VSS VSS VDD VDD _0854_ sky130_fd_sc_hd__nor2_4
X_8686_ net681 _4251_ VSS VSS VDD VDD _0855_ sky130_fd_sc_hd__nor2_4
X_8687_ _4241_ _4249_ VSS VSS VDD VDD _0845_ sky130_fd_sc_hd__nor2_4
X_8688_ _4249_ _4257_ VSS VSS VDD VDD _0843_ sky130_fd_sc_hd__nor2_4
X_8689_ net746 net657 VSS VSS VDD VDD _0518_ sky130_fd_sc_hd__nand2_1
X_8690_ mem_rdata_q\[14\] mem_rdata_q\[12\] VSS VSS VDD VDD
+ _4258_ sky130_fd_sc_hd__nor2_1
X_8691_ mem_rdata_q\[13\] _4258_ VSS VSS VDD VDD _4259_ sky130_fd_sc_hd__nand2_1
X_8692_ mem_rdata_q\[29\] mem_rdata_q\[28\] mem_rdata_q\[26\]
+ mem_rdata_q\[25\] VSS VSS VDD VDD _4260_ sky130_fd_sc_hd__or4_1
X_8693_ mem_rdata_q\[31\] net735 _4260_ VSS VSS VDD VDD _4261_
+ sky130_fd_sc_hd__or3_1
X_8694_ mem_rdata_q\[30\] _4261_ VSS VSS VDD VDD _4262_ sky130_fd_sc_hd__nor2_1
X_8695_ net776 is_alu_reg_reg net680 VSS VSS VDD VDD _4263_
+ sky130_fd_sc_hd__and3_1
X_8696_ _4262_ _4263_ VSS VSS VDD VDD _4264_ sky130_fd_sc_hd__nand2_1
X_8697_ net680 net776 VSS VSS VDD VDD _4265_ sky130_fd_sc_hd__nor2b_1
Xoutput257 net256 VSS VSS VDD VDD mem_la_wdata[2] sky130_fd_sc_hd__clkdlybuf4s50_1
X_8699_ instr_slt net663 VSS VSS VDD VDD _4267_ sky130_fd_sc_hd__nand2_1
X_8700_ _4259_ _4264_ _4267_ VSS VSS VDD VDD _0760_ sky130_fd_sc_hd__o21ai_0
X_8701_ net699 decoder_pseudo_trigger instr_sll VSS VSS VDD
+ VDD _4268_ sky130_fd_sc_hd__o21ai_0
X_8702_ mem_rdata_q\[13\] mem_rdata_q\[12\] VSS VSS VDD VDD
+ _4269_ sky130_fd_sc_hd__nand2b_1
X_8703_ _4269_ _3277_ VSS VSS VDD VDD _4270_ sky130_fd_sc_hd__nand2b_1
X_8704_ mem_rdata_q\[30\] _4261_ _4270_ VSS VSS VDD VDD _4271_
+ sky130_fd_sc_hd__nor3_1
X_8705_ is_alu_reg_reg net680 _4271_ VSS VSS VDD VDD _4272_
+ sky130_fd_sc_hd__nand3_1
X_8706_ _4268_ _4272_ net776 VSS VSS VDD VDD _0761_ sky130_fd_sc_hd__a21boi_0
X_8707_ mem_rdata_q\[14\] mem_rdata_q\[13\] mem_rdata_q\[12\]
+ VSS VSS VDD VDD _4273_ sky130_fd_sc_hd__or3_1
Xoutput256 net255 VSS VSS VDD VDD mem_la_wdata[29] sky130_fd_sc_hd__clkdlybuf4s50_1
X_8709_ mem_rdata_q\[31\] net735 _4260_ VSS VSS VDD VDD _4275_
+ sky130_fd_sc_hd__nor3_1
X_8710_ mem_rdata_q\[30\] _4275_ _4263_ VSS VSS VDD VDD _4276_
+ sky130_fd_sc_hd__nand3_1
Xoutput255 net254 VSS VSS VDD VDD mem_la_wdata[28] sky130_fd_sc_hd__clkdlybuf4s50_1
X_8712_ net739 _4265_ VSS VSS VDD VDD _4278_ sky130_fd_sc_hd__nand2_1
X_8713_ _4273_ _4276_ _4278_ VSS VSS VDD VDD _0762_ sky130_fd_sc_hd__o21ai_0
X_8714_ instr_add net663 VSS VSS VDD VDD _4279_ sky130_fd_sc_hd__nand2_1
X_8715_ _4264_ _4273_ _4279_ VSS VSS VDD VDD _0763_ sky130_fd_sc_hd__o21ai_0
Xoutput254 net253 VSS VSS VDD VDD mem_la_wdata[27] sky130_fd_sc_hd__clkdlybuf4s50_1
X_8717_ mem_do_prefetch mem_do_rinst VSS VSS VDD VDD _4281_
+ sky130_fd_sc_hd__nor2_1
X_8718_ mem_do_wdata _4281_ VSS VSS VDD VDD _0764_ sky130_fd_sc_hd__nor2_1
X_8719_ net776 is_alu_reg_imm net680 VSS VSS VDD VDD _4282_
+ sky130_fd_sc_hd__nand3_1
X_8720_ mem_rdata_q\[14\] mem_rdata_q\[13\] mem_rdata_q\[12\]
+ VSS VSS VDD VDD _4283_ sky130_fd_sc_hd__nand3_1
X_8721_ instr_andi net663 VSS VSS VDD VDD _4284_ sky130_fd_sc_hd__nand2_1
X_8722_ _4282_ _4283_ _4284_ VSS VSS VDD VDD _0765_ sky130_fd_sc_hd__o21ai_0
X_8723_ mem_rdata_q\[12\] mem_rdata_q\[13\] mem_rdata_q\[14\]
+ VSS VSS VDD VDD _4285_ sky130_fd_sc_hd__nand3b_1
X_8724_ instr_ori net663 VSS VSS VDD VDD _4286_ sky130_fd_sc_hd__nand2_1
X_8725_ _4282_ _4285_ _4286_ VSS VSS VDD VDD _0766_ sky130_fd_sc_hd__o21ai_0
X_8726_ _3277_ mem_rdata_q\[13\] mem_rdata_q\[12\] VSS VSS
+ VDD VDD _4287_ sky130_fd_sc_hd__nor3_1
X_8727_ _4287_ VSS VSS VDD VDD _4288_ sky130_fd_sc_hd__inv_1
X_8728_ instr_xori net663 VSS VSS VDD VDD _4289_ sky130_fd_sc_hd__nand2_1
X_8729_ _4282_ _4288_ _4289_ VSS VSS VDD VDD _0767_ sky130_fd_sc_hd__o21ai_0
X_8730_ _3277_ mem_rdata_q\[13\] mem_rdata_q\[12\] VSS VSS
+ VDD VDD _4290_ sky130_fd_sc_hd__nand3_1
X_8731_ instr_sltiu net663 VSS VSS VDD VDD _4291_ sky130_fd_sc_hd__nand2_1
X_8732_ _4282_ _4290_ _4291_ VSS VSS VDD VDD _0768_ sky130_fd_sc_hd__o21ai_0
X_8733_ instr_slti net663 VSS VSS VDD VDD _4292_ sky130_fd_sc_hd__nand2_1
X_8734_ _4259_ _4282_ _4292_ VSS VSS VDD VDD _0769_ sky130_fd_sc_hd__o21ai_0
X_8735_ instr_addi net663 VSS VSS VDD VDD _4293_ sky130_fd_sc_hd__nand2_1
X_8736_ _4273_ _4282_ _4293_ VSS VSS VDD VDD _0770_ sky130_fd_sc_hd__o21ai_0
X_8737_ is_beq_bne_blt_bge_bltu_bgeu net776 net680 VSS VSS
+ VDD VDD _4294_ sky130_fd_sc_hd__nand3_1
X_8738_ instr_bgeu net663 VSS VSS VDD VDD _4295_ sky130_fd_sc_hd__nand2_1
X_8739_ _4283_ _4294_ _4295_ VSS VSS VDD VDD _0771_ sky130_fd_sc_hd__o21ai_0
X_8740_ instr_bltu net663 VSS VSS VDD VDD _4296_ sky130_fd_sc_hd__nand2_1
X_8741_ _4285_ _4294_ _4296_ VSS VSS VDD VDD _0772_ sky130_fd_sc_hd__o21ai_0
X_8742_ _3277_ _4269_ VSS VSS VDD VDD _4297_ sky130_fd_sc_hd__or2_2
X_8743_ instr_bge _4265_ VSS VSS VDD VDD _4298_ sky130_fd_sc_hd__nand2_1
X_8744_ _4294_ _4297_ _4298_ VSS VSS VDD VDD _0773_ sky130_fd_sc_hd__o21ai_0
X_8745_ instr_blt net663 VSS VSS VDD VDD _4299_ sky130_fd_sc_hd__nand2_1
X_8746_ _4288_ _4294_ _4299_ VSS VSS VDD VDD _0774_ sky130_fd_sc_hd__o21ai_0
X_8747_ instr_bne _4265_ VSS VSS VDD VDD _4300_ sky130_fd_sc_hd__nand2_1
X_8748_ _4270_ _4294_ _4300_ VSS VSS VDD VDD _0775_ sky130_fd_sc_hd__o21ai_0
X_8749_ reg_out\[31\] alu_out_q\[31\] latched_stalu VSS VSS
+ VDD VDD _4301_ sky130_fd_sc_hd__mux2i_1
X_8750_ reg_next_pc\[31\] net697 VSS VSS VDD VDD _4302_ sky130_fd_sc_hd__nand2_1
X_8751_ net697 _4301_ _4302_ VSS VSS VDD VDD _4303_ sky130_fd_sc_hd__o21a_1
X_8752_ reg_pc\[31\] net682 VSS VSS VDD VDD _4304_ sky130_fd_sc_hd__nand2_1
X_8753_ _3881_ _4303_ _4304_ VSS VSS VDD VDD _0776_ sky130_fd_sc_hd__o21ai_0
X_8754_ net750 decoded_rd\[4\] VSS VSS VDD VDD _0777_ sky130_fd_sc_hd__and2_1
X_8755_ net776 _0870_ VSS VSS VDD VDD _4305_ sky130_fd_sc_hd__nand2_1
X_8756_ mem_do_prefetch _4305_ VSS VSS VDD VDD _4306_ sky130_fd_sc_hd__and2_1
X_8757_ mem_do_rdata _4306_ VSS VSS VDD VDD _4307_ sky130_fd_sc_hd__nor2_1
X_8758_ cpu_state\[1\] _4307_ cpu_state\[6\] VSS VSS VDD VDD
+ _4308_ sky130_fd_sc_hd__mux2i_1
X_8759_ instr_lb cpu_state\[6\] _4307_ _4308_ latched_is_lb
+ VSS VSS VDD VDD _4309_ sky130_fd_sc_hd__a32oi_1
X_8760_ _4309_ net776 VSS VSS VDD VDD _0778_ sky130_fd_sc_hd__nor2b_1
X_8761_ instr_lh cpu_state\[6\] _4307_ _4308_ latched_is_lh
+ VSS VSS VDD VDD _4310_ sky130_fd_sc_hd__a32oi_1
X_8762_ _4310_ net776 VSS VSS VDD VDD _0779_ sky130_fd_sc_hd__nor2b_1
X_8763_ count_instr\[61\] count_instr\[62\] _3452_ VSS VSS
+ VDD VDD _4311_ sky130_fd_sc_hd__nand3_1
X_8764_ _3491_ _4311_ count_instr\[63\] VSS VSS VDD VDD _4312_
+ sky130_fd_sc_hd__o21ai_0
X_8765_ count_instr\[63\] _3491_ _4311_ VSS VSS VDD VDD _4313_
+ sky130_fd_sc_hd__or3_1
X_8766_ _4312_ _4313_ net775 VSS VSS VDD VDD _0780_ sky130_fd_sc_hd__a21boi_1
X_8767_ net750 _3716_ VSS VSS VDD VDD _4314_ sky130_fd_sc_hd__nand2_1
X_8768_ net750 net748 net738 net171 _4314_ VSS VSS VDD VDD
+ _4315_ sky130_fd_sc_hd__o311a_1
X_8769_ net750 is_beq_bne_blt_bge_bltu_bgeu _2873_ instr_jalr
+ _4315_ VSS VSS VDD VDD _4316_ sky130_fd_sc_hd__o41ai_1
X_8770_ _3485_ is_beq_bne_blt_bge_bltu_bgeu net748 _1500_
+ _4316_ VSS VSS VDD VDD _0781_ sky130_fd_sc_hd__a41oi_1
X_8771_ net750 _2873_ VSS VSS VDD VDD _4317_ sky130_fd_sc_hd__nand2_1
X_8772_ is_beq_bne_blt_bge_bltu_bgeu _2873_ VSS VSS VDD VDD
+ _4318_ sky130_fd_sc_hd__nor2_1
X_8773_ latched_stalu _4317_ _4318_ VSS VSS VDD VDD _4319_
+ sky130_fd_sc_hd__a21oi_1
X_8774_ _4319_ net171 VSS VSS VDD VDD _0782_ sky130_fd_sc_hd__nor2b_1
X_8775_ net742 net741 net740 VSS VSS VDD VDD _4320_ sky130_fd_sc_hd__or3_1
X_8776_ instr_rdcycle _4320_ VSS VSS VDD VDD _4321_ sky130_fd_sc_hd__nor2_1
X_8777_ cpu_state\[1\] cpu_state\[6\] _2876_ VSS VSS VDD VDD
+ _4322_ sky130_fd_sc_hd__nor3_1
X_8778_ net749 _4321_ _4322_ VSS VSS VDD VDD _4323_ sky130_fd_sc_hd__a21oi_1
X_8779_ net736 _4323_ VSS VSS VDD VDD _4324_ sky130_fd_sc_hd__nor2_1
X_8780_ net750 _2873_ _4323_ _4324_ VSS VSS VDD VDD _4325_
+ sky130_fd_sc_hd__a31oi_1
X_8781_ net171 _4325_ VSS VSS VDD VDD _4326_ sky130_fd_sc_hd__nand2_1
X_8782_ is_beq_bne_blt_bge_bltu_bgeu net748 _1500_ _4323_
+ _4326_ VSS VSS VDD VDD _0783_ sky130_fd_sc_hd__a41oi_1
X_8783_ mem_do_prefetch _4305_ net691 VSS VSS VDD VDD _0784_
+ sky130_fd_sc_hd__nor3_1
Xoutput253 net252 VSS VSS VDD VDD mem_la_wdata[26] sky130_fd_sc_hd__clkdlybuf4s50_1
X_8785_ cpu_state\[5\] net776 VSS VSS VDD VDD _4328_ sky130_fd_sc_hd__nand2_1
X_8786_ mem_do_prefetch net661 _4328_ mem_do_wdata VSS VSS
+ VDD VDD _4329_ sky130_fd_sc_hd__a211oi_1
X_8787_ mem_do_wdata net776 net661 _4329_ VSS VSS VDD VDD
+ _0785_ sky130_fd_sc_hd__a31o_2
X_8788_ cpu_state\[5\] cpu_state\[0\] VSS VSS VDD VDD _4330_
+ sky130_fd_sc_hd__nor2_1
X_8789_ _2936_ net682 _4330_ VSS VSS VDD VDD _4331_ sky130_fd_sc_hd__nand3_1
X_8790_ mem_do_rdata net776 net661 VSS VSS VDD VDD _4332_
+ sky130_fd_sc_hd__nand3_1
X_8791_ mem_do_rdata _4306_ _4331_ _4332_ VSS VSS VDD VDD
+ _0786_ sky130_fd_sc_hd__o31ai_1
X_8792_ net776 net661 VSS VSS VDD VDD _4333_ sky130_fd_sc_hd__nand2_1
X_8793_ is_lb_lh_lw_lbu_lhu VSS VSS VDD VDD _4334_ sky130_fd_sc_hd__inv_1
X_8794_ _1018_ _4321_ VSS VSS VDD VDD _4335_ sky130_fd_sc_hd__nand2_1
X_8795_ instr_lh instr_lhu VSS VSS VDD VDD _4336_ sky130_fd_sc_hd__nor2_1
X_8796_ instr_lb instr_lbu instr_lw VSS VSS VDD VDD _4337_
+ sky130_fd_sc_hd__nor3_1
X_8797_ _4336_ _4337_ VSS VSS VDD VDD _4338_ sky130_fd_sc_hd__nand2_1
X_8798_ instr_sll instr_slli VSS VSS VDD VDD _4339_ sky130_fd_sc_hd__nor2_1
X_8799_ instr_fence instr_blt instr_sub instr_jalr VSS VSS
+ VDD VDD _4340_ sky130_fd_sc_hd__nor4_1
X_8800_ instr_beq instr_bltu instr_addi instr_add VSS VSS
+ VDD VDD _4341_ sky130_fd_sc_hd__nor4_1
X_8801_ _1671_ _4339_ _4340_ _4341_ VSS VSS VDD VDD _4342_
+ sky130_fd_sc_hd__nand4_1
X_8802_ instr_sb instr_sw instr_sh VSS VSS VDD VDD _4343_
+ sky130_fd_sc_hd__nor3_1
X_8803_ net743 _3421_ VSS VSS VDD VDD _4344_ sky130_fd_sc_hd__nor2_1
X_8804_ instr_sltu instr_slti instr_sltiu instr_slt VSS VSS
+ VDD VDD _4345_ sky130_fd_sc_hd__nor4_1
X_8805_ _1487_ _4343_ _4344_ _4345_ VSS VSS VDD VDD _4346_
+ sky130_fd_sc_hd__nand4_1
X_8806_ _4335_ _4338_ _4342_ _4346_ VSS VSS VDD VDD _4347_
+ sky130_fd_sc_hd__nor4_1
X_8807_ _4334_ net620 VSS VSS VDD VDD _4348_ sky130_fd_sc_hd__nor2_1
X_8808_ is_sb_sh_sw _2417_ _4348_ VSS VSS VDD VDD _4349_ sky130_fd_sc_hd__a21oi_1
X_8809_ _3485_ net749 mem_do_prefetch VSS VSS VDD VDD _4350_
+ sky130_fd_sc_hd__o21ai_0
X_8810_ _3485_ net676 _4349_ _2875_ _4350_ VSS VSS VDD VDD
+ _4351_ sky130_fd_sc_hd__o221ai_1
X_8811_ is_lb_lh_lw_lbu_lhu _2423_ VSS VSS VDD VDD _4352_
+ sky130_fd_sc_hd__nor2_1
X_8812_ is_sll_srl_sra _4352_ VSS VSS VDD VDD _4353_ sky130_fd_sc_hd__nand2_1
X_8813_ is_slli_srli_srai instr_rdcycle _4320_ net620 VSS
+ VSS VDD VDD _4354_ sky130_fd_sc_hd__nor4_1
X_8814_ _4353_ _4354_ VSS VSS VDD VDD _4355_ sky130_fd_sc_hd__nand2_1
X_8815_ _0165_ _0157_ VSS VSS VDD VDD _4356_ sky130_fd_sc_hd__nand2_1
X_8816_ reg_sh\[4\] _4356_ net747 VSS VSS VDD VDD _4357_ sky130_fd_sc_hd__o21ai_0
X_8817_ cpu_state\[1\] net747 net749 _4357_ VSS VSS VDD VDD
+ _4358_ sky130_fd_sc_hd__o31ai_1
X_8818_ net749 _4355_ _4358_ VSS VSS VDD VDD _4359_ sky130_fd_sc_hd__a21oi_1
X_8819_ mem_do_rinst _4351_ _4359_ VSS VSS VDD VDD _4360_
+ sky130_fd_sc_hd__mux2i_1
X_8820_ is_beq_bne_blt_bge_bltu_bgeu net748 net776 VSS VSS
+ VDD VDD _4361_ sky130_fd_sc_hd__nand3_1
X_8821_ _4333_ _4360_ _4361_ _1500_ VSS VSS VDD VDD _0787_
+ sky130_fd_sc_hd__o22ai_1
X_8822_ cpu_state\[1\] net676 mem_do_prefetch VSS VSS VDD
+ VDD _4362_ sky130_fd_sc_hd__a21oi_1
X_8823_ cpu_state\[1\] instr_jalr net676 _4333_ _4362_ VSS
+ VSS VDD VDD _0788_ sky130_fd_sc_hd__a311oi_1
X_8824_ mem_rdata_latched\[19\] decoded_imm_j\[19\] net618
+ VSS VSS VDD VDD _0533_ sky130_fd_sc_hd__mux2_2
X_8825_ mem_rdata_latched\[24\] decoded_imm_j\[4\] net618
+ VSS VSS VDD VDD _0538_ sky130_fd_sc_hd__mux2_2
X_8826_ mem_do_rdata net776 cpu_state\[6\] VSS VSS VDD VDD
+ _4363_ sky130_fd_sc_hd__nand3b_1
X_8827_ mem_do_prefetch net661 _4363_ VSS VSS VDD VDD _4364_
+ sky130_fd_sc_hd__a21oi_1
X_8828_ instr_sw _4329_ _4364_ instr_lw net683 VSS VSS VDD
+ VDD _4365_ sky130_fd_sc_hd__a221oi_1
X_8829_ mem_do_prefetch net661 _4338_ _4363_ VSS VSS VDD VDD
+ _4366_ sky130_fd_sc_hd__a211oi_1
X_8830_ mem_do_prefetch net661 net690 _4366_ VSS VSS VDD VDD
+ _4367_ sky130_fd_sc_hd__a31oi_1
X_8831_ mem_do_rdata cpu_state\[6\] VSS VSS VDD VDD _4368_
+ sky130_fd_sc_hd__nand2_1
X_8832_ mem_do_wdata cpu_state\[5\] VSS VSS VDD VDD _4369_
+ sky130_fd_sc_hd__nand2_1
X_8833_ cpu_state\[1\] net690 _4368_ _4369_ net776 VSS VSS
+ VDD VDD _4370_ sky130_fd_sc_hd__o2111ai_1
X_8834_ _4329_ _4343_ _4370_ VSS VSS VDD VDD _4371_ sky130_fd_sc_hd__a21oi_1
X_8835_ _4367_ _4371_ VSS VSS VDD VDD _4372_ sky130_fd_sc_hd__nand2_1
X_8836_ mem_wordsize\[0\] _4372_ VSS VSS VDD VDD _4373_ sky130_fd_sc_hd__nand2_1
X_8837_ _4365_ _4373_ VSS VSS VDD VDD _0508_ sky130_fd_sc_hd__nand2_1
X_8838_ net734 _4372_ VSS VSS VDD VDD _4374_ sky130_fd_sc_hd__nand2_1
X_8839_ instr_lb instr_lbu _4364_ VSS VSS VDD VDD _4375_ sky130_fd_sc_hd__o21ai_0
X_8840_ instr_sb _4329_ VSS VSS VDD VDD _4376_ sky130_fd_sc_hd__nand2_1
X_8841_ _4374_ _4375_ _4376_ VSS VSS VDD VDD _0509_ sky130_fd_sc_hd__nand3_1
X_8842_ mem_wordsize\[2\] _4372_ VSS VSS VDD VDD _4377_ sky130_fd_sc_hd__nand2_1
X_8843_ instr_lh instr_lhu _4364_ VSS VSS VDD VDD _4378_ sky130_fd_sc_hd__o21ai_0
X_8844_ instr_sh _4329_ VSS VSS VDD VDD _4379_ sky130_fd_sc_hd__nand2_1
X_8845_ _4377_ _4378_ _4379_ VSS VSS VDD VDD _0510_ sky130_fd_sc_hd__nand3_1
X_8846_ net749 net776 VSS VSS VDD VDD _0523_ sky130_fd_sc_hd__and2_2
X_8847_ net308 net721 mem_wordsize\[0\] VSS VSS VDD VDD _4380_
+ sky130_fd_sc_hd__o21ai_0
X_8848_ net308 mem_wordsize\[2\] VSS VSS VDD VDD _4381_ sky130_fd_sc_hd__nand2_1
X_8849_ _4380_ _4381_ _0867_ VSS VSS VDD VDD _4382_ sky130_fd_sc_hd__a21oi_1
X_8850_ mem_do_rinst reg_pc\[1\] _4382_ VSS VSS VDD VDD _4383_
+ sky130_fd_sc_hd__a21o_1
X_8851_ cpu_state\[0\] net776 VSS VSS VDD VDD _0790_ sky130_fd_sc_hd__and2_1
X_8852_ net620 _0523_ _4383_ net776 _0790_ VSS VSS VDD VDD
+ _0511_ sky130_fd_sc_hd__a221o_1
X_8853_ is_beq_bne_blt_bge_bltu_bgeu net748 VSS VSS VDD VDD
+ _4384_ sky130_fd_sc_hd__nand2_1
X_8854_ instr_rdcycle _4320_ net749 VSS VSS VDD VDD _4385_
+ sky130_fd_sc_hd__o21ai_0
X_8855_ reg_sh\[4\] net689 _4356_ VSS VSS VDD VDD _4386_ sky130_fd_sc_hd__or3_1
X_8856_ net683 _3787_ _4318_ VSS VSS VDD VDD _4387_ sky130_fd_sc_hd__a21oi_1
X_8857_ net661 _4384_ _4385_ _4386_ _4387_ VSS VSS VDD VDD
+ _4388_ sky130_fd_sc_hd__o2111ai_1
X_8858_ net171 _4383_ VSS VSS VDD VDD _4389_ sky130_fd_sc_hd__nand2_1
X_8859_ _0784_ _4388_ _4389_ VSS VSS VDD VDD _4390_ sky130_fd_sc_hd__o21ai_0
X_8860_ net171 _4390_ VSS VSS VDD VDD _0512_ sky130_fd_sc_hd__nand2_1
X_8861_ net683 net676 _4389_ VSS VSS VDD VDD _0513_ sky130_fd_sc_hd__and3_1
X_8862_ net171 _4389_ VSS VSS VDD VDD _4391_ sky130_fd_sc_hd__nand2_1
X_8863_ _4391_ VSS VSS VDD VDD _4392_ sky130_fd_sc_hd__inv_1
X_8864_ net749 _4352_ _4354_ _4392_ VSS VSS VDD VDD _4393_
+ sky130_fd_sc_hd__nand4_1
X_8865_ is_beq_bne_blt_bge_bltu_bgeu net748 net661 _2423_
+ net749 VSS VSS VDD VDD _4394_ sky130_fd_sc_hd__a32oi_1
X_8866_ is_sb_sh_sw is_sll_srl_sra _4393_ _4394_ _4391_ VSS
+ VSS VDD VDD _0514_ sky130_fd_sc_hd__o32ai_1
X_8867_ instr_rdcycle _4320_ _4353_ net620 VSS VSS VDD VDD
+ _4395_ sky130_fd_sc_hd__nor4_1
X_8868_ is_slli_srli_srai _4395_ net749 VSS VSS VDD VDD _4396_
+ sky130_fd_sc_hd__o21ai_0
X_8869_ _4357_ _4396_ _4391_ VSS VSS VDD VDD _0515_ sky130_fd_sc_hd__a21oi_1
X_8870_ mem_do_prefetch net661 cpu_state\[5\] VSS VSS VDD
+ VDD _4397_ sky130_fd_sc_hd__o21ai_0
X_8871_ _3440_ _4393_ _4397_ _4391_ VSS VSS VDD VDD _0516_
+ sky130_fd_sc_hd__o22ai_1
X_8872_ mem_do_prefetch net661 cpu_state\[6\] VSS VSS VDD
+ VDD _4398_ sky130_fd_sc_hd__o21ai_0
X_8873_ net749 _4348_ VSS VSS VDD VDD _4399_ sky130_fd_sc_hd__nand2_1
X_8874_ _4398_ _4399_ _4391_ VSS VSS VDD VDD _0517_ sky130_fd_sc_hd__a21oi_1
X_8875_ _0503_ _0502_ net698 VSS VSS VDD VDD _4400_ sky130_fd_sc_hd__o21ai_0
X_8876_ _0504_ _0500_ _0503_ _0502_ VSS VSS VDD VDD _4401_
+ sky130_fd_sc_hd__or4_1
X_8877_ mem_do_rinst VSS VSS VDD VDD _4402_ sky130_fd_sc_hd__inv_1
X_8878_ _4402_ _0504_ net364 VSS VSS VDD VDD _4403_ sky130_fd_sc_hd__a21oi_1
X_8879_ _4400_ _4401_ _4403_ VSS VSS VDD VDD _4404_ sky130_fd_sc_hd__nand3_1
X_8880_ _0500_ _0528_ VSS VSS VDD VDD _0795_ sky130_fd_sc_hd__and2_1
X_8881_ _0867_ _4281_ _0795_ VSS VSS VDD VDD _4405_ sky130_fd_sc_hd__and3_1
X_8882_ net776 _4404_ _4405_ VSS VSS VDD VDD _0519_ sky130_fd_sc_hd__a21oi_1
X_8883_ mem_do_wdata _0500_ VSS VSS VDD VDD _4406_ sky130_fd_sc_hd__nand2_1
X_8884_ _4406_ _3420_ VSS VSS VDD VDD _0520_ sky130_fd_sc_hd__nor2_4
X_8885_ net776 _1004_ VSS VSS VDD VDD net233 sky130_fd_sc_hd__and2_1
X_8886_ net266 net233 _0528_ VSS VSS VDD VDD _0521_ sky130_fd_sc_hd__o21a_1
X_8887_ _0501_ net364 VSS VSS VDD VDD _4407_ sky130_fd_sc_hd__nor2_1
X_8888_ _3278_ _4407_ _0504_ VSS VSS VDD VDD _4408_ sky130_fd_sc_hd__o21bai_1
X_8889_ net170 net364 VSS VSS VDD VDD _4409_ sky130_fd_sc_hd__nand2_1
X_8890_ net776 _4408_ _4409_ _4405_ VSS VSS VDD VDD _0522_
+ sky130_fd_sc_hd__a31oi_1
X_8891_ net266 net233 _0528_ VSS VSS VDD VDD _0524_ sky130_fd_sc_hd__o21a_1
X_8892_ _4317_ _4384_ net171 VSS VSS VDD VDD _0525_ sky130_fd_sc_hd__a21boi_0
X_8893_ _1679_ _4339_ _1670_ VSS VSS VDD VDD _4410_ sky130_fd_sc_hd__a21o_1
X_8894_ _1656_ _4368_ VSS VSS VDD VDD _4411_ sky130_fd_sc_hd__nand2_1
X_8895_ net747 net749 net691 VSS VSS VDD VDD _4412_ sky130_fd_sc_hd__o21ai_0
X_8896_ _4306_ _4411_ _4412_ VSS VSS VDD VDD _4413_ sky130_fd_sc_hd__o21ai_0
X_8897_ net776 _4369_ _4386_ _4413_ VSS VSS VDD VDD _4414_
+ sky130_fd_sc_hd__nand4_1
X_8898_ net747 _4410_ _4414_ VSS VSS VDD VDD _0526_ sky130_fd_sc_hd__a21oi_1
X_8899_ net747 net671 _4339_ _4414_ VSS VSS VDD VDD _0527_
+ sky130_fd_sc_hd__a31oi_4
X_8900_ instr_beq net663 VSS VSS VDD VDD _4415_ sky130_fd_sc_hd__nand2_1
X_8901_ _4273_ _4294_ _4415_ VSS VSS VDD VDD _0789_ sky130_fd_sc_hd__o21ai_0
X_8902_ count_cycle\[62\] VSS VSS VDD VDD _4416_ sky130_fd_sc_hd__inv_1
X_8903_ _4416_ _4022_ _4054_ VSS VSS VDD VDD _4417_ sky130_fd_sc_hd__nor3_1
X_8904_ count_cycle\[63\] _4417_ VSS VSS VDD VDD _4418_ sky130_fd_sc_hd__xor2_1
X_8905_ net775 _4418_ VSS VSS VDD VDD _0791_ sky130_fd_sc_hd__and2_1
X_8906_ mem_rdata_q\[3\] mem_rdata_q\[2\] VSS VSS VDD VDD
+ _4419_ sky130_fd_sc_hd__nand2_1
X_8907_ mem_rdata_q\[6\] mem_rdata_q\[5\] VSS VSS VDD VDD
+ _4420_ sky130_fd_sc_hd__nor2_1
X_8908_ mem_rdata_q\[1\] mem_rdata_q\[0\] _4420_ VSS VSS VDD
+ VDD _4421_ sky130_fd_sc_hd__nand3_1
X_8909_ mem_rdata_q\[4\] _4273_ _4419_ _4421_ VSS VSS VDD
+ VDD _4422_ sky130_fd_sc_hd__nor4_1
X_8910_ instr_fence _4422_ _0812_ VSS VSS VDD VDD _4423_ sky130_fd_sc_hd__mux2i_1
X_8911_ _4423_ net776 VSS VSS VDD VDD _0792_ sky130_fd_sc_hd__nor2b_1
X_8912_ net698 net163 net160 VSS VSS VDD VDD _4424_ sky130_fd_sc_hd__nor3b_1
X_8913_ mem_rdata_q\[3\] _3278_ mem_rdata_q\[2\] VSS VSS VDD
+ VDD _4425_ sky130_fd_sc_hd__nor3b_1
X_8914_ mem_rdata_q\[1\] mem_rdata_q\[0\] VSS VSS VDD VDD
+ _4426_ sky130_fd_sc_hd__nand2_1
X_8915_ net149 net138 _3278_ VSS VSS VDD VDD _4427_ sky130_fd_sc_hd__nand3_1
X_8916_ _3278_ _4426_ _4427_ VSS VSS VDD VDD _4428_ sky130_fd_sc_hd__o21ai_0
X_8917_ _4424_ _4425_ _4428_ VSS VSS VDD VDD _4429_ sky130_fd_sc_hd__o21ai_0
X_8918_ net166 net165 net677 VSS VSS VDD VDD _4430_ sky130_fd_sc_hd__nand3b_1
X_8919_ mem_rdata_q\[6\] mem_rdata_q\[5\] net698 VSS VSS VDD
+ VDD _4431_ sky130_fd_sc_hd__nand3b_1
X_8920_ net164 mem_rdata_q\[4\] net698 VSS VSS VDD VDD _4432_
+ sky130_fd_sc_hd__mux2i_1
X_8921_ _4430_ _4431_ _4432_ VSS VSS VDD VDD _4433_ sky130_fd_sc_hd__a21o_1
X_8922_ _4429_ _4433_ VSS VSS VDD VDD _0805_ sky130_fd_sc_hd__nor2_1
X_8923_ net166 net165 net698 VSS VSS VDD VDD _4434_ sky130_fd_sc_hd__nor3_1
X_8924_ net698 _4420_ _4434_ VSS VSS VDD VDD _4435_ sky130_fd_sc_hd__a21oi_1
X_8925_ _4429_ _4432_ _4435_ VSS VSS VDD VDD _0806_ sky130_fd_sc_hd__nor3_1
X_8926_ mem_rdata_q\[6\] mem_rdata_q\[5\] net698 VSS VSS VDD
+ VDD _4436_ sky130_fd_sc_hd__nand3_1
X_8927_ net166 net165 _3278_ VSS VSS VDD VDD _4437_ sky130_fd_sc_hd__nand3_1
X_8928_ _4436_ _4437_ VSS VSS VDD VDD _4438_ sky130_fd_sc_hd__nand2_1
X_8929_ _4432_ _4438_ VSS VSS VDD VDD _4439_ sky130_fd_sc_hd__nand2_1
X_8930_ net163 net160 _3278_ VSS VSS VDD VDD _4440_ sky130_fd_sc_hd__nand3_1
X_8931_ _3278_ _4419_ _4440_ VSS VSS VDD VDD _4441_ sky130_fd_sc_hd__o21ai_0
X_8932_ _4428_ _4441_ VSS VSS VDD VDD _4442_ sky130_fd_sc_hd__nand2_1
X_8933_ _4439_ _4442_ VSS VSS VDD VDD _0807_ sky130_fd_sc_hd__nor2_1
X_8934_ mem_rdata_q\[3\] mem_rdata_q\[2\] _3278_ VSS VSS VDD
+ VDD _4443_ sky130_fd_sc_hd__nor3_1
X_8935_ net163 net160 net698 VSS VSS VDD VDD _4444_ sky130_fd_sc_hd__nor3_1
X_8936_ _4443_ _4444_ _4428_ VSS VSS VDD VDD _4445_ sky130_fd_sc_hd__o21ai_0
X_8937_ _4445_ VSS VSS VDD VDD _4446_ sky130_fd_sc_hd__inv_1
X_8938_ _4432_ _4446_ VSS VSS VDD VDD _4447_ sky130_fd_sc_hd__nand2_1
X_8939_ _4435_ _4447_ VSS VSS VDD VDD _0808_ sky130_fd_sc_hd__nor2_1
X_8940_ _4430_ _4431_ _4447_ VSS VSS VDD VDD _0809_ sky130_fd_sc_hd__a21oi_1
X_8941_ _4432_ _4435_ _4445_ VSS VSS VDD VDD _0810_ sky130_fd_sc_hd__nor3_1
X_8942_ _4433_ _4445_ VSS VSS VDD VDD _0811_ sky130_fd_sc_hd__nor2_1
X_8943_ _4334_ _4273_ VSS VSS VDD VDD _0813_ sky130_fd_sc_hd__nor2_1
X_8944_ _4334_ _4270_ VSS VSS VDD VDD _0814_ sky130_fd_sc_hd__nor2_1
X_8945_ _4334_ _4259_ VSS VSS VDD VDD _0815_ sky130_fd_sc_hd__nor2_1
X_8946_ _4334_ _4288_ VSS VSS VDD VDD _0816_ sky130_fd_sc_hd__nor2_1
X_8947_ _4334_ _4297_ VSS VSS VDD VDD _0817_ sky130_fd_sc_hd__nor2_1
X_8948_ _3440_ _4273_ VSS VSS VDD VDD _0818_ sky130_fd_sc_hd__nor2_1
X_8949_ _3440_ _4270_ VSS VSS VDD VDD _0819_ sky130_fd_sc_hd__nor2_1
X_8950_ _3440_ _4259_ VSS VSS VDD VDD _0820_ sky130_fd_sc_hd__nor2_1
X_8951_ is_alu_reg_imm _4271_ VSS VSS VDD VDD _0821_ sky130_fd_sc_hd__and2_1
X_8952_ _3277_ _4269_ VSS VSS VDD VDD _4448_ sky130_fd_sc_hd__nor2_1
X_8953_ is_alu_reg_imm _4262_ _4448_ VSS VSS VDD VDD _0822_
+ sky130_fd_sc_hd__and3_1
X_8954_ mem_rdata_q\[30\] is_alu_reg_imm _4275_ _4448_ VSS
+ VSS VDD VDD _0823_ sky130_fd_sc_hd__and4_1
X_8955_ mem_rdata_q\[31\] mem_rdata_q\[30\] VSS VSS VDD VDD
+ _4449_ sky130_fd_sc_hd__nand2_1
X_8956_ mem_rdata_q\[24\] _4259_ _4260_ _4449_ VSS VSS VDD
+ VDD _4450_ sky130_fd_sc_hd__or4_1
X_8957_ mem_rdata_q\[19\] mem_rdata_q\[18\] mem_rdata_q\[17\]
+ mem_rdata_q\[15\] VSS VSS VDD VDD _4451_ sky130_fd_sc_hd__nor4_1
X_8958_ mem_rdata_q\[23\] mem_rdata_q\[22\] mem_rdata_q\[16\]
+ mem_rdata_q\[4\] VSS VSS VDD VDD _4452_ sky130_fd_sc_hd__nor4b_1
X_8959_ _4451_ _4452_ VSS VSS VDD VDD _4453_ sky130_fd_sc_hd__nand2_1
X_8960_ mem_rdata_q\[3\] mem_rdata_q\[2\] VSS VSS VDD VDD
+ _4454_ sky130_fd_sc_hd__nor2_1
X_8961_ mem_rdata_q\[6\] mem_rdata_q\[5\] _4454_ VSS VSS VDD
+ VDD _4455_ sky130_fd_sc_hd__nand3_1
X_8962_ _4426_ _4450_ _4453_ _4455_ VSS VSS VDD VDD _4456_
+ sky130_fd_sc_hd__or4_1
X_8963_ net735 mem_rdata_q\[20\] _4456_ mem_rdata_q\[21\]
+ VSS VSS VDD VDD _0826_ sky130_fd_sc_hd__nor4b_1
X_8964_ mem_rdata_q\[20\] _4456_ net735 mem_rdata_q\[21\]
+ VSS VSS VDD VDD _0827_ sky130_fd_sc_hd__nor4bb_1
X_8965_ mem_rdata_q\[30\] _3277_ _4261_ _4269_ VSS VSS VDD
+ VDD _4457_ sky130_fd_sc_hd__a211oi_1
X_8966_ is_alu_reg_imm _4457_ VSS VSS VDD VDD _0828_ sky130_fd_sc_hd__and2_1
X_8967_ is_alu_reg_reg _4457_ VSS VSS VDD VDD _0829_ sky130_fd_sc_hd__and2_1
X_8968_ mem_rdata_latched\[14\] mem_rdata_latched\[12\] mem_rdata_latched\[13\]
+ VSS VSS VDD VDD _4458_ sky130_fd_sc_hd__or3_1
X_8969_ _4429_ _4439_ _4458_ VSS VSS VDD VDD _0831_ sky130_fd_sc_hd__nor3_1
X_8970_ net735 mem_rdata_q\[21\] _4456_ VSS VSS VDD VDD _0824_
+ sky130_fd_sc_hd__nor3_1
X_8971_ mem_rdata_q\[21\] _4456_ net735 VSS VSS VDD VDD _0825_
+ sky130_fd_sc_hd__nor3b_1
X_8972_ is_alu_reg_imm _4269_ instr_jalr VSS VSS VDD VDD _0832_
+ sky130_fd_sc_hd__a21o_1
X_8973_ instr_xor net663 VSS VSS VDD VDD _4459_ sky130_fd_sc_hd__nand2_1
X_8974_ _4264_ _4288_ _4459_ VSS VSS VDD VDD _0793_ sky130_fd_sc_hd__o21ai_0
X_8975_ net308 net733 net721 VSS VSS VDD VDD _4460_ sky130_fd_sc_hd__o21ai_0
X_8976_ _0962_ _4460_ VSS VSS VDD VDD net270 sky130_fd_sc_hd__nand2_1
X_8977_ _1500_ net690 _4384_ _0784_ net611 VSS VSS VDD VDD
+ _0000_ sky130_fd_sc_hd__o32a_1
X_8978_ count_cycle\[63\] net742 net741 count_instr\[31\]
+ count_instr\[63\] net740 VSS VSS VDD VDD _4461_ sky130_fd_sc_hd__a222oi_1
X_8979_ count_cycle\[31\] net686 VSS VSS VDD VDD _4462_ sky130_fd_sc_hd__nand2_1
X_8980_ _4461_ _4462_ VSS VSS VDD VDD _4463_ sky130_fd_sc_hd__nand2_1
X_8981_ net709 net747 net749 _4463_ _2936_ VSS VSS VDD VDD
+ _4464_ sky130_fd_sc_hd__a221oi_1
X_8982_ _0291_ _0440_ _0439_ VSS VSS VDD VDD _4465_ sky130_fd_sc_hd__a21o_1
X_8983_ _0292_ _0440_ _2986_ _4465_ VSS VSS VDD VDD _4466_
+ sky130_fd_sc_hd__a31oi_1
X_8984_ reg_pc\[31\] decoded_imm\[31\] VSS VSS VDD VDD _4467_
+ sky130_fd_sc_hd__xor2_1
X_8985_ _4466_ _4467_ VSS VSS VDD VDD _4468_ sky130_fd_sc_hd__xnor2_1
X_8986_ net748 _4468_ VSS VSS VDD VDD _4469_ sky130_fd_sc_hd__nand2_1
X_8987_ net162 net678 _2881_ VSS VSS VDD VDD _4470_ sky130_fd_sc_hd__a21oi_1
X_8988_ _4464_ _4469_ _4470_ VSS VSS VDD VDD _0028_ sky130_fd_sc_hd__a21oi_1
X_8989_ is_slli_srli_srai _2795_ VSS VSS VDD VDD _4471_ sky130_fd_sc_hd__nor2_1
X_8990_ decoded_imm_j\[4\] is_slli_srli_srai _4471_ VSS VSS
+ VDD VDD _4472_ sky130_fd_sc_hd__a21oi_1
X_8991_ reg_sh\[4\] _0157_ VSS VSS VDD VDD _4473_ sky130_fd_sc_hd__xor2_1
X_8992_ _0159_ VSS VSS VDD VDD _4474_ sky130_fd_sc_hd__inv_1
X_8993_ _4474_ _0165_ _0157_ VSS VSS VDD VDD _4475_ sky130_fd_sc_hd__o21ai_0
X_8994_ net658 _4475_ VSS VSS VDD VDD _4476_ sky130_fd_sc_hd__nand2_1
X_8995_ net658 _4473_ _4476_ net746 VSS VSS VDD VDD _4477_
+ sky130_fd_sc_hd__o211ai_1
X_8996_ net746 _4472_ _4477_ VSS VSS VDD VDD _0040_ sky130_fd_sc_hd__o21ai_0
X_8997_ cpuregs\[0\]\[31\] cpuregs\[1\]\[31\] cpuregs\[2\]\[31\]
+ cpuregs\[3\]\[31\] net762 net757 VSS VSS VDD VDD _4478_ sky130_fd_sc_hd__mux4_2
X_8998_ cpuregs\[4\]\[31\] cpuregs\[5\]\[31\] cpuregs\[6\]\[31\]
+ cpuregs\[7\]\[31\] net762 net757 VSS VSS VDD VDD _4479_ sky130_fd_sc_hd__mux4_2
X_8999_ cpuregs\[8\]\[31\] cpuregs\[9\]\[31\] cpuregs\[10\]\[31\]
+ cpuregs\[11\]\[31\] net762 net757 VSS VSS VDD VDD _4480_ sky130_fd_sc_hd__mux4_2
X_9000_ cpuregs\[12\]\[31\] cpuregs\[13\]\[31\] cpuregs\[14\]\[31\]
+ cpuregs\[15\]\[31\] net762 net757 VSS VSS VDD VDD _4481_ sky130_fd_sc_hd__mux4_2
X_9001_ _4478_ _4479_ _4480_ _4481_ net754 _0049_ VSS VSS
+ VDD VDD _4482_ sky130_fd_sc_hd__mux4_2
X_9002_ cpuregs\[16\]\[31\] cpuregs\[17\]\[31\] cpuregs\[18\]\[31\]
+ cpuregs\[19\]\[31\] _0046_ net757 VSS VSS VDD VDD _4483_ sky130_fd_sc_hd__mux4_2
X_9003_ cpuregs\[20\]\[31\] cpuregs\[21\]\[31\] cpuregs\[22\]\[31\]
+ cpuregs\[23\]\[31\] _0046_ net757 VSS VSS VDD VDD _4484_ sky130_fd_sc_hd__mux4_2
X_9004_ cpuregs\[24\]\[31\] cpuregs\[25\]\[31\] cpuregs\[26\]\[31\]
+ cpuregs\[27\]\[31\] _0046_ net757 VSS VSS VDD VDD _4485_ sky130_fd_sc_hd__mux4_2
X_9005_ cpuregs\[28\]\[31\] cpuregs\[29\]\[31\] cpuregs\[30\]\[31\]
+ cpuregs\[31\]\[31\] _0046_ net757 VSS VSS VDD VDD _4486_ sky130_fd_sc_hd__mux4_2
X_9006_ _4483_ _4484_ _4485_ _4486_ net754 _0049_ VSS VSS
+ VDD VDD _4487_ sky130_fd_sc_hd__mux4_2
X_9007_ _4482_ _4487_ _0050_ VSS VSS VDD VDD _4488_ sky130_fd_sc_hd__mux2i_1
X_9008_ decoded_imm\[31\] net687 VSS VSS VDD VDD _4489_ sky130_fd_sc_hd__nand2_1
X_9009_ net668 _4488_ _4489_ VSS VSS VDD VDD _4588_ sky130_fd_sc_hd__o21ai_0
X_9010_ _4406_ _4233_ _3420_ VSS VSS VDD VDD _0794_ sky130_fd_sc_hd__a21oi_1
X_9011_ _0087_ _0088_ _0086_ VSS VSS VDD VDD _4490_ sky130_fd_sc_hd__a21o_1
X_9012_ _0085_ _4490_ _0084_ VSS VSS VDD VDD _4491_ sky130_fd_sc_hd__a21oi_1
X_9013_ _1659_ _4491_ _0082_ VSS VSS VDD VDD _4492_ sky130_fd_sc_hd__o21bai_1
X_9014_ _0081_ _4492_ _0080_ VSS VSS VDD VDD _4493_ sky130_fd_sc_hd__a21oi_1
X_9015_ _1654_ _1788_ _4493_ VSS VSS VDD VDD _4494_ sky130_fd_sc_hd__o21ai_0
X_9016_ _0079_ _4494_ _0078_ VSS VSS VDD VDD _4495_ sky130_fd_sc_hd__a21oi_1
X_9017_ net709 decoded_imm\[31\] VSS VSS VDD VDD _4496_ sky130_fd_sc_hd__xnor2_1
X_9018_ _4495_ _4496_ VSS VSS VDD VDD _4497_ sky130_fd_sc_hd__xnor2_1
X_9019_ net710 net658 VSS VSS VDD VDD _4498_ sky130_fd_sc_hd__nand2_1
X_9020_ _0297_ net658 _4498_ VSS VSS VDD VDD _4499_ sky130_fd_sc_hd__o21ai_0
X_9021_ cpuregs\[0\]\[31\] cpuregs\[1\]\[31\] cpuregs\[2\]\[31\]
+ cpuregs\[3\]\[31\] _0041_ net768 VSS VSS VDD VDD _4500_ sky130_fd_sc_hd__mux4_2
X_9022_ cpuregs\[4\]\[31\] cpuregs\[5\]\[31\] cpuregs\[6\]\[31\]
+ cpuregs\[7\]\[31\] net771 net768 VSS VSS VDD VDD _4501_ sky130_fd_sc_hd__mux4_2
X_9023_ cpuregs\[16\]\[31\] cpuregs\[17\]\[31\] cpuregs\[18\]\[31\]
+ cpuregs\[19\]\[31\] net771 net768 VSS VSS VDD VDD _4502_ sky130_fd_sc_hd__mux4_2
X_9024_ cpuregs\[20\]\[31\] cpuregs\[21\]\[31\] cpuregs\[22\]\[31\]
+ cpuregs\[23\]\[31\] net771 net768 VSS VSS VDD VDD _4503_ sky130_fd_sc_hd__mux4_2
X_9025_ _4500_ _4501_ _4502_ _4503_ _0043_ _0045_ VSS VSS
+ VDD VDD _4504_ sky130_fd_sc_hd__mux4_2
X_9026_ cpuregs\[8\]\[31\] cpuregs\[9\]\[31\] cpuregs\[10\]\[31\]
+ cpuregs\[11\]\[31\] _0041_ net769 VSS VSS VDD VDD _4505_ sky130_fd_sc_hd__mux4_2
X_9027_ cpuregs\[12\]\[31\] cpuregs\[13\]\[31\] cpuregs\[14\]\[31\]
+ cpuregs\[15\]\[31\] _0041_ net769 VSS VSS VDD VDD _4506_ sky130_fd_sc_hd__mux4_2
X_9028_ cpuregs\[24\]\[31\] cpuregs\[25\]\[31\] cpuregs\[26\]\[31\]
+ cpuregs\[27\]\[31\] net771 net769 VSS VSS VDD VDD _4507_ sky130_fd_sc_hd__mux4_2
X_9029_ cpuregs\[28\]\[31\] cpuregs\[29\]\[31\] cpuregs\[30\]\[31\]
+ cpuregs\[31\]\[31\] net771 net769 VSS VSS VDD VDD _4508_ sky130_fd_sc_hd__mux4_2
X_9030_ _4505_ _4506_ _4507_ _4508_ _0043_ net763 VSS VSS
+ VDD VDD _4509_ sky130_fd_sc_hd__mux4_2
X_9031_ _4504_ _4509_ net764 VSS VSS VDD VDD _4510_ sky130_fd_sc_hd__mux2i_1
X_9032_ reg_pc\[31\] net688 VSS VSS VDD VDD _4511_ sky130_fd_sc_hd__nand2_1
X_9033_ _1687_ _4510_ _4511_ VSS VSS VDD VDD _4512_ sky130_fd_sc_hd__o21ai_0
X_9034_ net747 net671 _4499_ _4512_ _1728_ VSS VSS VDD VDD
+ _4513_ sky130_fd_sc_hd__a32oi_1
X_9035_ net691 _4497_ _4513_ VSS VSS VDD VDD _4620_ sky130_fd_sc_hd__o21ai_0
X_9036_ _0871_ _4439_ _4445_ VSS VSS VDD VDD _4514_ sky130_fd_sc_hd__nor3_1
X_9037_ is_beq_bne_blt_bge_bltu_bgeu _0871_ _4514_ VSS VSS
+ VDD VDD _4515_ sky130_fd_sc_hd__a21oi_1
X_9038_ _4515_ net776 VSS VSS VDD VDD _0796_ sky130_fd_sc_hd__nor2b_1
X_9039_ reg_pc\[27\] reg_pc\[28\] reg_pc\[29\] reg_pc\[30\]
+ VSS VSS VDD VDD _4516_ sky130_fd_sc_hd__nand4_1
X_9040_ _1533_ _4516_ VSS VSS VDD VDD _4517_ sky130_fd_sc_hd__nor2_1
X_9041_ reg_pc\[31\] _4517_ VSS VSS VDD VDD _4518_ sky130_fd_sc_hd__xnor2_1
X_9042_ _4301_ _4518_ net693 VSS VSS VDD VDD cpuregs_wrdata\[31\]
+ sky130_fd_sc_hd__mux2i_2
X_9043_ _0194_ _1181_ _0193_ VSS VSS VDD VDD _4519_ sky130_fd_sc_hd__a21o_1
X_9044_ _0147_ _0194_ _0116_ _1027_ VSS VSS VDD VDD _4520_
+ sky130_fd_sc_hd__and4_1
X_9045_ _0147_ _4519_ _4520_ _1180_ _0146_ VSS VSS VDD VDD
+ _4521_ sky130_fd_sc_hd__a221oi_2
X_9046_ _1495_ _4521_ VSS VSS VDD VDD _4522_ sky130_fd_sc_hd__xnor2_1
X_9047_ _0296_ _0489_ VSS VSS VDD VDD _4523_ sky130_fd_sc_hd__nor2_1
X_9048_ _1224_ _1223_ _1103_ VSS VSS VDD VDD _4524_ sky130_fd_sc_hd__a21boi_0
X_9049_ _1031_ _4524_ _0295_ VSS VSS VDD VDD _4525_ sky130_fd_sc_hd__o21ai_0
X_9050_ _0489_ _4523_ _4525_ VSS VSS VDD VDD _4526_ sky130_fd_sc_hd__mux2_2
X_9051_ net739 _0296_ _0489_ VSS VSS VDD VDD _4527_ sky130_fd_sc_hd__nand3b_1
X_9052_ _0489_ _1013_ VSS VSS VDD VDD _4528_ sky130_fd_sc_hd__nand2_1
X_9053_ _0488_ net694 _4528_ VSS VSS VDD VDD _4529_ sky130_fd_sc_hd__o21ai_0
X_9054_ _0490_ _1016_ net679 _4527_ _4529_ VSS VSS VDD VDD
+ _4530_ sky130_fd_sc_hd__a221oi_1
X_9055_ _1100_ _4522_ _4526_ _1254_ _4530_ VSS VSS VDD VDD
+ alu_out\[31\] sky130_fd_sc_hd__a221oi_1
X_9056_ _0076_ _3753_ VSS VSS VDD VDD _4531_ sky130_fd_sc_hd__nand2b_1
X_9057_ _0424_ _3724_ _0423_ VSS VSS VDD VDD _4532_ sky130_fd_sc_hd__a21oi_1
X_9058_ _4532_ _0389_ VSS VSS VDD VDD _4533_ sky130_fd_sc_hd__nor2b_1
X_9059_ _0392_ _4531_ _4533_ _0391_ _0388_ VSS VSS VDD VDD
+ _4534_ sky130_fd_sc_hd__a2111oi_1
X_9060_ _0339_ _0381_ _0338_ VSS VSS VDD VDD _4535_ sky130_fd_sc_hd__a21oi_1
X_9061_ _3692_ _4535_ _0424_ VSS VSS VDD VDD _4536_ sky130_fd_sc_hd__a21boi_0
X_9062_ _0423_ _4536_ _0389_ VSS VSS VDD VDD _4537_ sky130_fd_sc_hd__o21ai_0
X_9063_ _0388_ _4537_ VSS VSS VDD VDD _4538_ sky130_fd_sc_hd__nand2b_1
X_9064_ net745 _4303_ VSS VSS VDD VDD _4539_ sky130_fd_sc_hd__xor2_1
X_9065_ reg_next_pc\[31\] cpu_state\[1\] net776 VSS VSS VDD
+ VDD _4540_ sky130_fd_sc_hd__o21ai_0
X_9066_ _3716_ _4540_ VSS VSS VDD VDD _4541_ sky130_fd_sc_hd__nor2_1
X_9067_ _4538_ _4539_ _4541_ VSS VSS VDD VDD _4542_ sky130_fd_sc_hd__nand3_1
X_9068_ _0387_ _3704_ _3764_ VSS VSS VDD VDD _4543_ sky130_fd_sc_hd__nand3_1
X_9069_ _4303_ _4543_ VSS VSS VDD VDD _4544_ sky130_fd_sc_hd__xor2_1
X_9070_ net745 net744 _4303_ VSS VSS VDD VDD _4545_ sky130_fd_sc_hd__nand3_1
X_9071_ net745 _4303_ _4545_ VSS VSS VDD VDD _4546_ sky130_fd_sc_hd__o21ai_0
X_9072_ net743 _4546_ VSS VSS VDD VDD _4547_ sky130_fd_sc_hd__nand2_1
X_9073_ net744 _4303_ _4538_ _4547_ cpu_state\[1\] VSS VSS
+ VDD VDD _4548_ sky130_fd_sc_hd__o221ai_1
X_9074_ _3780_ _4544_ _4548_ VSS VSS VDD VDD _4549_ sky130_fd_sc_hd__a21oi_1
X_9075_ _3716_ _4540_ _4539_ VSS VSS VDD VDD _4550_ sky130_fd_sc_hd__nor3_1
X_9076_ _4540_ _4549_ _4534_ _4550_ VSS VSS VDD VDD _4551_
+ sky130_fd_sc_hd__a2bb2oi_1
X_9077_ _4534_ _4542_ _4551_ VSS VSS VDD VDD _0797_ sky130_fd_sc_hd__o21ai_0
X_9078_ _3439_ _4345_ _4265_ VSS VSS VDD VDD _0798_ sky130_fd_sc_hd__a21boi_0
X_9079_ instr_and net663 VSS VSS VDD VDD _4552_ sky130_fd_sc_hd__nand2_1
X_9080_ _4264_ _4283_ _4552_ VSS VSS VDD VDD _0799_ sky130_fd_sc_hd__o21ai_0
X_9081_ net307 net266 VSS VSS VDD VDD _4553_ sky130_fd_sc_hd__nor2_1
X_9082_ _0962_ net266 _4460_ _4553_ _1004_ VSS VSS VDD VDD
+ _4632_ sky130_fd_sc_hd__a311oi_1
X_9083_ instr_sltu net663 VSS VSS VDD VDD _4554_ sky130_fd_sc_hd__nand2_1
X_9084_ _4264_ _4290_ _4554_ VSS VSS VDD VDD _0800_ sky130_fd_sc_hd__o21ai_0
X_9085_ _3423_ _3421_ mem_rdata_q\[31\] VSS VSS VDD VDD _4555_
+ sky130_fd_sc_hd__o21ai_0
X_9086_ _3428_ _4555_ VSS VSS VDD VDD _0801_ sky130_fd_sc_hd__nand2_1
X_9087_ instr_or net663 VSS VSS VDD VDD _4556_ sky130_fd_sc_hd__nand2_1
X_9088_ _4264_ _4285_ _4556_ VSS VSS VDD VDD _0802_ sky130_fd_sc_hd__o21ai_0
X_9089_ instr_sra _4265_ VSS VSS VDD VDD _4557_ sky130_fd_sc_hd__nand2_1
X_9090_ _4276_ _4297_ _4557_ VSS VSS VDD VDD _0803_ sky130_fd_sc_hd__o21ai_0
X_9091_ instr_srl _4265_ VSS VSS VDD VDD _4558_ sky130_fd_sc_hd__nand2_1
X_9092_ _4264_ _4297_ _4558_ VSS VSS VDD VDD _0804_ sky130_fd_sc_hd__o21ai_0
X_9093_ net345 net733 net734 net263 VSS VSS VDD VDD _4559_
+ sky130_fd_sc_hd__a22oi_1
X_9094_ _0481_ _0962_ _4559_ VSS VSS VDD VDD net258 sky130_fd_sc_hd__o21ai_0
X_9095_ _4344_ VSS VSS VDD VDD _0001_ sky130_fd_sc_hd__inv_1
X_9096_ instr_blt instr_slti instr_slt VSS VSS VDD VDD _0002_
+ sky130_fd_sc_hd__or3_1
X_9097_ instr_sltu instr_bltu instr_sltiu VSS VSS VDD VDD
+ _0003_ sky130_fd_sc_hd__or3_1
X_9098_ reg_out\[31\] _0886_ VSS VSS VDD VDD _4560_ sky130_fd_sc_hd__nand2_1
X_9099_ net332 net695 VSS VSS VDD VDD _4561_ sky130_fd_sc_hd__nor2_1
X_9100_ net695 _4302_ _4560_ _4561_ VSS VSS VDD VDD net225
+ sky130_fd_sc_hd__a31oi_1
X_9101_ net162 _3278_ VSS VSS VDD VDD _4562_ sky130_fd_sc_hd__nand2_1
X_9102_ mem_rdata_q\[31\] net698 VSS VSS VDD VDD _4563_ sky130_fd_sc_hd__nand2_1
X_9103_ _4562_ _4563_ VSS VSS VDD VDD mem_rdata_latched\[31\]
+ sky130_fd_sc_hd__nand2_1
X_9104_ decoded_imm_j\[2\] _0051_ _0052_ VSS VSS VDD VDD _0053_
+ _0054_ sky130_fd_sc_hd__fa_1
X_9105_ net245 _0055_ _0056_ VSS VSS VDD VDD _0057_ _0058_
+ sky130_fd_sc_hd__fa_1
X_9106_ net245 net721 _0060_ VSS VSS VDD VDD _0061_ _0062_
+ sky130_fd_sc_hd__fa_1
X_9107_ net319 decoded_imm\[1\] _0063_ VSS VSS VDD VDD _0064_
+ _0065_ sky130_fd_sc_hd__fa_1
X_9108_ reg_pc\[2\] decoded_imm\[2\] _0066_ VSS VSS VDD VDD
+ _0067_ _0068_ sky130_fd_sc_hd__fa_1
X_9109_ reg_pc\[2\] decoded_imm\[2\] VSS VSS VDD VDD _0070_
+ _0071_ sky130_fd_sc_hd__ha_1
X_9110_ decoded_imm_j\[20\] _0072_ VSS VSS VDD VDD _0073_
+ _0074_ sky130_fd_sc_hd__ha_1
X_9111_ net745 _0075_ VSS VSS VDD VDD _0076_ _0077_ sky130_fd_sc_hd__ha_1
X_9112_ net710 decoded_imm\[30\] VSS VSS VDD VDD _0078_ _0079_
+ sky130_fd_sc_hd__ha_1
X_9113_ net329 decoded_imm\[29\] VSS VSS VDD VDD _0080_ _0081_
+ sky130_fd_sc_hd__ha_1
X_9114_ net712 decoded_imm\[28\] VSS VSS VDD VDD _0082_ _0083_
+ sky130_fd_sc_hd__ha_1
X_9115_ net713 decoded_imm\[27\] VSS VSS VDD VDD _0084_ _0085_
+ sky130_fd_sc_hd__ha_1
X_9116_ net714 decoded_imm\[26\] VSS VSS VDD VDD _0086_ _0087_
+ sky130_fd_sc_hd__ha_1
X_9117_ net715 decoded_imm\[25\] VSS VSS VDD VDD _0088_ _0089_
+ sky130_fd_sc_hd__ha_1
X_9118_ net716 decoded_imm\[24\] VSS VSS VDD VDD _0090_ _0091_
+ sky130_fd_sc_hd__ha_1
X_9119_ net717 decoded_imm\[23\] VSS VSS VDD VDD _0092_ _0093_
+ sky130_fd_sc_hd__ha_1
X_9120_ decoded_imm_j\[20\] _0094_ VSS VSS VDD VDD _0095_
+ _0096_ sky130_fd_sc_hd__ha_1
X_9121_ decoded_imm_j\[16\] _0097_ VSS VSS VDD VDD _0098_
+ _0099_ sky130_fd_sc_hd__ha_1
X_9122_ net718 decoded_imm\[22\] VSS VSS VDD VDD _0100_ _0101_
+ sky130_fd_sc_hd__ha_1
X_9123_ reg_pc\[9\] decoded_imm\[9\] VSS VSS VDD VDD _0103_
+ _0104_ sky130_fd_sc_hd__ha_1
X_9124_ net717 _0105_ VSS VSS VDD VDD _0106_ _0107_ sky130_fd_sc_hd__ha_1
X_9125_ _0108_ _0109_ VSS VSS VDD VDD _0110_ _0111_ sky130_fd_sc_hd__ha_1
X_9126_ net720 _0109_ VSS VSS VDD VDD _0112_ _4633_ sky130_fd_sc_hd__ha_1
X_9127_ net720 net350 VSS VSS VDD VDD _0113_ _4634_ sky130_fd_sc_hd__ha_1
X_9128_ net713 _0114_ VSS VSS VDD VDD _0115_ _0116_ sky130_fd_sc_hd__ha_1
X_9129_ decoded_imm_j\[9\] _0117_ VSS VSS VDD VDD _0118_ _0119_
+ sky130_fd_sc_hd__ha_1
X_9130_ decoded_imm_j\[12\] _0120_ VSS VSS VDD VDD _0121_
+ _0122_ sky130_fd_sc_hd__ha_1
X_9131_ _0123_ _0105_ VSS VSS VDD VDD _0124_ _0125_ sky130_fd_sc_hd__ha_1
X_9132_ net717 net353 VSS VSS VDD VDD _0126_ _4635_ sky130_fd_sc_hd__ha_1
X_9133_ net715 _0127_ VSS VSS VDD VDD _0128_ _0129_ sky130_fd_sc_hd__ha_1
X_9134_ reg_pc\[10\] decoded_imm\[10\] VSS VSS VDD VDD _0130_
+ _0131_ sky130_fd_sc_hd__ha_1
X_9135_ count_cycle\[0\] count_cycle\[1\] VSS VSS VDD VDD
+ _0132_ _0133_ sky130_fd_sc_hd__ha_1
X_9136_ reg_pc\[19\] decoded_imm\[19\] VSS VSS VDD VDD _0134_
+ _0135_ sky130_fd_sc_hd__ha_1
X_9137_ net703 _0136_ VSS VSS VDD VDD _0137_ _0138_ sky130_fd_sc_hd__ha_1
X_9138_ net726 _0139_ VSS VSS VDD VDD _0140_ _0141_ sky130_fd_sc_hd__ha_1
X_9139_ net728 _0142_ VSS VSS VDD VDD _0143_ _0144_ sky130_fd_sc_hd__ha_1
X_9140_ net710 _0145_ VSS VSS VDD VDD _0146_ _0147_ sky130_fd_sc_hd__ha_1
X_9141_ net730 _0148_ VSS VSS VDD VDD _0149_ _0150_ sky130_fd_sc_hd__ha_1
X_9142_ reg_pc\[26\] decoded_imm\[26\] VSS VSS VDD VDD _0151_
+ _0152_ sky130_fd_sc_hd__ha_1
X_9143_ reg_pc\[22\] decoded_imm\[22\] VSS VSS VDD VDD _0153_
+ _0154_ sky130_fd_sc_hd__ha_1
X_9144_ _0155_ _0156_ VSS VSS VDD VDD _0157_ _0158_ sky130_fd_sc_hd__ha_1
X_9145_ _0155_ _0156_ VSS VSS VDD VDD _0159_ _4636_ sky130_fd_sc_hd__ha_1
X_9146_ reg_sh\[2\] _0156_ VSS VSS VDD VDD _0160_ _4637_ sky130_fd_sc_hd__ha_1
X_9147_ reg_pc\[2\] reg_pc\[3\] VSS VSS VDD VDD _0161_ _0162_
+ sky130_fd_sc_hd__ha_1
X_9148_ _0163_ _0164_ VSS VSS VDD VDD _0165_ _0166_ sky130_fd_sc_hd__ha_1
X_9149_ _0163_ _0164_ VSS VSS VDD VDD _0167_ _4638_ sky130_fd_sc_hd__ha_1
X_9150_ net719 decoded_imm\[21\] VSS VSS VDD VDD _0168_ _0169_
+ sky130_fd_sc_hd__ha_1
X_9151_ net720 decoded_imm\[20\] VSS VSS VDD VDD _0170_ _0171_
+ sky130_fd_sc_hd__ha_1
X_9152_ net722 decoded_imm\[19\] VSS VSS VDD VDD _0172_ _0173_
+ sky130_fd_sc_hd__ha_1
X_9153_ net723 decoded_imm\[18\] VSS VSS VDD VDD _0174_ _0175_
+ sky130_fd_sc_hd__ha_1
X_9154_ net724 decoded_imm\[17\] VSS VSS VDD VDD _0176_ _0177_
+ sky130_fd_sc_hd__ha_1
X_9155_ net725 decoded_imm\[16\] VSS VSS VDD VDD _0178_ _0179_
+ sky130_fd_sc_hd__ha_1
X_9156_ net726 decoded_imm\[15\] VSS VSS VDD VDD _0180_ _0181_
+ sky130_fd_sc_hd__ha_1
X_9157_ net727 decoded_imm\[14\] VSS VSS VDD VDD _0182_ _0183_
+ sky130_fd_sc_hd__ha_1
X_9158_ net728 decoded_imm\[13\] VSS VSS VDD VDD _0184_ _0185_
+ sky130_fd_sc_hd__ha_1
X_9159_ net729 decoded_imm\[12\] VSS VSS VDD VDD _0186_ _0187_
+ sky130_fd_sc_hd__ha_1
X_9160_ net730 decoded_imm\[11\] VSS VSS VDD VDD _0188_ _0189_
+ sky130_fd_sc_hd__ha_1
X_9161_ net704 decoded_imm\[7\] VSS VSS VDD VDD _0190_ _0191_
+ sky130_fd_sc_hd__ha_1
X_9162_ net329 _0192_ VSS VSS VDD VDD _0193_ _0194_ sky130_fd_sc_hd__ha_1
X_9163_ net714 _0195_ VSS VSS VDD VDD _0196_ _0197_ sky130_fd_sc_hd__ha_1
X_9164_ _0198_ _0199_ VSS VSS VDD VDD _0200_ _0201_ sky130_fd_sc_hd__ha_1
X_9165_ net719 _0199_ VSS VSS VDD VDD _0202_ _4639_ sky130_fd_sc_hd__ha_1
X_9166_ net719 net351 VSS VSS VDD VDD _0203_ _4640_ sky130_fd_sc_hd__ha_1
X_9167_ net723 _0204_ VSS VSS VDD VDD _0205_ _0206_ sky130_fd_sc_hd__ha_1
X_9168_ net724 _0207_ VSS VSS VDD VDD _0208_ _0209_ sky130_fd_sc_hd__ha_1
X_9169_ _0210_ _0211_ VSS VSS VDD VDD _0212_ _0213_ sky130_fd_sc_hd__ha_1
X_9170_ net729 _0211_ VSS VSS VDD VDD _0214_ _4641_ sky130_fd_sc_hd__ha_1
X_9171_ net729 net342 VSS VSS VDD VDD _0215_ _4642_ sky130_fd_sc_hd__ha_1
X_9172_ net722 _0216_ VSS VSS VDD VDD _0217_ _0218_ sky130_fd_sc_hd__ha_1
X_9173_ net703 decoded_imm\[8\] VSS VSS VDD VDD _0220_ _0221_
+ sky130_fd_sc_hd__ha_1
X_9174_ net707 decoded_imm\[4\] VSS VSS VDD VDD _0222_ _0223_
+ sky130_fd_sc_hd__ha_1
X_9175_ net708 decoded_imm\[3\] VSS VSS VDD VDD _0224_ _0225_
+ sky130_fd_sc_hd__ha_1
X_9176_ net711 decoded_imm\[2\] VSS VSS VDD VDD _0226_ _0227_
+ sky130_fd_sc_hd__ha_1
X_9177_ net732 decoded_imm\[0\] VSS VSS VDD VDD _0063_ _0228_
+ sky130_fd_sc_hd__ha_1
X_9178_ net718 _0229_ VSS VSS VDD VDD _0230_ _0231_ sky130_fd_sc_hd__ha_1
X_9179_ reg_pc\[16\] decoded_imm\[16\] VSS VSS VDD VDD _0232_
+ _0233_ sky130_fd_sc_hd__ha_1
X_9180_ net706 _0234_ VSS VSS VDD VDD _0235_ _0236_ sky130_fd_sc_hd__ha_1
X_9181_ net731 decoded_imm\[10\] VSS VSS VDD VDD _0237_ _0238_
+ sky130_fd_sc_hd__ha_1
X_9182_ net702 decoded_imm\[9\] VSS VSS VDD VDD _0239_ _0240_
+ sky130_fd_sc_hd__ha_1
X_9183_ net705 decoded_imm\[6\] VSS VSS VDD VDD _0241_ _0242_
+ sky130_fd_sc_hd__ha_1
X_9184_ net706 decoded_imm\[5\] VSS VSS VDD VDD _0243_ _0244_
+ sky130_fd_sc_hd__ha_1
X_9185_ net319 decoded_imm\[1\] VSS VSS VDD VDD _0245_ _0219_
+ sky130_fd_sc_hd__ha_1
X_9186_ _0246_ _0204_ VSS VSS VDD VDD _0247_ _0248_ sky130_fd_sc_hd__ha_1
X_9187_ net723 net348 VSS VSS VDD VDD _0249_ _4643_ sky130_fd_sc_hd__ha_1
X_9188_ _0250_ _0207_ VSS VSS VDD VDD _0251_ _0252_ sky130_fd_sc_hd__ha_1
X_9189_ net724 net347 VSS VSS VDD VDD _0253_ _4644_ sky130_fd_sc_hd__ha_1
X_9190_ _0254_ _0127_ VSS VSS VDD VDD _0255_ _0256_ sky130_fd_sc_hd__ha_1
X_9191_ net715 net355 VSS VSS VDD VDD _0257_ _4645_ sky130_fd_sc_hd__ha_1
X_9192_ net745 _0258_ VSS VSS VDD VDD _0259_ _0260_ sky130_fd_sc_hd__ha_1
X_9193_ decoded_imm_j\[15\] _0261_ VSS VSS VDD VDD _0262_
+ _0263_ sky130_fd_sc_hd__ha_1
X_9194_ reg_pc\[15\] decoded_imm\[15\] VSS VSS VDD VDD _0264_
+ _0265_ sky130_fd_sc_hd__ha_1
X_9195_ decoded_imm_j\[3\] _0266_ VSS VSS VDD VDD _0267_ _0268_
+ sky130_fd_sc_hd__ha_1
X_9196_ _0269_ _0192_ VSS VSS VDD VDD _0270_ _0271_ sky130_fd_sc_hd__ha_1
X_9197_ net329 net359 VSS VSS VDD VDD _0272_ _4646_ sky130_fd_sc_hd__ha_1
X_9198_ decoded_imm_j\[5\] _0273_ VSS VSS VDD VDD _0274_ _0275_
+ sky130_fd_sc_hd__ha_1
X_9199_ _0052_ _0266_ VSS VSS VDD VDD _0276_ _0277_ sky130_fd_sc_hd__ha_1
X_9200_ net711 _0278_ VSS VSS VDD VDD _0279_ _0280_ sky130_fd_sc_hd__ha_1
X_9201_ reg_pc\[28\] decoded_imm\[28\] VSS VSS VDD VDD _0281_
+ _0282_ sky130_fd_sc_hd__ha_1
X_9202_ _0283_ _0284_ VSS VSS VDD VDD _0285_ _0286_ sky130_fd_sc_hd__ha_1
X_9203_ net731 _0284_ VSS VSS VDD VDD _0287_ _4647_ sky130_fd_sc_hd__ha_1
X_9204_ net731 net340 VSS VSS VDD VDD _0288_ _4648_ sky130_fd_sc_hd__ha_1
X_9205_ reg_pc\[11\] decoded_imm\[11\] VSS VSS VDD VDD _0289_
+ _0290_ sky130_fd_sc_hd__ha_1
X_9206_ reg_pc\[29\] decoded_imm\[29\] VSS VSS VDD VDD _0291_
+ _0292_ sky130_fd_sc_hd__ha_1
X_9207_ _0293_ _0145_ VSS VSS VDD VDD _0294_ _0295_ sky130_fd_sc_hd__ha_1
X_9208_ net710 net701 VSS VSS VDD VDD _0296_ _4649_ sky130_fd_sc_hd__ha_1
X_9209_ _0297_ _0114_ VSS VSS VDD VDD _0298_ _0299_ sky130_fd_sc_hd__ha_1
X_9210_ net713 net357 VSS VSS VDD VDD _0300_ _4650_ sky130_fd_sc_hd__ha_1
X_9211_ _0301_ _0195_ VSS VSS VDD VDD _0302_ _0303_ sky130_fd_sc_hd__ha_1
X_9212_ net714 net356 VSS VSS VDD VDD _0304_ _4651_ sky130_fd_sc_hd__ha_1
X_9213_ _0305_ _0229_ VSS VSS VDD VDD _0306_ _0307_ sky130_fd_sc_hd__ha_1
X_9214_ net718 net352 VSS VSS VDD VDD _0308_ _4652_ sky130_fd_sc_hd__ha_1
X_9215_ _0309_ _0216_ VSS VSS VDD VDD _0310_ _0311_ sky130_fd_sc_hd__ha_1
X_9216_ net722 net349 VSS VSS VDD VDD _0312_ _4653_ sky130_fd_sc_hd__ha_1
X_9217_ _0313_ _0139_ VSS VSS VDD VDD _0314_ _0315_ sky130_fd_sc_hd__ha_1
X_9218_ net726 net345 VSS VSS VDD VDD _0316_ _4654_ sky130_fd_sc_hd__ha_1
X_9219_ _0317_ _0142_ VSS VSS VDD VDD _0318_ _0319_ sky130_fd_sc_hd__ha_1
X_9220_ net728 net343 VSS VSS VDD VDD _0320_ _4655_ sky130_fd_sc_hd__ha_1
X_9221_ _0321_ _0148_ VSS VSS VDD VDD _0322_ _0323_ sky130_fd_sc_hd__ha_1
X_9222_ net730 net341 VSS VSS VDD VDD _0324_ _4656_ sky130_fd_sc_hd__ha_1
X_9223_ _0325_ _0136_ VSS VSS VDD VDD _0326_ _0327_ sky130_fd_sc_hd__ha_1
X_9224_ net703 net362 VSS VSS VDD VDD _0328_ _4657_ sky130_fd_sc_hd__ha_1
X_9225_ _0234_ _0329_ VSS VSS VDD VDD _0330_ _0331_ sky130_fd_sc_hd__ha_1
X_9226_ net261 net706 VSS VSS VDD VDD _0332_ _4658_ sky130_fd_sc_hd__ha_1
X_9227_ _0278_ _0333_ VSS VSS VDD VDD _0334_ _0335_ sky130_fd_sc_hd__ha_1
X_9228_ net256 net711 VSS VSS VDD VDD _0336_ _4659_ sky130_fd_sc_hd__ha_1
X_9229_ net745 _0337_ VSS VSS VDD VDD _0338_ _0339_ sky130_fd_sc_hd__ha_1
X_9230_ _0340_ _0341_ VSS VSS VDD VDD _0342_ _0343_ sky130_fd_sc_hd__ha_1
X_9231_ net725 _0341_ VSS VSS VDD VDD _0344_ _4660_ sky130_fd_sc_hd__ha_1
X_9232_ net725 net346 VSS VSS VDD VDD _0345_ _4661_ sky130_fd_sc_hd__ha_1
X_9233_ _0346_ _0347_ VSS VSS VDD VDD _0348_ _0349_ sky130_fd_sc_hd__ha_1
X_9234_ net727 _0347_ VSS VSS VDD VDD _0350_ _4662_ sky130_fd_sc_hd__ha_1
X_9235_ net727 net344 VSS VSS VDD VDD _0351_ _4663_ sky130_fd_sc_hd__ha_1
X_9236_ reg_pc\[27\] decoded_imm\[27\] VSS VSS VDD VDD _0352_
+ _0353_ sky130_fd_sc_hd__ha_1
X_9237_ reg_pc\[23\] decoded_imm\[23\] VSS VSS VDD VDD _0354_
+ _0355_ sky130_fd_sc_hd__ha_1
X_9238_ reg_pc\[5\] decoded_imm\[5\] VSS VSS VDD VDD _0356_
+ _0357_ sky130_fd_sc_hd__ha_1
X_9239_ reg_pc\[1\] decoded_imm\[1\] VSS VSS VDD VDD _0066_
+ _0358_ sky130_fd_sc_hd__ha_1
X_9240_ count_instr\[0\] count_instr\[1\] VSS VSS VDD VDD
+ _0359_ _0360_ sky130_fd_sc_hd__ha_1
X_9241_ reg_pc\[6\] decoded_imm\[6\] VSS VSS VDD VDD _0361_
+ _0362_ sky130_fd_sc_hd__ha_1
X_9242_ reg_pc\[3\] decoded_imm\[3\] VSS VSS VDD VDD _0363_
+ _0364_ sky130_fd_sc_hd__ha_1
X_9243_ decoded_imm_j\[8\] _0365_ VSS VSS VDD VDD _0366_ _0367_
+ sky130_fd_sc_hd__ha_1
X_9244_ _0368_ _0369_ VSS VSS VDD VDD _0370_ _0371_ sky130_fd_sc_hd__ha_1
X_9245_ net716 _0369_ VSS VSS VDD VDD _0372_ _4664_ sky130_fd_sc_hd__ha_1
X_9246_ net716 net354 VSS VSS VDD VDD _0373_ _4665_ sky130_fd_sc_hd__ha_1
X_9247_ _0374_ _0375_ VSS VSS VDD VDD _0376_ _0377_ sky130_fd_sc_hd__ha_1
X_9248_ _0374_ net705 VSS VSS VDD VDD _0378_ _4666_ sky130_fd_sc_hd__ha_1
X_9249_ net262 net705 VSS VSS VDD VDD _0379_ _4667_ sky130_fd_sc_hd__ha_1
X_9250_ net745 _0380_ VSS VSS VDD VDD _0381_ _0382_ sky130_fd_sc_hd__ha_1
X_9251_ reg_pc\[21\] decoded_imm\[21\] VSS VSS VDD VDD _0383_
+ _0384_ sky130_fd_sc_hd__ha_1
X_9252_ reg_pc\[18\] decoded_imm\[18\] VSS VSS VDD VDD _0385_
+ _0386_ sky130_fd_sc_hd__ha_1
X_9253_ net745 _0387_ VSS VSS VDD VDD _0388_ _0389_ sky130_fd_sc_hd__ha_1
X_9254_ net745 _0390_ VSS VSS VDD VDD _0391_ _0392_ sky130_fd_sc_hd__ha_1
X_9255_ net745 _0393_ VSS VSS VDD VDD _0394_ _0395_ sky130_fd_sc_hd__ha_1
X_9256_ decoded_imm_j\[18\] _0396_ VSS VSS VDD VDD _0397_
+ _0398_ sky130_fd_sc_hd__ha_1
X_9257_ decoded_imm_j\[14\] _0399_ VSS VSS VDD VDD _0400_
+ _0401_ sky130_fd_sc_hd__ha_1
X_9258_ decoded_imm_j\[10\] _0402_ VSS VSS VDD VDD _0403_
+ _0404_ sky130_fd_sc_hd__ha_1
X_9259_ decoded_imm_j\[6\] _0405_ VSS VSS VDD VDD _0406_ _0407_
+ sky130_fd_sc_hd__ha_1
X_9260_ decoded_imm_j\[2\] _0052_ VSS VSS VDD VDD _0408_ _0069_
+ sky130_fd_sc_hd__ha_1
X_9261_ reg_pc\[7\] decoded_imm\[7\] VSS VSS VDD VDD _0409_
+ _0410_ sky130_fd_sc_hd__ha_1
X_9262_ _0411_ _0412_ VSS VSS VDD VDD _0413_ _0414_ sky130_fd_sc_hd__ha_1
X_9263_ net702 _0412_ VSS VSS VDD VDD _0415_ _4668_ sky130_fd_sc_hd__ha_1
X_9264_ net702 net363 VSS VSS VDD VDD _0416_ _4669_ sky130_fd_sc_hd__ha_1
X_9265_ decoded_imm_j\[17\] _0417_ VSS VSS VDD VDD _0418_
+ _0419_ sky130_fd_sc_hd__ha_1
X_9266_ decoded_imm_j\[1\] _0420_ VSS VSS VDD VDD _0051_ _0421_
+ sky130_fd_sc_hd__ha_1
X_9267_ net745 _0422_ VSS VSS VDD VDD _0423_ _0424_ sky130_fd_sc_hd__ha_1
X_9268_ decoded_imm_j\[13\] _0425_ VSS VSS VDD VDD _0426_
+ _0427_ sky130_fd_sc_hd__ha_1
X_9269_ decoded_imm_j\[19\] _0428_ VSS VSS VDD VDD _0429_
+ _0430_ sky130_fd_sc_hd__ha_1
X_9270_ net745 _0431_ VSS VSS VDD VDD _0432_ _0433_ sky130_fd_sc_hd__ha_1
X_9271_ decoded_imm_j\[7\] _0434_ VSS VSS VDD VDD _0435_ _0436_
+ sky130_fd_sc_hd__ha_1
X_9272_ reg_pc\[4\] decoded_imm\[4\] VSS VSS VDD VDD _0437_
+ _0438_ sky130_fd_sc_hd__ha_1
X_9273_ reg_pc\[30\] decoded_imm\[30\] VSS VSS VDD VDD _0439_
+ _0440_ sky130_fd_sc_hd__ha_1
X_9274_ reg_pc\[24\] decoded_imm\[24\] VSS VSS VDD VDD _0441_
+ _0442_ sky130_fd_sc_hd__ha_1
X_9275_ reg_pc\[25\] decoded_imm\[25\] VSS VSS VDD VDD _0443_
+ _0444_ sky130_fd_sc_hd__ha_1
X_9276_ reg_pc\[13\] decoded_imm\[13\] VSS VSS VDD VDD _0445_
+ _0446_ sky130_fd_sc_hd__ha_1
X_9277_ reg_pc\[14\] decoded_imm\[14\] VSS VSS VDD VDD _0447_
+ _0448_ sky130_fd_sc_hd__ha_1
X_9278_ reg_pc\[17\] decoded_imm\[17\] VSS VSS VDD VDD _0449_
+ _0450_ sky130_fd_sc_hd__ha_1
X_9279_ _0451_ _0452_ VSS VSS VDD VDD _0453_ _0454_ sky130_fd_sc_hd__ha_1
X_9280_ _0451_ net704 VSS VSS VDD VDD _0455_ _4670_ sky130_fd_sc_hd__ha_1
X_9281_ net263 net704 VSS VSS VDD VDD _0456_ _4671_ sky130_fd_sc_hd__ha_1
X_9282_ decoded_imm_j\[4\] _0457_ VSS VSS VDD VDD _0458_ _0459_
+ sky130_fd_sc_hd__ha_1
X_9283_ decoded_imm_j\[11\] _0460_ VSS VSS VDD VDD _0461_
+ _0462_ sky130_fd_sc_hd__ha_1
X_9284_ _0463_ _0464_ VSS VSS VDD VDD _0465_ _0466_ sky130_fd_sc_hd__ha_1
X_9285_ _0463_ net707 VSS VSS VDD VDD _0467_ _4672_ sky130_fd_sc_hd__ha_1
X_9286_ net260 net707 VSS VSS VDD VDD _0468_ _4673_ sky130_fd_sc_hd__ha_1
X_9287_ _0469_ _0470_ VSS VSS VDD VDD _0471_ _0472_ sky130_fd_sc_hd__ha_1
X_9288_ _0469_ net708 VSS VSS VDD VDD _0473_ _4674_ sky130_fd_sc_hd__ha_1
X_9289_ net259 net708 VSS VSS VDD VDD _0474_ _4675_ sky130_fd_sc_hd__ha_1
X_9290_ _0475_ _0476_ VSS VSS VDD VDD _0477_ _0478_ sky130_fd_sc_hd__ha_1
X_9291_ net712 _0476_ VSS VSS VDD VDD _0479_ _4676_ sky130_fd_sc_hd__ha_1
X_9292_ net712 net358 VSS VSS VDD VDD _0480_ _4677_ sky130_fd_sc_hd__ha_1
X_9293_ net709 _0481_ VSS VSS VDD VDD _0482_ _0483_ sky130_fd_sc_hd__ha_1
X_9294_ _0484_ _0485_ VSS VSS VDD VDD _0486_ alu_add_sub\[0\]
+ sky130_fd_sc_hd__ha_1
X_9295_ net234 _0485_ VSS VSS VDD VDD _0056_ _4678_ sky130_fd_sc_hd__ha_1
X_9296_ net234 net732 VSS VSS VDD VDD _0060_ _4679_ sky130_fd_sc_hd__ha_1
X_9297_ _0487_ _0481_ VSS VSS VDD VDD _0488_ _0489_ sky130_fd_sc_hd__ha_1
X_9298_ net709 net700 VSS VSS VDD VDD _0490_ _4680_ sky130_fd_sc_hd__ha_1
X_9299_ _0059_ _0055_ VSS VSS VDD VDD _0491_ _0102_ sky130_fd_sc_hd__ha_1
X_9300_ _0059_ net721 VSS VSS VDD VDD _0492_ _4681_ sky130_fd_sc_hd__ha_1
X_9301_ net245 net721 VSS VSS VDD VDD _0493_ _4682_ sky130_fd_sc_hd__ha_1
X_9302_ reg_pc\[8\] decoded_imm\[8\] VSS VSS VDD VDD _0494_
+ _0495_ sky130_fd_sc_hd__ha_1
X_9303_ reg_pc\[12\] decoded_imm\[12\] VSS VSS VDD VDD _0496_
+ _0497_ sky130_fd_sc_hd__ha_1
X_9304_ _0498_ _0499_ VSS VSS VDD VDD _0500_ _0501_ sky130_fd_sc_hd__ha_1
X_9305_ _0498_ mem_state\[1\] VSS VSS VDD VDD _0502_ _4683_
+ sky130_fd_sc_hd__ha_1
X_9306_ mem_state\[0\] _0499_ VSS VSS VDD VDD _0503_ _4684_
+ sky130_fd_sc_hd__ha_1
X_9307_ mem_state\[0\] mem_state\[1\] VSS VSS VDD VDD _0504_
+ _4685_ sky130_fd_sc_hd__ha_1
X_9308_ mem_state\[0\] mem_state\[1\] VSS VSS VDD VDD _0505_
+ _4686_ sky130_fd_sc_hd__ha_1
X_9309_ reg_pc\[20\] decoded_imm\[20\] VSS VSS VDD VDD _0506_
+ _0507_ sky130_fd_sc_hd__ha_1
X_9310_ clknet_leaf_139_clk _0529_ VSS VSS VDD VDD _0041_
+ sky130_fd_sc_hd__dfxtp_4
X_9311_ clknet_leaf_139_clk _0530_ VSS VSS VDD VDD _0042_
+ sky130_fd_sc_hd__dfxtp_4
X_9312_ clknet_leaf_139_clk _0531_ VSS VSS VDD VDD _0043_
+ sky130_fd_sc_hd__dfxtp_4
X_9313_ clknet_leaf_139_clk _0532_ VSS VSS VDD VDD _0044_
+ sky130_fd_sc_hd__dfxtp_2
X_9314_ clknet_leaf_140_clk _0533_ VSS VSS VDD VDD _0045_
+ sky130_fd_sc_hd__dfxtp_4
X_9315_ clknet_leaf_134_clk _0534_ VSS VSS VDD VDD _0046_
+ sky130_fd_sc_hd__dfxtp_4
X_9316_ clknet_leaf_134_clk _0535_ VSS VSS VDD VDD _0047_
+ sky130_fd_sc_hd__dfxtp_4
X_9317_ clknet_leaf_134_clk _0536_ VSS VSS VDD VDD _0048_
+ sky130_fd_sc_hd__dfxtp_4
X_9318_ clknet_leaf_134_clk _0537_ VSS VSS VDD VDD _0049_
+ sky130_fd_sc_hd__dfxtp_4
X_9319_ clknet_leaf_134_clk _0538_ VSS VSS VDD VDD _0050_
+ sky130_fd_sc_hd__dfxtp_2
XTAP_TAPCELL_ROW_0_0 VSS VDD sky130_fd_sc_hd__tapvpwrvgnd_1
Xoutput252 net251 VSS VSS VDD VDD mem_la_wdata[25] sky130_fd_sc_hd__clkdlybuf4s50_1
Xoutput251 net250 VSS VSS VDD VDD mem_la_wdata[24] sky130_fd_sc_hd__clkdlybuf4s50_1
Xoutput250 net249 VSS VSS VDD VDD mem_la_wdata[23] sky130_fd_sc_hd__clkdlybuf4s50_1
Xoutput249 net248 VSS VSS VDD VDD mem_la_wdata[22] sky130_fd_sc_hd__clkdlybuf4s50_1
Xoutput248 net247 VSS VSS VDD VDD mem_la_wdata[21] sky130_fd_sc_hd__clkdlybuf4s50_1
Xoutput247 net246 VSS VSS VDD VDD mem_la_wdata[20] sky130_fd_sc_hd__clkdlybuf4s50_1
Xoutput246 net245 VSS VSS VDD VDD mem_la_wdata[1] sky130_fd_sc_hd__clkdlybuf4s50_1
Xoutput245 net244 VSS VSS VDD VDD mem_la_wdata[19] sky130_fd_sc_hd__clkdlybuf4s50_1
Xoutput244 net243 VSS VSS VDD VDD mem_la_wdata[18] sky130_fd_sc_hd__clkdlybuf4s50_1
Xoutput243 net242 VSS VSS VDD VDD mem_la_wdata[17] sky130_fd_sc_hd__clkdlybuf4s50_1
Xoutput242 net241 VSS VSS VDD VDD mem_la_wdata[16] sky130_fd_sc_hd__clkdlybuf4s50_1
Xoutput241 net240 VSS VSS VDD VDD mem_la_wdata[15] sky130_fd_sc_hd__clkdlybuf4s50_1
Xoutput240 net239 VSS VSS VDD VDD mem_la_wdata[14] sky130_fd_sc_hd__clkdlybuf4s50_1
Xoutput239 net238 VSS VSS VDD VDD mem_la_wdata[13] sky130_fd_sc_hd__clkdlybuf4s50_1
Xoutput238 net237 VSS VSS VDD VDD mem_la_wdata[12] sky130_fd_sc_hd__clkdlybuf4s50_1
Xoutput237 net236 VSS VSS VDD VDD mem_la_wdata[11] sky130_fd_sc_hd__clkdlybuf4s50_1
Xoutput236 net235 VSS VSS VDD VDD mem_la_wdata[10] sky130_fd_sc_hd__clkdlybuf4s50_1
Xoutput235 net234 VSS VSS VDD VDD mem_la_wdata[0] sky130_fd_sc_hd__clkdlybuf4s50_1
Xoutput234 net233 VSS VSS VDD VDD mem_la_read sky130_fd_sc_hd__clkdlybuf4s50_1
Xoutput233 net232 VSS VSS VDD VDD mem_la_addr[9] sky130_fd_sc_hd__clkdlybuf4s50_1
Xoutput232 net231 VSS VSS VDD VDD mem_la_addr[8] sky130_fd_sc_hd__clkdlybuf4s50_1
Xoutput231 net664 VSS VSS VDD VDD mem_la_addr[7] sky130_fd_sc_hd__clkdlybuf4s50_1
Xoutput230 net229 VSS VSS VDD VDD mem_la_addr[6] sky130_fd_sc_hd__clkdlybuf4s50_1
Xoutput229 net228 VSS VSS VDD VDD mem_la_addr[5] sky130_fd_sc_hd__clkdlybuf4s50_1
Xoutput228 net227 VSS VSS VDD VDD mem_la_addr[4] sky130_fd_sc_hd__clkdlybuf4s50_1
Xoutput227 net226 VSS VSS VDD VDD mem_la_addr[3] sky130_fd_sc_hd__clkdlybuf4s50_1
Xoutput226 net225 VSS VSS VDD VDD mem_la_addr[31] sky130_fd_sc_hd__clkdlybuf4s50_1
Xoutput225 net224 VSS VSS VDD VDD mem_la_addr[30] sky130_fd_sc_hd__clkdlybuf4s50_1
Xoutput224 net223 VSS VSS VDD VDD mem_la_addr[2] sky130_fd_sc_hd__clkdlybuf4s50_1
Xoutput223 net222 VSS VSS VDD VDD mem_la_addr[29] sky130_fd_sc_hd__clkdlybuf4s50_1
Xoutput222 net221 VSS VSS VDD VDD mem_la_addr[28] sky130_fd_sc_hd__clkdlybuf4s50_1
Xoutput221 net220 VSS VSS VDD VDD mem_la_addr[27] sky130_fd_sc_hd__clkdlybuf4s50_1
Xoutput220 net219 VSS VSS VDD VDD mem_la_addr[26] sky130_fd_sc_hd__clkdlybuf4s50_1
Xoutput219 net218 VSS VSS VDD VDD mem_la_addr[25] sky130_fd_sc_hd__clkdlybuf4s50_1
Xoutput218 net217 VSS VSS VDD VDD mem_la_addr[24] sky130_fd_sc_hd__clkdlybuf4s50_1
Xoutput217 net216 VSS VSS VDD VDD mem_la_addr[23] sky130_fd_sc_hd__clkdlybuf4s50_1
Xoutput216 net215 VSS VSS VDD VDD mem_la_addr[22] sky130_fd_sc_hd__clkdlybuf4s50_1
Xoutput215 net214 VSS VSS VDD VDD mem_la_addr[21] sky130_fd_sc_hd__clkdlybuf4s50_1
Xoutput214 net213 VSS VSS VDD VDD mem_la_addr[20] sky130_fd_sc_hd__clkdlybuf4s50_1
Xoutput213 net212 VSS VSS VDD VDD mem_la_addr[19] sky130_fd_sc_hd__clkdlybuf4s50_1
Xoutput212 net211 VSS VSS VDD VDD mem_la_addr[18] sky130_fd_sc_hd__clkdlybuf4s50_1
Xoutput211 net210 VSS VSS VDD VDD mem_la_addr[17] sky130_fd_sc_hd__clkdlybuf4s50_1
Xoutput210 net209 VSS VSS VDD VDD mem_la_addr[16] sky130_fd_sc_hd__clkdlybuf4s50_1
Xoutput209 net208 VSS VSS VDD VDD mem_la_addr[15] sky130_fd_sc_hd__clkdlybuf4s50_1
Xoutput208 net207 VSS VSS VDD VDD mem_la_addr[14] sky130_fd_sc_hd__clkdlybuf4s50_1
Xoutput207 net667 VSS VSS VDD VDD mem_la_addr[13] sky130_fd_sc_hd__clkdlybuf4s50_1
Xoutput206 net666 VSS VSS VDD VDD mem_la_addr[12] sky130_fd_sc_hd__clkdlybuf4s50_1
Xoutput205 net665 VSS VSS VDD VDD mem_la_addr[11] sky130_fd_sc_hd__clkdlybuf4s50_1
Xoutput204 net203 VSS VSS VDD VDD mem_la_addr[10] sky130_fd_sc_hd__clkdlybuf4s50_1
Xoutput203 net202 VSS VSS VDD VDD mem_instr sky130_fd_sc_hd__clkdlybuf4s50_1
Xoutput202 net201 VSS VSS VDD VDD mem_addr[9] sky130_fd_sc_hd__clkdlybuf4s50_1
Xoutput201 net200 VSS VSS VDD VDD mem_addr[8] sky130_fd_sc_hd__clkdlybuf4s50_1
Xoutput200 net199 VSS VSS VDD VDD mem_addr[7] sky130_fd_sc_hd__clkdlybuf4s50_1
Xoutput199 net198 VSS VSS VDD VDD mem_addr[6] sky130_fd_sc_hd__clkdlybuf4s50_1
Xoutput198 net197 VSS VSS VDD VDD mem_addr[5] sky130_fd_sc_hd__clkdlybuf4s50_1
Xoutput197 net196 VSS VSS VDD VDD mem_addr[4] sky130_fd_sc_hd__clkdlybuf4s50_1
Xoutput196 net195 VSS VSS VDD VDD mem_addr[3] sky130_fd_sc_hd__clkdlybuf4s50_1
Xoutput195 net194 VSS VSS VDD VDD mem_addr[31] sky130_fd_sc_hd__clkdlybuf4s50_1
Xoutput194 net193 VSS VSS VDD VDD mem_addr[30] sky130_fd_sc_hd__clkdlybuf4s50_1
Xoutput193 net192 VSS VSS VDD VDD mem_addr[2] sky130_fd_sc_hd__clkdlybuf4s50_1
Xoutput192 net191 VSS VSS VDD VDD mem_addr[29] sky130_fd_sc_hd__clkdlybuf4s50_1
Xoutput191 net190 VSS VSS VDD VDD mem_addr[28] sky130_fd_sc_hd__clkdlybuf4s50_1
Xoutput190 net189 VSS VSS VDD VDD mem_addr[27] sky130_fd_sc_hd__clkdlybuf4s50_1
Xoutput189 net188 VSS VSS VDD VDD mem_addr[26] sky130_fd_sc_hd__clkdlybuf4s50_1
Xoutput188 net187 VSS VSS VDD VDD mem_addr[25] sky130_fd_sc_hd__clkdlybuf4s50_1
Xoutput187 net186 VSS VSS VDD VDD mem_addr[24] sky130_fd_sc_hd__clkdlybuf4s50_1
Xoutput186 net185 VSS VSS VDD VDD mem_addr[23] sky130_fd_sc_hd__clkdlybuf4s50_1
Xoutput185 net184 VSS VSS VDD VDD mem_addr[22] sky130_fd_sc_hd__clkdlybuf4s50_1
Xoutput184 net183 VSS VSS VDD VDD mem_addr[21] sky130_fd_sc_hd__clkdlybuf4s50_1
Xoutput183 net182 VSS VSS VDD VDD mem_addr[20] sky130_fd_sc_hd__clkdlybuf4s50_1
Xoutput182 net181 VSS VSS VDD VDD mem_addr[19] sky130_fd_sc_hd__clkdlybuf4s50_1
Xoutput181 net180 VSS VSS VDD VDD mem_addr[18] sky130_fd_sc_hd__clkdlybuf4s50_1
Xoutput180 net179 VSS VSS VDD VDD mem_addr[17] sky130_fd_sc_hd__clkdlybuf4s50_1
Xoutput179 net178 VSS VSS VDD VDD mem_addr[16] sky130_fd_sc_hd__clkdlybuf4s50_1
Xoutput178 net177 VSS VSS VDD VDD mem_addr[15] sky130_fd_sc_hd__clkdlybuf4s50_1
Xoutput177 net176 VSS VSS VDD VDD mem_addr[14] sky130_fd_sc_hd__clkdlybuf4s50_1
Xoutput176 net175 VSS VSS VDD VDD mem_addr[13] sky130_fd_sc_hd__clkdlybuf4s50_1
Xoutput175 net174 VSS VSS VDD VDD mem_addr[12] sky130_fd_sc_hd__clkdlybuf4s50_1
Xoutput174 net173 VSS VSS VDD VDD mem_addr[11] sky130_fd_sc_hd__clkdlybuf4s50_1
Xoutput173 net172 VSS VSS VDD VDD mem_addr[10] sky130_fd_sc_hd__clkdlybuf4s50_1
Xinput172 net777 VSS VSS VDD VDD net171 sky130_fd_sc_hd__buf_4
Xinput171 net784 VSS VSS VDD VDD net170 sky130_fd_sc_hd__clkdlybuf4s50_1
Xinput170 mem_rdata[9] VSS VSS VDD VDD net169 sky130_fd_sc_hd__clkdlybuf4s50_1
Xinput169 mem_rdata[8] VSS VSS VDD VDD net168 sky130_fd_sc_hd__clkdlybuf4s50_1
Xinput168 net789 VSS VSS VDD VDD net167 sky130_fd_sc_hd__clkdlybuf4s50_1
Xinput167 net783 VSS VSS VDD VDD net166 sky130_fd_sc_hd__clkdlybuf4s50_1
Xinput166 net785 VSS VSS VDD VDD net165 sky130_fd_sc_hd__clkdlybuf4s50_1
Xinput165 net779 VSS VSS VDD VDD net164 sky130_fd_sc_hd__clkdlybuf4s50_1
Xinput164 net781 VSS VSS VDD VDD net163 sky130_fd_sc_hd__clkdlybuf4s50_1
Xinput163 mem_rdata[31] VSS VSS VDD VDD net162 sky130_fd_sc_hd__clkdlybuf4s50_1
Xinput162 mem_rdata[30] VSS VSS VDD VDD net161 sky130_fd_sc_hd__clkdlybuf4s50_1
Xinput161 net782 VSS VSS VDD VDD net160 sky130_fd_sc_hd__clkdlybuf4s50_1
Xinput160 mem_rdata[29] VSS VSS VDD VDD net159 sky130_fd_sc_hd__clkdlybuf4s50_1
Xinput159 mem_rdata[28] VSS VSS VDD VDD net158 sky130_fd_sc_hd__clkdlybuf4s50_1
Xinput158 mem_rdata[27] VSS VSS VDD VDD net157 sky130_fd_sc_hd__clkdlybuf4s50_1
Xinput157 mem_rdata[26] VSS VSS VDD VDD net156 sky130_fd_sc_hd__clkdlybuf4s50_1
Xinput156 mem_rdata[25] VSS VSS VDD VDD net155 sky130_fd_sc_hd__clkdlybuf4s50_1
Xinput155 mem_rdata[24] VSS VSS VDD VDD net154 sky130_fd_sc_hd__clkdlybuf4s50_1
Xinput154 mem_rdata[23] VSS VSS VDD VDD net153 sky130_fd_sc_hd__clkdlybuf4s50_1
Xinput153 mem_rdata[22] VSS VSS VDD VDD net152 sky130_fd_sc_hd__clkdlybuf4s50_1
Xinput152 mem_rdata[21] VSS VSS VDD VDD net151 sky130_fd_sc_hd__clkdlybuf4s50_1
Xinput151 mem_rdata[20] VSS VSS VDD VDD net150 sky130_fd_sc_hd__clkdlybuf4s50_1
Xinput150 net778 VSS VSS VDD VDD net149 sky130_fd_sc_hd__clkdlybuf4s50_1
Xinput149 mem_rdata[19] VSS VSS VDD VDD net148 sky130_fd_sc_hd__clkdlybuf4s50_1
Xinput148 mem_rdata[18] VSS VSS VDD VDD net147 sky130_fd_sc_hd__clkdlybuf4s50_1
Xinput147 mem_rdata[17] VSS VSS VDD VDD net146 sky130_fd_sc_hd__clkdlybuf4s50_1
Xinput146 mem_rdata[16] VSS VSS VDD VDD net145 sky130_fd_sc_hd__clkdlybuf4s50_1
Xinput145 mem_rdata[15] VSS VSS VDD VDD net144 sky130_fd_sc_hd__clkdlybuf4s50_1
Xinput144 net786 VSS VSS VDD VDD net143 sky130_fd_sc_hd__clkdlybuf4s50_1
Xinput143 net788 VSS VSS VDD VDD net142 sky130_fd_sc_hd__clkdlybuf4s50_1
Xinput142 net787 VSS VSS VDD VDD net141 sky130_fd_sc_hd__clkdlybuf4s50_1
Xinput141 mem_rdata[11] VSS VSS VDD VDD net140 sky130_fd_sc_hd__clkdlybuf4s50_1
Xinput140 mem_rdata[10] VSS VSS VDD VDD net139 sky130_fd_sc_hd__clkdlybuf4s50_1
Xinput139 net780 VSS VSS VDD VDD net138 sky130_fd_sc_hd__clkdlybuf4s50_1
Xalu_out_q\[0\]$_DFF_P_ clknet_leaf_98_clk alu_out\[0\] VSS
+ VSS VDD VDD alu_out_q\[0\] sky130_fd_sc_hd__dfxtp_1
Xalu_out_q\[10\]$_DFF_P_ clknet_leaf_81_clk alu_out\[10\]
+ VSS VSS VDD VDD alu_out_q\[10\] sky130_fd_sc_hd__dfxtp_1
Xalu_out_q\[11\]$_DFF_P_ clknet_leaf_79_clk alu_out\[11\]
+ VSS VSS VDD VDD alu_out_q\[11\] sky130_fd_sc_hd__dfxtp_1
Xalu_out_q\[12\]$_DFF_P_ clknet_leaf_84_clk alu_out\[12\]
+ VSS VSS VDD VDD alu_out_q\[12\] sky130_fd_sc_hd__dfxtp_1
Xalu_out_q\[13\]$_DFF_P_ clknet_leaf_85_clk alu_out\[13\]
+ VSS VSS VDD VDD alu_out_q\[13\] sky130_fd_sc_hd__dfxtp_1
Xalu_out_q\[14\]$_DFF_P_ clknet_leaf_81_clk alu_out\[14\]
+ VSS VSS VDD VDD alu_out_q\[14\] sky130_fd_sc_hd__dfxtp_1
Xalu_out_q\[15\]$_DFF_P_ clknet_leaf_85_clk alu_out\[15\]
+ VSS VSS VDD VDD alu_out_q\[15\] sky130_fd_sc_hd__dfxtp_1
Xalu_out_q\[16\]$_DFF_P_ clknet_leaf_85_clk alu_out\[16\]
+ VSS VSS VDD VDD alu_out_q\[16\] sky130_fd_sc_hd__dfxtp_1
Xalu_out_q\[17\]$_DFF_P_ clknet_leaf_85_clk alu_out\[17\]
+ VSS VSS VDD VDD alu_out_q\[17\] sky130_fd_sc_hd__dfxtp_1
Xalu_out_q\[18\]$_DFF_P_ clknet_leaf_86_clk alu_out\[18\]
+ VSS VSS VDD VDD alu_out_q\[18\] sky130_fd_sc_hd__dfxtp_1
Xalu_out_q\[19\]$_DFF_P_ clknet_leaf_86_clk alu_out\[19\]
+ VSS VSS VDD VDD alu_out_q\[19\] sky130_fd_sc_hd__dfxtp_1
Xalu_out_q\[1\]$_DFF_P_ clknet_leaf_85_clk alu_out\[1\] VSS
+ VSS VDD VDD alu_out_q\[1\] sky130_fd_sc_hd__dfxtp_1
Xalu_out_q\[20\]$_DFF_P_ clknet_leaf_86_clk alu_out\[20\]
+ VSS VSS VDD VDD alu_out_q\[20\] sky130_fd_sc_hd__dfxtp_1
Xalu_out_q\[21\]$_DFF_P_ clknet_leaf_86_clk alu_out\[21\]
+ VSS VSS VDD VDD alu_out_q\[21\] sky130_fd_sc_hd__dfxtp_1
Xalu_out_q\[22\]$_DFF_P_ clknet_leaf_91_clk alu_out\[22\]
+ VSS VSS VDD VDD alu_out_q\[22\] sky130_fd_sc_hd__dfxtp_1
Xalu_out_q\[23\]$_DFF_P_ clknet_leaf_86_clk alu_out\[23\]
+ VSS VSS VDD VDD alu_out_q\[23\] sky130_fd_sc_hd__dfxtp_1
Xalu_out_q\[24\]$_DFF_P_ clknet_leaf_86_clk alu_out\[24\]
+ VSS VSS VDD VDD alu_out_q\[24\] sky130_fd_sc_hd__dfxtp_1
Xalu_out_q\[25\]$_DFF_P_ clknet_leaf_91_clk alu_out\[25\]
+ VSS VSS VDD VDD alu_out_q\[25\] sky130_fd_sc_hd__dfxtp_1
Xalu_out_q\[26\]$_DFF_P_ clknet_leaf_90_clk alu_out\[26\]
+ VSS VSS VDD VDD alu_out_q\[26\] sky130_fd_sc_hd__dfxtp_1
Xalu_out_q\[27\]$_DFF_P_ clknet_leaf_90_clk alu_out\[27\]
+ VSS VSS VDD VDD alu_out_q\[27\] sky130_fd_sc_hd__dfxtp_1
Xalu_out_q\[28\]$_DFF_P_ clknet_leaf_90_clk alu_out\[28\]
+ VSS VSS VDD VDD alu_out_q\[28\] sky130_fd_sc_hd__dfxtp_1
Xalu_out_q\[29\]$_DFF_P_ clknet_leaf_90_clk alu_out\[29\]
+ VSS VSS VDD VDD alu_out_q\[29\] sky130_fd_sc_hd__dfxtp_1
Xalu_out_q\[2\]$_DFF_P_ clknet_leaf_80_clk alu_out\[2\] VSS
+ VSS VDD VDD alu_out_q\[2\] sky130_fd_sc_hd__dfxtp_1
Xalu_out_q\[30\]$_DFF_P_ clknet_leaf_89_clk alu_out\[30\]
+ VSS VSS VDD VDD alu_out_q\[30\] sky130_fd_sc_hd__dfxtp_1
Xalu_out_q\[31\]$_DFF_P_ clknet_leaf_89_clk alu_out\[31\]
+ VSS VSS VDD VDD alu_out_q\[31\] sky130_fd_sc_hd__dfxtp_1
Xalu_out_q\[3\]$_DFF_P_ clknet_leaf_80_clk alu_out\[3\] VSS
+ VSS VDD VDD alu_out_q\[3\] sky130_fd_sc_hd__dfxtp_1
Xalu_out_q\[4\]$_DFF_P_ clknet_leaf_79_clk alu_out\[4\] VSS
+ VSS VDD VDD alu_out_q\[4\] sky130_fd_sc_hd__dfxtp_1
Xalu_out_q\[5\]$_DFF_P_ clknet_leaf_81_clk alu_out\[5\] VSS
+ VSS VDD VDD alu_out_q\[5\] sky130_fd_sc_hd__dfxtp_1
Xalu_out_q\[6\]$_DFF_P_ clknet_leaf_81_clk alu_out\[6\] VSS
+ VSS VDD VDD alu_out_q\[6\] sky130_fd_sc_hd__dfxtp_1
Xalu_out_q\[7\]$_DFF_P_ clknet_leaf_81_clk alu_out\[7\] VSS
+ VSS VDD VDD alu_out_q\[7\] sky130_fd_sc_hd__dfxtp_1
Xalu_out_q\[8\]$_DFF_P_ clknet_leaf_81_clk alu_out\[8\] VSS
+ VSS VDD VDD alu_out_q\[8\] sky130_fd_sc_hd__dfxtp_1
Xalu_out_q\[9\]$_DFF_P_ clknet_leaf_83_clk alu_out\[9\] VSS
+ VSS VDD VDD alu_out_q\[9\] sky130_fd_sc_hd__dfxtp_1
Xcount_cycle\[0\]$_SDFF_PN0_ clknet_leaf_134_clk _0724_ VSS
+ VSS VDD VDD count_cycle\[0\] sky130_fd_sc_hd__dfxtp_1
Xcount_cycle\[10\]$_SDFF_PN0_ clknet_leaf_132_clk _0714_ VSS
+ VSS VDD VDD count_cycle\[10\] sky130_fd_sc_hd__dfxtp_1
Xcount_cycle\[11\]$_SDFF_PN0_ clknet_leaf_133_clk _0713_ VSS
+ VSS VDD VDD count_cycle\[11\] sky130_fd_sc_hd__dfxtp_1
Xcount_cycle\[12\]$_SDFF_PN0_ clknet_leaf_133_clk _0712_ VSS
+ VSS VDD VDD count_cycle\[12\] sky130_fd_sc_hd__dfxtp_1
Xcount_cycle\[13\]$_SDFF_PN0_ clknet_leaf_133_clk _0711_ VSS
+ VSS VDD VDD count_cycle\[13\] sky130_fd_sc_hd__dfxtp_1
Xcount_cycle\[14\]$_SDFF_PN0_ clknet_leaf_133_clk _0710_ VSS
+ VSS VDD VDD count_cycle\[14\] sky130_fd_sc_hd__dfxtp_1
Xcount_cycle\[15\]$_SDFF_PN0_ clknet_leaf_128_clk _0709_ VSS
+ VSS VDD VDD count_cycle\[15\] sky130_fd_sc_hd__dfxtp_1
Xcount_cycle\[16\]$_SDFF_PN0_ clknet_leaf_128_clk _0708_ VSS
+ VSS VDD VDD count_cycle\[16\] sky130_fd_sc_hd__dfxtp_1
Xcount_cycle\[17\]$_SDFF_PN0_ clknet_leaf_128_clk _0707_ VSS
+ VSS VDD VDD count_cycle\[17\] sky130_fd_sc_hd__dfxtp_1
Xcount_cycle\[18\]$_SDFF_PN0_ clknet_leaf_128_clk _0706_ VSS
+ VSS VDD VDD count_cycle\[18\] sky130_fd_sc_hd__dfxtp_1
Xcount_cycle\[19\]$_SDFF_PN0_ clknet_leaf_129_clk _0705_ VSS
+ VSS VDD VDD count_cycle\[19\] sky130_fd_sc_hd__dfxtp_1
Xcount_cycle\[1\]$_SDFF_PN0_ clknet_leaf_133_clk _0723_ VSS
+ VSS VDD VDD count_cycle\[1\] sky130_fd_sc_hd__dfxtp_1
Xcount_cycle\[20\]$_SDFF_PN0_ clknet_leaf_129_clk _0704_ VSS
+ VSS VDD VDD count_cycle\[20\] sky130_fd_sc_hd__dfxtp_1
Xcount_cycle\[21\]$_SDFF_PN0_ clknet_leaf_125_clk _0703_ VSS
+ VSS VDD VDD count_cycle\[21\] sky130_fd_sc_hd__dfxtp_1
Xcount_cycle\[22\]$_SDFF_PN0_ clknet_leaf_125_clk _0702_ VSS
+ VSS VDD VDD count_cycle\[22\] sky130_fd_sc_hd__dfxtp_1
Xcount_cycle\[23\]$_SDFF_PN0_ clknet_leaf_125_clk _0701_ VSS
+ VSS VDD VDD count_cycle\[23\] sky130_fd_sc_hd__dfxtp_1
Xcount_cycle\[24\]$_SDFF_PN0_ clknet_leaf_125_clk _0700_ VSS
+ VSS VDD VDD count_cycle\[24\] sky130_fd_sc_hd__dfxtp_1
Xcount_cycle\[25\]$_SDFF_PN0_ clknet_leaf_118_clk _0699_ VSS
+ VSS VDD VDD count_cycle\[25\] sky130_fd_sc_hd__dfxtp_1
Xcount_cycle\[26\]$_SDFF_PN0_ clknet_leaf_118_clk _0698_ VSS
+ VSS VDD VDD count_cycle\[26\] sky130_fd_sc_hd__dfxtp_1
Xcount_cycle\[27\]$_SDFF_PN0_ clknet_leaf_121_clk _0697_ VSS
+ VSS VDD VDD count_cycle\[27\] sky130_fd_sc_hd__dfxtp_1
Xcount_cycle\[28\]$_SDFF_PN0_ clknet_leaf_120_clk _0696_ VSS
+ VSS VDD VDD count_cycle\[28\] sky130_fd_sc_hd__dfxtp_1
Xcount_cycle\[29\]$_SDFF_PN0_ clknet_leaf_121_clk _0695_ VSS
+ VSS VDD VDD count_cycle\[29\] sky130_fd_sc_hd__dfxtp_1
Xcount_cycle\[2\]$_SDFF_PN0_ clknet_leaf_134_clk _0722_ VSS
+ VSS VDD VDD count_cycle\[2\] sky130_fd_sc_hd__dfxtp_1
Xcount_cycle\[30\]$_SDFF_PN0_ clknet_leaf_121_clk _0694_ VSS
+ VSS VDD VDD count_cycle\[30\] sky130_fd_sc_hd__dfxtp_1
Xcount_cycle\[31\]$_SDFF_PN0_ clknet_leaf_126_clk _0693_ VSS
+ VSS VDD VDD count_cycle\[31\] sky130_fd_sc_hd__dfxtp_1
Xcount_cycle\[32\]$_SDFF_PN0_ clknet_leaf_126_clk _0692_ VSS
+ VSS VDD VDD count_cycle\[32\] sky130_fd_sc_hd__dfxtp_1
Xcount_cycle\[33\]$_SDFF_PN0_ clknet_leaf_125_clk _0691_ VSS
+ VSS VDD VDD count_cycle\[33\] sky130_fd_sc_hd__dfxtp_1
Xcount_cycle\[34\]$_SDFF_PN0_ clknet_leaf_126_clk _0690_ VSS
+ VSS VDD VDD count_cycle\[34\] sky130_fd_sc_hd__dfxtp_1
Xcount_cycle\[35\]$_SDFF_PN0_ clknet_leaf_126_clk _0689_ VSS
+ VSS VDD VDD count_cycle\[35\] sky130_fd_sc_hd__dfxtp_1
Xcount_cycle\[36\]$_SDFF_PN0_ clknet_leaf_126_clk _0688_ VSS
+ VSS VDD VDD count_cycle\[36\] sky130_fd_sc_hd__dfxtp_1
Xcount_cycle\[37\]$_SDFF_PN0_ clknet_leaf_128_clk _0687_ VSS
+ VSS VDD VDD count_cycle\[37\] sky130_fd_sc_hd__dfxtp_1
Xcount_cycle\[38\]$_SDFF_PN0_ clknet_leaf_128_clk _0686_ VSS
+ VSS VDD VDD count_cycle\[38\] sky130_fd_sc_hd__dfxtp_1
Xcount_cycle\[39\]$_SDFF_PN0_ clknet_leaf_128_clk _0685_ VSS
+ VSS VDD VDD count_cycle\[39\] sky130_fd_sc_hd__dfxtp_1
Xcount_cycle\[3\]$_SDFF_PN0_ clknet_leaf_133_clk _0721_ VSS
+ VSS VDD VDD count_cycle\[3\] sky130_fd_sc_hd__dfxtp_1
Xcount_cycle\[40\]$_SDFF_PN0_ clknet_leaf_128_clk _0684_ VSS
+ VSS VDD VDD count_cycle\[40\] sky130_fd_sc_hd__dfxtp_1
Xcount_cycle\[41\]$_SDFF_PN0_ clknet_leaf_132_clk _0683_ VSS
+ VSS VDD VDD count_cycle\[41\] sky130_fd_sc_hd__dfxtp_1
Xcount_cycle\[42\]$_SDFF_PN0_ clknet_leaf_132_clk _0682_ VSS
+ VSS VDD VDD count_cycle\[42\] sky130_fd_sc_hd__dfxtp_1
Xcount_cycle\[43\]$_SDFF_PN0_ clknet_leaf_132_clk _0681_ VSS
+ VSS VDD VDD count_cycle\[43\] sky130_fd_sc_hd__dfxtp_1
Xcount_cycle\[44\]$_SDFF_PN0_ clknet_leaf_132_clk _0680_ VSS
+ VSS VDD VDD count_cycle\[44\] sky130_fd_sc_hd__dfxtp_1
Xcount_cycle\[45\]$_SDFF_PN0_ clknet_leaf_132_clk _0679_ VSS
+ VSS VDD VDD count_cycle\[45\] sky130_fd_sc_hd__dfxtp_1
Xcount_cycle\[46\]$_SDFF_PN0_ clknet_leaf_130_clk _0678_ VSS
+ VSS VDD VDD count_cycle\[46\] sky130_fd_sc_hd__dfxtp_1
Xcount_cycle\[47\]$_SDFF_PN0_ clknet_leaf_130_clk _0677_ VSS
+ VSS VDD VDD count_cycle\[47\] sky130_fd_sc_hd__dfxtp_1
Xcount_cycle\[48\]$_SDFF_PN0_ clknet_leaf_130_clk _0676_ VSS
+ VSS VDD VDD count_cycle\[48\] sky130_fd_sc_hd__dfxtp_1
Xcount_cycle\[49\]$_SDFF_PN0_ clknet_leaf_130_clk _0675_ VSS
+ VSS VDD VDD count_cycle\[49\] sky130_fd_sc_hd__dfxtp_1
Xcount_cycle\[4\]$_SDFF_PN0_ clknet_leaf_135_clk _0720_ VSS
+ VSS VDD VDD count_cycle\[4\] sky130_fd_sc_hd__dfxtp_1
Xcount_cycle\[50\]$_SDFF_PN0_ clknet_leaf_129_clk _0674_ VSS
+ VSS VDD VDD count_cycle\[50\] sky130_fd_sc_hd__dfxtp_1
Xcount_cycle\[51\]$_SDFF_PN0_ clknet_leaf_129_clk _0673_ VSS
+ VSS VDD VDD count_cycle\[51\] sky130_fd_sc_hd__dfxtp_1
Xcount_cycle\[52\]$_SDFF_PN0_ clknet_leaf_124_clk _0672_ VSS
+ VSS VDD VDD count_cycle\[52\] sky130_fd_sc_hd__dfxtp_1
Xcount_cycle\[53\]$_SDFF_PN0_ clknet_leaf_124_clk _0671_ VSS
+ VSS VDD VDD count_cycle\[53\] sky130_fd_sc_hd__dfxtp_1
Xcount_cycle\[54\]$_SDFF_PN0_ clknet_leaf_124_clk _0670_ VSS
+ VSS VDD VDD count_cycle\[54\] sky130_fd_sc_hd__dfxtp_1
Xcount_cycle\[55\]$_SDFF_PN0_ clknet_leaf_124_clk _0669_ VSS
+ VSS VDD VDD count_cycle\[55\] sky130_fd_sc_hd__dfxtp_1
Xcount_cycle\[56\]$_SDFF_PN0_ clknet_leaf_124_clk _0668_ VSS
+ VSS VDD VDD count_cycle\[56\] sky130_fd_sc_hd__dfxtp_1
Xcount_cycle\[57\]$_SDFF_PN0_ clknet_leaf_123_clk _0667_ VSS
+ VSS VDD VDD count_cycle\[57\] sky130_fd_sc_hd__dfxtp_1
Xcount_cycle\[58\]$_SDFF_PN0_ clknet_leaf_122_clk _0666_ VSS
+ VSS VDD VDD count_cycle\[58\] sky130_fd_sc_hd__dfxtp_1
Xcount_cycle\[59\]$_SDFF_PN0_ clknet_leaf_122_clk _0665_ VSS
+ VSS VDD VDD count_cycle\[59\] sky130_fd_sc_hd__dfxtp_1
Xcount_cycle\[5\]$_SDFF_PN0_ clknet_leaf_135_clk _0719_ VSS
+ VSS VDD VDD count_cycle\[5\] sky130_fd_sc_hd__dfxtp_1
Xcount_cycle\[60\]$_SDFF_PN0_ clknet_leaf_122_clk _0664_ VSS
+ VSS VDD VDD count_cycle\[60\] sky130_fd_sc_hd__dfxtp_1
Xcount_cycle\[61\]$_SDFF_PN0_ clknet_leaf_122_clk _0663_ VSS
+ VSS VDD VDD count_cycle\[61\] sky130_fd_sc_hd__dfxtp_1
Xcount_cycle\[62\]$_SDFF_PN0_ clknet_leaf_122_clk _0662_ VSS
+ VSS VDD VDD count_cycle\[62\] sky130_fd_sc_hd__dfxtp_1
Xcount_cycle\[63\]$_SDFF_PN0_ clknet_leaf_121_clk _0791_ VSS
+ VSS VDD VDD count_cycle\[63\] sky130_fd_sc_hd__dfxtp_1
Xcount_cycle\[6\]$_SDFF_PN0_ clknet_leaf_133_clk _0718_ VSS
+ VSS VDD VDD count_cycle\[6\] sky130_fd_sc_hd__dfxtp_1
Xcount_cycle\[7\]$_SDFF_PN0_ clknet_leaf_136_clk _0717_ VSS
+ VSS VDD VDD count_cycle\[7\] sky130_fd_sc_hd__dfxtp_1
Xcount_cycle\[8\]$_SDFF_PN0_ clknet_leaf_133_clk _0716_ VSS
+ VSS VDD VDD count_cycle\[8\] sky130_fd_sc_hd__dfxtp_1
Xcount_cycle\[9\]$_SDFF_PN0_ clknet_leaf_132_clk _0715_ VSS
+ VSS VDD VDD count_cycle\[9\] sky130_fd_sc_hd__dfxtp_1
Xcount_instr\[0\]$_SDFFE_PN0P_ clknet_leaf_126_clk _0631_
+ VSS VSS VDD VDD count_instr\[0\] sky130_fd_sc_hd__dfxtp_1
Xcount_instr\[10\]$_SDFFE_PN0P_ clknet_leaf_132_clk _0621_
+ VSS VSS VDD VDD count_instr\[10\] sky130_fd_sc_hd__dfxtp_1
Xcount_instr\[11\]$_SDFFE_PN0P_ clknet_leaf_132_clk _0620_
+ VSS VSS VDD VDD count_instr\[11\] sky130_fd_sc_hd__dfxtp_1
Xcount_instr\[12\]$_SDFFE_PN0P_ clknet_leaf_131_clk _0619_
+ VSS VSS VDD VDD count_instr\[12\] sky130_fd_sc_hd__dfxtp_1
Xcount_instr\[13\]$_SDFFE_PN0P_ clknet_leaf_131_clk _0618_
+ VSS VSS VDD VDD count_instr\[13\] sky130_fd_sc_hd__dfxtp_1
Xcount_instr\[14\]$_SDFFE_PN0P_ clknet_leaf_131_clk _0617_
+ VSS VSS VDD VDD count_instr\[14\] sky130_fd_sc_hd__dfxtp_1
Xcount_instr\[15\]$_SDFFE_PN0P_ clknet_leaf_130_clk _0616_
+ VSS VSS VDD VDD count_instr\[15\] sky130_fd_sc_hd__dfxtp_1
Xcount_instr\[16\]$_SDFFE_PN0P_ clknet_leaf_130_clk _0615_
+ VSS VSS VDD VDD count_instr\[16\] sky130_fd_sc_hd__dfxtp_1
Xcount_instr\[17\]$_SDFFE_PN0P_ clknet_leaf_129_clk _0614_
+ VSS VSS VDD VDD count_instr\[17\] sky130_fd_sc_hd__dfxtp_1
Xcount_instr\[18\]$_SDFFE_PN0P_ clknet_leaf_124_clk _0613_
+ VSS VSS VDD VDD count_instr\[18\] sky130_fd_sc_hd__dfxtp_1
Xcount_instr\[19\]$_SDFFE_PN0P_ clknet_leaf_129_clk _0612_
+ VSS VSS VDD VDD count_instr\[19\] sky130_fd_sc_hd__dfxtp_1
Xcount_instr\[1\]$_SDFFE_PN0P_ clknet_leaf_126_clk _0630_
+ VSS VSS VDD VDD count_instr\[1\] sky130_fd_sc_hd__dfxtp_1
Xcount_instr\[20\]$_SDFFE_PN0P_ clknet_leaf_124_clk _0611_
+ VSS VSS VDD VDD count_instr\[20\] sky130_fd_sc_hd__dfxtp_1
Xcount_instr\[21\]$_SDFFE_PN0P_ clknet_leaf_124_clk _0610_
+ VSS VSS VDD VDD count_instr\[21\] sky130_fd_sc_hd__dfxtp_1
Xcount_instr\[22\]$_SDFFE_PN0P_ clknet_leaf_124_clk _0609_
+ VSS VSS VDD VDD count_instr\[22\] sky130_fd_sc_hd__dfxtp_1
Xcount_instr\[23\]$_SDFFE_PN0P_ clknet_leaf_125_clk _0608_
+ VSS VSS VDD VDD count_instr\[23\] sky130_fd_sc_hd__dfxtp_1
Xcount_instr\[24\]$_SDFFE_PN0P_ clknet_leaf_125_clk _0607_
+ VSS VSS VDD VDD count_instr\[24\] sky130_fd_sc_hd__dfxtp_1
Xcount_instr\[25\]$_SDFFE_PN0P_ clknet_leaf_121_clk _0606_
+ VSS VSS VDD VDD count_instr\[25\] sky130_fd_sc_hd__dfxtp_1
Xcount_instr\[26\]$_SDFFE_PN0P_ clknet_leaf_121_clk _0605_
+ VSS VSS VDD VDD count_instr\[26\] sky130_fd_sc_hd__dfxtp_1
Xcount_instr\[27\]$_SDFFE_PN0P_ clknet_leaf_122_clk _0604_
+ VSS VSS VDD VDD count_instr\[27\] sky130_fd_sc_hd__dfxtp_1
Xcount_instr\[28\]$_SDFFE_PN0P_ clknet_leaf_121_clk _0603_
+ VSS VSS VDD VDD count_instr\[28\] sky130_fd_sc_hd__dfxtp_1
Xcount_instr\[29\]$_SDFFE_PN0P_ clknet_leaf_121_clk _0602_
+ VSS VSS VDD VDD count_instr\[29\] sky130_fd_sc_hd__dfxtp_1
Xcount_instr\[2\]$_SDFFE_PN0P_ clknet_leaf_127_clk _0629_
+ VSS VSS VDD VDD count_instr\[2\] sky130_fd_sc_hd__dfxtp_1
Xcount_instr\[30\]$_SDFFE_PN0P_ clknet_leaf_123_clk _0601_
+ VSS VSS VDD VDD count_instr\[30\] sky130_fd_sc_hd__dfxtp_1
Xcount_instr\[31\]$_SDFFE_PN0P_ clknet_leaf_123_clk _0600_
+ VSS VSS VDD VDD count_instr\[31\] sky130_fd_sc_hd__dfxtp_1
Xcount_instr\[32\]$_SDFFE_PN0P_ clknet_leaf_125_clk _0599_
+ VSS VSS VDD VDD count_instr\[32\] sky130_fd_sc_hd__dfxtp_1
Xcount_instr\[33\]$_SDFFE_PN0P_ clknet_leaf_126_clk _0598_
+ VSS VSS VDD VDD count_instr\[33\] sky130_fd_sc_hd__dfxtp_1
Xcount_instr\[34\]$_SDFFE_PN0P_ clknet_leaf_127_clk _0597_
+ VSS VSS VDD VDD count_instr\[34\] sky130_fd_sc_hd__dfxtp_1
Xcount_instr\[35\]$_SDFFE_PN0P_ clknet_leaf_126_clk _0596_
+ VSS VSS VDD VDD count_instr\[35\] sky130_fd_sc_hd__dfxtp_1
Xcount_instr\[36\]$_SDFFE_PN0P_ clknet_leaf_128_clk _0595_
+ VSS VSS VDD VDD count_instr\[36\] sky130_fd_sc_hd__dfxtp_1
Xcount_instr\[37\]$_SDFFE_PN0P_ clknet_leaf_128_clk _0594_
+ VSS VSS VDD VDD count_instr\[37\] sky130_fd_sc_hd__dfxtp_1
Xcount_instr\[38\]$_SDFFE_PN0P_ clknet_leaf_130_clk _0593_
+ VSS VSS VDD VDD count_instr\[38\] sky130_fd_sc_hd__dfxtp_1
Xcount_instr\[39\]$_SDFFE_PN0P_ clknet_leaf_130_clk _0592_
+ VSS VSS VDD VDD count_instr\[39\] sky130_fd_sc_hd__dfxtp_1
Xcount_instr\[3\]$_SDFFE_PN0P_ clknet_leaf_127_clk _0628_
+ VSS VSS VDD VDD count_instr\[3\] sky130_fd_sc_hd__dfxtp_1
Xcount_instr\[40\]$_SDFFE_PN0P_ clknet_leaf_131_clk _0591_
+ VSS VSS VDD VDD count_instr\[40\] sky130_fd_sc_hd__dfxtp_1
Xcount_instr\[41\]$_SDFFE_PN0P_ clknet_leaf_133_clk _0590_
+ VSS VSS VDD VDD count_instr\[41\] sky130_fd_sc_hd__dfxtp_1
Xcount_instr\[42\]$_SDFFE_PN0P_ clknet_leaf_132_clk _0589_
+ VSS VSS VDD VDD count_instr\[42\] sky130_fd_sc_hd__dfxtp_1
Xcount_instr\[43\]$_SDFFE_PN0P_ clknet_leaf_131_clk _0588_
+ VSS VSS VDD VDD count_instr\[43\] sky130_fd_sc_hd__dfxtp_1
Xcount_instr\[44\]$_SDFFE_PN0P_ clknet_leaf_131_clk _0587_
+ VSS VSS VDD VDD count_instr\[44\] sky130_fd_sc_hd__dfxtp_1
Xcount_instr\[45\]$_SDFFE_PN0P_ clknet_leaf_131_clk _0586_
+ VSS VSS VDD VDD count_instr\[45\] sky130_fd_sc_hd__dfxtp_1
Xcount_instr\[46\]$_SDFFE_PN0P_ clknet_leaf_130_clk _0585_
+ VSS VSS VDD VDD count_instr\[46\] sky130_fd_sc_hd__dfxtp_1
Xcount_instr\[47\]$_SDFFE_PN0P_ clknet_leaf_130_clk _0584_
+ VSS VSS VDD VDD count_instr\[47\] sky130_fd_sc_hd__dfxtp_1
Xcount_instr\[48\]$_SDFFE_PN0P_ clknet_leaf_130_clk _0583_
+ VSS VSS VDD VDD count_instr\[48\] sky130_fd_sc_hd__dfxtp_1
Xcount_instr\[49\]$_SDFFE_PN0P_ clknet_leaf_129_clk _0582_
+ VSS VSS VDD VDD count_instr\[49\] sky130_fd_sc_hd__dfxtp_1
Xcount_instr\[4\]$_SDFFE_PN0P_ clknet_leaf_128_clk _0627_
+ VSS VSS VDD VDD count_instr\[4\] sky130_fd_sc_hd__dfxtp_1
Xcount_instr\[50\]$_SDFFE_PN0P_ clknet_leaf_129_clk _0581_
+ VSS VSS VDD VDD count_instr\[50\] sky130_fd_sc_hd__dfxtp_1
Xcount_instr\[51\]$_SDFFE_PN0P_ clknet_leaf_129_clk _0580_
+ VSS VSS VDD VDD count_instr\[51\] sky130_fd_sc_hd__dfxtp_1
Xcount_instr\[52\]$_SDFFE_PN0P_ clknet_leaf_129_clk _0579_
+ VSS VSS VDD VDD count_instr\[52\] sky130_fd_sc_hd__dfxtp_1
Xcount_instr\[53\]$_SDFFE_PN0P_ clknet_leaf_124_clk _0578_
+ VSS VSS VDD VDD count_instr\[53\] sky130_fd_sc_hd__dfxtp_1
Xcount_instr\[54\]$_SDFFE_PN0P_ clknet_leaf_124_clk _0577_
+ VSS VSS VDD VDD count_instr\[54\] sky130_fd_sc_hd__dfxtp_1
Xcount_instr\[55\]$_SDFFE_PN0P_ clknet_leaf_123_clk _0576_
+ VSS VSS VDD VDD count_instr\[55\] sky130_fd_sc_hd__dfxtp_1
Xcount_instr\[56\]$_SDFFE_PN0P_ clknet_leaf_123_clk _0575_
+ VSS VSS VDD VDD count_instr\[56\] sky130_fd_sc_hd__dfxtp_1
Xcount_instr\[57\]$_SDFFE_PN0P_ clknet_leaf_123_clk _0574_
+ VSS VSS VDD VDD count_instr\[57\] sky130_fd_sc_hd__dfxtp_1
Xcount_instr\[58\]$_SDFFE_PN0P_ clknet_leaf_123_clk _0573_
+ VSS VSS VDD VDD count_instr\[58\] sky130_fd_sc_hd__dfxtp_1
Xcount_instr\[59\]$_SDFFE_PN0P_ clknet_leaf_122_clk _0572_
+ VSS VSS VDD VDD count_instr\[59\] sky130_fd_sc_hd__dfxtp_1
Xcount_instr\[5\]$_SDFFE_PN0P_ clknet_leaf_136_clk _0626_
+ VSS VSS VDD VDD count_instr\[5\] sky130_fd_sc_hd__dfxtp_1
Xcount_instr\[60\]$_SDFFE_PN0P_ clknet_leaf_122_clk _0571_
+ VSS VSS VDD VDD count_instr\[60\] sky130_fd_sc_hd__dfxtp_1
Xcount_instr\[61\]$_SDFFE_PN0P_ clknet_leaf_122_clk _0570_
+ VSS VSS VDD VDD count_instr\[61\] sky130_fd_sc_hd__dfxtp_1
Xcount_instr\[62\]$_SDFFE_PN0P_ clknet_leaf_123_clk _0569_
+ VSS VSS VDD VDD count_instr\[62\] sky130_fd_sc_hd__dfxtp_1
Xcount_instr\[63\]$_SDFFE_PN0P_ clknet_leaf_123_clk _0780_
+ VSS VSS VDD VDD count_instr\[63\] sky130_fd_sc_hd__dfxtp_1
Xcount_instr\[6\]$_SDFFE_PN0P_ clknet_leaf_136_clk _0625_
+ VSS VSS VDD VDD count_instr\[6\] sky130_fd_sc_hd__dfxtp_1
Xcount_instr\[7\]$_SDFFE_PN0P_ clknet_leaf_136_clk _0624_
+ VSS VSS VDD VDD count_instr\[7\] sky130_fd_sc_hd__dfxtp_1
Xcount_instr\[8\]$_SDFFE_PN0P_ clknet_leaf_136_clk _0623_
+ VSS VSS VDD VDD count_instr\[8\] sky130_fd_sc_hd__dfxtp_1
Xcount_instr\[9\]$_SDFFE_PN0P_ clknet_leaf_131_clk _0622_
+ VSS VSS VDD VDD count_instr\[9\] sky130_fd_sc_hd__dfxtp_1
Xcpu_state\[0\]$_DFF_P_ clknet_leaf_116_clk _0511_ VSS VSS
+ VDD VDD cpu_state\[0\] sky130_fd_sc_hd__dfxtp_1
Xcpu_state\[1\]$_DFF_P_ clknet_leaf_116_clk _0512_ VSS VSS
+ VDD VDD cpu_state\[1\] sky130_fd_sc_hd__dfxtp_2
Xcpu_state\[2\]$_DFF_P_ clknet_leaf_116_clk _0513_ VSS VSS
+ VDD VDD cpu_state\[2\] sky130_fd_sc_hd__dfxtp_1
Xcpu_state\[3\]$_DFF_P_ clknet_leaf_119_clk _0514_ VSS VSS
+ VDD VDD cpu_state\[3\] sky130_fd_sc_hd__dfxtp_1
Xcpu_state\[4\]$_DFF_P_ clknet_leaf_117_clk _0515_ VSS VSS
+ VDD VDD cpu_state\[4\] sky130_fd_sc_hd__dfxtp_2
Xcpu_state\[5\]$_DFF_P_ clknet_leaf_115_clk _0516_ VSS VSS
+ VDD VDD cpu_state\[5\] sky130_fd_sc_hd__dfxtp_1
Xcpu_state\[6\]$_DFF_P_ clknet_leaf_115_clk _0517_ VSS VSS
+ VDD VDD cpu_state\[6\] sky130_fd_sc_hd__dfxtp_1
Xcpuregs\[0\]\[0\]$_DFFE_PP_ clknet_leaf_140_clk cpuregs_wrdata\[0\]
+ net106 VSS VSS VDD VDD cpuregs\[0\]\[0\] sky130_fd_sc_hd__edfxtp_1
Xcpuregs\[0\]\[10\]$_DFFE_PP_ clknet_leaf_19_clk net654 net107
+ VSS VSS VDD VDD cpuregs\[0\]\[10\] sky130_fd_sc_hd__edfxtp_1
Xcpuregs\[0\]\[11\]$_DFFE_PP_ clknet_leaf_12_clk net614 net108
+ VSS VSS VDD VDD cpuregs\[0\]\[11\] sky130_fd_sc_hd__edfxtp_1
Xcpuregs\[0\]\[12\]$_DFFE_PP_ clknet_leaf_158_clk net655 net109
+ VSS VSS VDD VDD cpuregs\[0\]\[12\] sky130_fd_sc_hd__edfxtp_1
Xcpuregs\[0\]\[13\]$_DFFE_PP_ clknet_leaf_15_clk net615 net110
+ VSS VSS VDD VDD cpuregs\[0\]\[13\] sky130_fd_sc_hd__edfxtp_1
Xcpuregs\[0\]\[14\]$_DFFE_PP_ clknet_leaf_35_clk net616 net111
+ VSS VSS VDD VDD cpuregs\[0\]\[14\] sky130_fd_sc_hd__edfxtp_1
Xcpuregs\[0\]\[15\]$_DFFE_PP_ clknet_leaf_78_clk cpuregs_wrdata\[15\]
+ net112 VSS VSS VDD VDD cpuregs\[0\]\[15\] sky130_fd_sc_hd__edfxtp_1
Xcpuregs\[0\]\[16\]$_DFFE_PP_ clknet_leaf_28_clk cpuregs_wrdata\[16\]
+ net113 VSS VSS VDD VDD cpuregs\[0\]\[16\] sky130_fd_sc_hd__edfxtp_1
Xcpuregs\[0\]\[17\]$_DFFE_PP_ clknet_leaf_23_clk cpuregs_wrdata\[17\]
+ net114 VSS VSS VDD VDD cpuregs\[0\]\[17\] sky130_fd_sc_hd__edfxtp_1
Xcpuregs\[0\]\[18\]$_DFFE_PP_ clknet_leaf_19_clk net617 net115
+ VSS VSS VDD VDD cpuregs\[0\]\[18\] sky130_fd_sc_hd__edfxtp_1
Xcpuregs\[0\]\[19\]$_DFFE_PP_ clknet_leaf_26_clk net606 net116
+ VSS VSS VDD VDD cpuregs\[0\]\[19\] sky130_fd_sc_hd__edfxtp_1
Xcpuregs\[0\]\[1\]$_DFFE_PP_ clknet_leaf_133_clk cpuregs_wrdata\[1\]
+ net117 VSS VSS VDD VDD cpuregs\[0\]\[1\] sky130_fd_sc_hd__edfxtp_1
Xcpuregs\[0\]\[20\]$_DFFE_PP_ clknet_leaf_60_clk net610 net118
+ VSS VSS VDD VDD cpuregs\[0\]\[20\] sky130_fd_sc_hd__edfxtp_1
Xcpuregs\[0\]\[21\]$_DFFE_PP_ clknet_leaf_43_clk net607 net119
+ VSS VSS VDD VDD cpuregs\[0\]\[21\] sky130_fd_sc_hd__edfxtp_1
Xcpuregs\[0\]\[22\]$_DFFE_PP_ clknet_leaf_53_clk net608 net120
+ VSS VSS VDD VDD cpuregs\[0\]\[22\] sky130_fd_sc_hd__edfxtp_1
Xcpuregs\[0\]\[23\]$_DFFE_PP_ clknet_leaf_54_clk net603 net121
+ VSS VSS VDD VDD cpuregs\[0\]\[23\] sky130_fd_sc_hd__edfxtp_1
Xcpuregs\[0\]\[24\]$_DFFE_PP_ clknet_leaf_61_clk net600 net122
+ VSS VSS VDD VDD cpuregs\[0\]\[24\] sky130_fd_sc_hd__edfxtp_1
Xcpuregs\[0\]\[25\]$_DFFE_PP_ clknet_leaf_83_clk net604 net123
+ VSS VSS VDD VDD cpuregs\[0\]\[25\] sky130_fd_sc_hd__edfxtp_1
Xcpuregs\[0\]\[26\]$_DFFE_PP_ clknet_leaf_63_clk net605 net124
+ VSS VSS VDD VDD cpuregs\[0\]\[26\] sky130_fd_sc_hd__edfxtp_1
Xcpuregs\[0\]\[27\]$_DFFE_PP_ clknet_leaf_71_clk net601 net125
+ VSS VSS VDD VDD cpuregs\[0\]\[27\] sky130_fd_sc_hd__edfxtp_1
Xcpuregs\[0\]\[28\]$_DFFE_PP_ clknet_leaf_82_clk net602 net126
+ VSS VSS VDD VDD cpuregs\[0\]\[28\] sky130_fd_sc_hd__edfxtp_1
Xcpuregs\[0\]\[29\]$_DFFE_PP_ clknet_leaf_79_clk cpuregs_wrdata\[29\]
+ net127 VSS VSS VDD VDD cpuregs\[0\]\[29\] sky130_fd_sc_hd__edfxtp_1
Xcpuregs\[0\]\[2\]$_DFFE_PP_ clknet_leaf_158_clk net672 net128
+ VSS VSS VDD VDD cpuregs\[0\]\[2\] sky130_fd_sc_hd__edfxtp_1
Xcpuregs\[0\]\[30\]$_DFFE_PP_ clknet_leaf_150_clk cpuregs_wrdata\[30\]
+ net129 VSS VSS VDD VDD cpuregs\[0\]\[30\] sky130_fd_sc_hd__edfxtp_1
Xcpuregs\[0\]\[31\]$_DFFE_PP_ clknet_leaf_142_clk net598 net130
+ VSS VSS VDD VDD cpuregs\[0\]\[31\] sky130_fd_sc_hd__edfxtp_1
Xcpuregs\[0\]\[3\]$_DFFE_PP_ clknet_leaf_152_clk net673 net131
+ VSS VSS VDD VDD cpuregs\[0\]\[3\] sky130_fd_sc_hd__edfxtp_1
Xcpuregs\[0\]\[4\]$_DFFE_PP_ clknet_leaf_151_clk net659 net132
+ VSS VSS VDD VDD cpuregs\[0\]\[4\] sky130_fd_sc_hd__edfxtp_1
Xcpuregs\[0\]\[5\]$_DFFE_PP_ clknet_leaf_35_clk net674 net133
+ VSS VSS VDD VDD cpuregs\[0\]\[5\] sky130_fd_sc_hd__edfxtp_1
Xcpuregs\[0\]\[6\]$_DFFE_PP_ clknet_leaf_46_clk cpuregs_wrdata\[6\]
+ net134 VSS VSS VDD VDD cpuregs\[0\]\[6\] sky130_fd_sc_hd__edfxtp_1
Xcpuregs\[0\]\[7\]$_DFFE_PP_ clknet_leaf_47_clk cpuregs_wrdata\[7\]
+ net135 VSS VSS VDD VDD cpuregs\[0\]\[7\] sky130_fd_sc_hd__edfxtp_1
Xcpuregs\[0\]\[8\]$_DFFE_PP_ clknet_leaf_25_clk net660 net136
+ VSS VSS VDD VDD cpuregs\[0\]\[8\] sky130_fd_sc_hd__edfxtp_1
Xcpuregs\[0\]\[9\]$_DFFE_PP_ clknet_leaf_15_clk net613 net137
+ VSS VSS VDD VDD cpuregs\[0\]\[9\] sky130_fd_sc_hd__edfxtp_1
Xcpuregs\[10\]\[0\]$_DFFE_PP_ clknet_leaf_22_clk cpuregs_wrdata\[0\]
+ net635 VSS VSS VDD VDD cpuregs\[10\]\[0\] sky130_fd_sc_hd__edfxtp_1
Xcpuregs\[10\]\[10\]$_DFFE_PP_ clknet_leaf_18_clk net654 net635
+ VSS VSS VDD VDD cpuregs\[10\]\[10\] sky130_fd_sc_hd__edfxtp_1
Xcpuregs\[10\]\[11\]$_DFFE_PP_ clknet_leaf_11_clk net614 net635
+ VSS VSS VDD VDD cpuregs\[10\]\[11\] sky130_fd_sc_hd__edfxtp_1
Xcpuregs\[10\]\[12\]$_DFFE_PP_ clknet_leaf_156_clk net655
+ net635 VSS VSS VDD VDD cpuregs\[10\]\[12\] sky130_fd_sc_hd__edfxtp_1
Xcpuregs\[10\]\[13\]$_DFFE_PP_ clknet_leaf_4_clk net615 net635
+ VSS VSS VDD VDD cpuregs\[10\]\[13\] sky130_fd_sc_hd__edfxtp_1
Xcpuregs\[10\]\[14\]$_DFFE_PP_ clknet_leaf_35_clk net616 net635
+ VSS VSS VDD VDD cpuregs\[10\]\[14\] sky130_fd_sc_hd__edfxtp_1
Xcpuregs\[10\]\[15\]$_DFFE_PP_ clknet_leaf_76_clk cpuregs_wrdata\[15\]
+ net635 VSS VSS VDD VDD cpuregs\[10\]\[15\] sky130_fd_sc_hd__edfxtp_1
Xcpuregs\[10\]\[16\]$_DFFE_PP_ clknet_leaf_33_clk cpuregs_wrdata\[16\]
+ net635 VSS VSS VDD VDD cpuregs\[10\]\[16\] sky130_fd_sc_hd__edfxtp_1
Xcpuregs\[10\]\[17\]$_DFFE_PP_ clknet_leaf_22_clk cpuregs_wrdata\[17\]
+ net635 VSS VSS VDD VDD cpuregs\[10\]\[17\] sky130_fd_sc_hd__edfxtp_1
Xcpuregs\[10\]\[18\]$_DFFE_PP_ clknet_leaf_14_clk net617 net635
+ VSS VSS VDD VDD cpuregs\[10\]\[18\] sky130_fd_sc_hd__edfxtp_1
Xcpuregs\[10\]\[19\]$_DFFE_PP_ clknet_leaf_20_clk net606 net635
+ VSS VSS VDD VDD cpuregs\[10\]\[19\] sky130_fd_sc_hd__edfxtp_1
Xcpuregs\[10\]\[1\]$_DFFE_PP_ clknet_leaf_148_clk cpuregs_wrdata\[1\]
+ net635 VSS VSS VDD VDD cpuregs\[10\]\[1\] sky130_fd_sc_hd__edfxtp_1
Xcpuregs\[10\]\[20\]$_DFFE_PP_ clknet_leaf_56_clk net610 net635
+ VSS VSS VDD VDD cpuregs\[10\]\[20\] sky130_fd_sc_hd__edfxtp_1
Xcpuregs\[10\]\[21\]$_DFFE_PP_ clknet_leaf_39_clk net607 net635
+ VSS VSS VDD VDD cpuregs\[10\]\[21\] sky130_fd_sc_hd__edfxtp_1
Xcpuregs\[10\]\[22\]$_DFFE_PP_ clknet_leaf_46_clk net608 net635
+ VSS VSS VDD VDD cpuregs\[10\]\[22\] sky130_fd_sc_hd__edfxtp_1
Xcpuregs\[10\]\[23\]$_DFFE_PP_ clknet_leaf_46_clk net603 net635
+ VSS VSS VDD VDD cpuregs\[10\]\[23\] sky130_fd_sc_hd__edfxtp_1
Xcpuregs\[10\]\[24\]$_DFFE_PP_ clknet_leaf_57_clk net600 net635
+ VSS VSS VDD VDD cpuregs\[10\]\[24\] sky130_fd_sc_hd__edfxtp_1
Xcpuregs\[10\]\[25\]$_DFFE_PP_ clknet_leaf_66_clk net604 net635
+ VSS VSS VDD VDD cpuregs\[10\]\[25\] sky130_fd_sc_hd__edfxtp_1
Xcpuregs\[10\]\[26\]$_DFFE_PP_ clknet_leaf_68_clk net605 net635
+ VSS VSS VDD VDD cpuregs\[10\]\[26\] sky130_fd_sc_hd__edfxtp_1
Xcpuregs\[10\]\[27\]$_DFFE_PP_ clknet_leaf_30_clk net601 net635
+ VSS VSS VDD VDD cpuregs\[10\]\[27\] sky130_fd_sc_hd__edfxtp_1
Xcpuregs\[10\]\[28\]$_DFFE_PP_ clknet_leaf_73_clk net602 net635
+ VSS VSS VDD VDD cpuregs\[10\]\[28\] sky130_fd_sc_hd__edfxtp_1
Xcpuregs\[10\]\[29\]$_DFFE_PP_ clknet_leaf_74_clk cpuregs_wrdata\[29\]
+ net635 VSS VSS VDD VDD cpuregs\[10\]\[29\] sky130_fd_sc_hd__edfxtp_1
Xcpuregs\[10\]\[2\]$_DFFE_PP_ clknet_leaf_1_clk net672 net635
+ VSS VSS VDD VDD cpuregs\[10\]\[2\] sky130_fd_sc_hd__edfxtp_1
Xcpuregs\[10\]\[30\]$_DFFE_PP_ clknet_leaf_147_clk cpuregs_wrdata\[30\]
+ net635 VSS VSS VDD VDD cpuregs\[10\]\[30\] sky130_fd_sc_hd__edfxtp_1
Xcpuregs\[10\]\[31\]$_DFFE_PP_ clknet_leaf_142_clk net598
+ net635 VSS VSS VDD VDD cpuregs\[10\]\[31\] sky130_fd_sc_hd__edfxtp_1
Xcpuregs\[10\]\[3\]$_DFFE_PP_ clknet_leaf_156_clk net673 net635
+ VSS VSS VDD VDD cpuregs\[10\]\[3\] sky130_fd_sc_hd__edfxtp_1
Xcpuregs\[10\]\[4\]$_DFFE_PP_ clknet_leaf_153_clk net659 net635
+ VSS VSS VDD VDD cpuregs\[10\]\[4\] sky130_fd_sc_hd__edfxtp_1
Xcpuregs\[10\]\[5\]$_DFFE_PP_ clknet_leaf_36_clk net674 net635
+ VSS VSS VDD VDD cpuregs\[10\]\[5\] sky130_fd_sc_hd__edfxtp_1
Xcpuregs\[10\]\[6\]$_DFFE_PP_ clknet_leaf_42_clk cpuregs_wrdata\[6\]
+ net635 VSS VSS VDD VDD cpuregs\[10\]\[6\] sky130_fd_sc_hd__edfxtp_1
Xcpuregs\[10\]\[7\]$_DFFE_PP_ clknet_leaf_47_clk cpuregs_wrdata\[7\]
+ net635 VSS VSS VDD VDD cpuregs\[10\]\[7\] sky130_fd_sc_hd__edfxtp_1
Xcpuregs\[10\]\[8\]$_DFFE_PP_ clknet_leaf_33_clk net660 net635
+ VSS VSS VDD VDD cpuregs\[10\]\[8\] sky130_fd_sc_hd__edfxtp_1
Xcpuregs\[10\]\[9\]$_DFFE_PP_ clknet_leaf_5_clk net613 net635
+ VSS VSS VDD VDD cpuregs\[10\]\[9\] sky130_fd_sc_hd__edfxtp_1
Xcpuregs\[11\]\[0\]$_DFFE_PP_ clknet_leaf_141_clk cpuregs_wrdata\[0\]
+ net636 VSS VSS VDD VDD cpuregs\[11\]\[0\] sky130_fd_sc_hd__edfxtp_1
Xcpuregs\[11\]\[10\]$_DFFE_PP_ clknet_leaf_17_clk net654 net636
+ VSS VSS VDD VDD cpuregs\[11\]\[10\] sky130_fd_sc_hd__edfxtp_1
Xcpuregs\[11\]\[11\]$_DFFE_PP_ clknet_leaf_8_clk net614 net636
+ VSS VSS VDD VDD cpuregs\[11\]\[11\] sky130_fd_sc_hd__edfxtp_1
Xcpuregs\[11\]\[12\]$_DFFE_PP_ clknet_leaf_156_clk net655
+ net636 VSS VSS VDD VDD cpuregs\[11\]\[12\] sky130_fd_sc_hd__edfxtp_1
Xcpuregs\[11\]\[13\]$_DFFE_PP_ clknet_leaf_3_clk net615 net636
+ VSS VSS VDD VDD cpuregs\[11\]\[13\] sky130_fd_sc_hd__edfxtp_1
Xcpuregs\[11\]\[14\]$_DFFE_PP_ clknet_leaf_35_clk net616 net636
+ VSS VSS VDD VDD cpuregs\[11\]\[14\] sky130_fd_sc_hd__edfxtp_1
Xcpuregs\[11\]\[15\]$_DFFE_PP_ clknet_leaf_76_clk cpuregs_wrdata\[15\]
+ net636 VSS VSS VDD VDD cpuregs\[11\]\[15\] sky130_fd_sc_hd__edfxtp_1
Xcpuregs\[11\]\[16\]$_DFFE_PP_ clknet_leaf_33_clk cpuregs_wrdata\[16\]
+ net636 VSS VSS VDD VDD cpuregs\[11\]\[16\] sky130_fd_sc_hd__edfxtp_1
Xcpuregs\[11\]\[17\]$_DFFE_PP_ clknet_leaf_24_clk cpuregs_wrdata\[17\]
+ net636 VSS VSS VDD VDD cpuregs\[11\]\[17\] sky130_fd_sc_hd__edfxtp_1
Xcpuregs\[11\]\[18\]$_DFFE_PP_ clknet_leaf_14_clk net617 net636
+ VSS VSS VDD VDD cpuregs\[11\]\[18\] sky130_fd_sc_hd__edfxtp_1
Xcpuregs\[11\]\[19\]$_DFFE_PP_ clknet_leaf_20_clk net606 net636
+ VSS VSS VDD VDD cpuregs\[11\]\[19\] sky130_fd_sc_hd__edfxtp_1
Xcpuregs\[11\]\[1\]$_DFFE_PP_ clknet_leaf_149_clk cpuregs_wrdata\[1\]
+ net636 VSS VSS VDD VDD cpuregs\[11\]\[1\] sky130_fd_sc_hd__edfxtp_1
Xcpuregs\[11\]\[20\]$_DFFE_PP_ clknet_leaf_57_clk net610 net636
+ VSS VSS VDD VDD cpuregs\[11\]\[20\] sky130_fd_sc_hd__edfxtp_1
Xcpuregs\[11\]\[21\]$_DFFE_PP_ clknet_leaf_43_clk net607 net636
+ VSS VSS VDD VDD cpuregs\[11\]\[21\] sky130_fd_sc_hd__edfxtp_1
Xcpuregs\[11\]\[22\]$_DFFE_PP_ clknet_leaf_46_clk net608 net636
+ VSS VSS VDD VDD cpuregs\[11\]\[22\] sky130_fd_sc_hd__edfxtp_1
Xcpuregs\[11\]\[23\]$_DFFE_PP_ clknet_leaf_56_clk net603 net636
+ VSS VSS VDD VDD cpuregs\[11\]\[23\] sky130_fd_sc_hd__edfxtp_1
Xcpuregs\[11\]\[24\]$_DFFE_PP_ clknet_leaf_58_clk net600 net636
+ VSS VSS VDD VDD cpuregs\[11\]\[24\] sky130_fd_sc_hd__edfxtp_1
Xcpuregs\[11\]\[25\]$_DFFE_PP_ clknet_leaf_66_clk net604 net636
+ VSS VSS VDD VDD cpuregs\[11\]\[25\] sky130_fd_sc_hd__edfxtp_1
Xcpuregs\[11\]\[26\]$_DFFE_PP_ clknet_leaf_65_clk net605 net636
+ VSS VSS VDD VDD cpuregs\[11\]\[26\] sky130_fd_sc_hd__edfxtp_1
Xcpuregs\[11\]\[27\]$_DFFE_PP_ clknet_leaf_30_clk net601 net636
+ VSS VSS VDD VDD cpuregs\[11\]\[27\] sky130_fd_sc_hd__edfxtp_1
Xcpuregs\[11\]\[28\]$_DFFE_PP_ clknet_leaf_67_clk net602 net636
+ VSS VSS VDD VDD cpuregs\[11\]\[28\] sky130_fd_sc_hd__edfxtp_1
Xcpuregs\[11\]\[29\]$_DFFE_PP_ clknet_leaf_74_clk cpuregs_wrdata\[29\]
+ net636 VSS VSS VDD VDD cpuregs\[11\]\[29\] sky130_fd_sc_hd__edfxtp_1
Xcpuregs\[11\]\[2\]$_DFFE_PP_ clknet_leaf_1_clk net672 net636
+ VSS VSS VDD VDD cpuregs\[11\]\[2\] sky130_fd_sc_hd__edfxtp_1
Xcpuregs\[11\]\[30\]$_DFFE_PP_ clknet_leaf_147_clk cpuregs_wrdata\[30\]
+ net636 VSS VSS VDD VDD cpuregs\[11\]\[30\] sky130_fd_sc_hd__edfxtp_1
Xcpuregs\[11\]\[31\]$_DFFE_PP_ clknet_leaf_143_clk net598
+ net636 VSS VSS VDD VDD cpuregs\[11\]\[31\] sky130_fd_sc_hd__edfxtp_1
Xcpuregs\[11\]\[3\]$_DFFE_PP_ clknet_leaf_154_clk net673 net636
+ VSS VSS VDD VDD cpuregs\[11\]\[3\] sky130_fd_sc_hd__edfxtp_1
Xcpuregs\[11\]\[4\]$_DFFE_PP_ clknet_leaf_153_clk net659 net636
+ VSS VSS VDD VDD cpuregs\[11\]\[4\] sky130_fd_sc_hd__edfxtp_1
Xcpuregs\[11\]\[5\]$_DFFE_PP_ clknet_leaf_36_clk net674 net636
+ VSS VSS VDD VDD cpuregs\[11\]\[5\] sky130_fd_sc_hd__edfxtp_1
Xcpuregs\[11\]\[6\]$_DFFE_PP_ clknet_leaf_42_clk cpuregs_wrdata\[6\]
+ net636 VSS VSS VDD VDD cpuregs\[11\]\[6\] sky130_fd_sc_hd__edfxtp_1
Xcpuregs\[11\]\[7\]$_DFFE_PP_ clknet_leaf_47_clk cpuregs_wrdata\[7\]
+ net636 VSS VSS VDD VDD cpuregs\[11\]\[7\] sky130_fd_sc_hd__edfxtp_1
Xcpuregs\[11\]\[8\]$_DFFE_PP_ clknet_leaf_33_clk net660 net636
+ VSS VSS VDD VDD cpuregs\[11\]\[8\] sky130_fd_sc_hd__edfxtp_1
Xcpuregs\[11\]\[9\]$_DFFE_PP_ clknet_leaf_3_clk net613 net636
+ VSS VSS VDD VDD cpuregs\[11\]\[9\] sky130_fd_sc_hd__edfxtp_1
Xcpuregs\[12\]\[0\]$_DFFE_PP_ clknet_leaf_23_clk cpuregs_wrdata\[0\]
+ net638 VSS VSS VDD VDD cpuregs\[12\]\[0\] sky130_fd_sc_hd__edfxtp_1
Xcpuregs\[12\]\[10\]$_DFFE_PP_ clknet_leaf_17_clk net654 net638
+ VSS VSS VDD VDD cpuregs\[12\]\[10\] sky130_fd_sc_hd__edfxtp_1
Xcpuregs\[12\]\[11\]$_DFFE_PP_ clknet_leaf_14_clk net614 net638
+ VSS VSS VDD VDD cpuregs\[12\]\[11\] sky130_fd_sc_hd__edfxtp_1
Xcpuregs\[12\]\[12\]$_DFFE_PP_ clknet_leaf_157_clk net655
+ net638 VSS VSS VDD VDD cpuregs\[12\]\[12\] sky130_fd_sc_hd__edfxtp_1
Xcpuregs\[12\]\[13\]$_DFFE_PP_ clknet_leaf_4_clk net615 net638
+ VSS VSS VDD VDD cpuregs\[12\]\[13\] sky130_fd_sc_hd__edfxtp_1
Xcpuregs\[12\]\[14\]$_DFFE_PP_ clknet_leaf_39_clk net616 net638
+ VSS VSS VDD VDD cpuregs\[12\]\[14\] sky130_fd_sc_hd__edfxtp_1
Xcpuregs\[12\]\[15\]$_DFFE_PP_ clknet_leaf_76_clk cpuregs_wrdata\[15\]
+ net638 VSS VSS VDD VDD cpuregs\[12\]\[15\] sky130_fd_sc_hd__edfxtp_1
Xcpuregs\[12\]\[16\]$_DFFE_PP_ clknet_leaf_32_clk cpuregs_wrdata\[16\]
+ net638 VSS VSS VDD VDD cpuregs\[12\]\[16\] sky130_fd_sc_hd__edfxtp_1
Xcpuregs\[12\]\[17\]$_DFFE_PP_ clknet_leaf_77_clk cpuregs_wrdata\[17\]
+ net638 VSS VSS VDD VDD cpuregs\[12\]\[17\] sky130_fd_sc_hd__edfxtp_1
Xcpuregs\[12\]\[18\]$_DFFE_PP_ clknet_leaf_15_clk net617 net638
+ VSS VSS VDD VDD cpuregs\[12\]\[18\] sky130_fd_sc_hd__edfxtp_1
Xcpuregs\[12\]\[19\]$_DFFE_PP_ clknet_leaf_21_clk net606 net638
+ VSS VSS VDD VDD cpuregs\[12\]\[19\] sky130_fd_sc_hd__edfxtp_1
Xcpuregs\[12\]\[1\]$_DFFE_PP_ clknet_leaf_149_clk cpuregs_wrdata\[1\]
+ net638 VSS VSS VDD VDD cpuregs\[12\]\[1\] sky130_fd_sc_hd__edfxtp_1
Xcpuregs\[12\]\[20\]$_DFFE_PP_ clknet_leaf_59_clk net610 net638
+ VSS VSS VDD VDD cpuregs\[12\]\[20\] sky130_fd_sc_hd__edfxtp_1
Xcpuregs\[12\]\[21\]$_DFFE_PP_ clknet_leaf_39_clk net607 net638
+ VSS VSS VDD VDD cpuregs\[12\]\[21\] sky130_fd_sc_hd__edfxtp_1
Xcpuregs\[12\]\[22\]$_DFFE_PP_ clknet_leaf_52_clk net608 net638
+ VSS VSS VDD VDD cpuregs\[12\]\[22\] sky130_fd_sc_hd__edfxtp_1
Xcpuregs\[12\]\[23\]$_DFFE_PP_ clknet_leaf_55_clk net603 net638
+ VSS VSS VDD VDD cpuregs\[12\]\[23\] sky130_fd_sc_hd__edfxtp_1
Xcpuregs\[12\]\[24\]$_DFFE_PP_ clknet_leaf_58_clk net600 net638
+ VSS VSS VDD VDD cpuregs\[12\]\[24\] sky130_fd_sc_hd__edfxtp_1
Xcpuregs\[12\]\[25\]$_DFFE_PP_ clknet_leaf_66_clk net604 net638
+ VSS VSS VDD VDD cpuregs\[12\]\[25\] sky130_fd_sc_hd__edfxtp_1
Xcpuregs\[12\]\[26\]$_DFFE_PP_ clknet_leaf_64_clk net605 net638
+ VSS VSS VDD VDD cpuregs\[12\]\[26\] sky130_fd_sc_hd__edfxtp_1
Xcpuregs\[12\]\[27\]$_DFFE_PP_ clknet_leaf_44_clk net601 net638
+ VSS VSS VDD VDD cpuregs\[12\]\[27\] sky130_fd_sc_hd__edfxtp_1
Xcpuregs\[12\]\[28\]$_DFFE_PP_ clknet_leaf_73_clk net602 net638
+ VSS VSS VDD VDD cpuregs\[12\]\[28\] sky130_fd_sc_hd__edfxtp_1
Xcpuregs\[12\]\[29\]$_DFFE_PP_ clknet_leaf_75_clk cpuregs_wrdata\[29\]
+ net638 VSS VSS VDD VDD cpuregs\[12\]\[29\] sky130_fd_sc_hd__edfxtp_1
Xcpuregs\[12\]\[2\]$_DFFE_PP_ clknet_leaf_0_clk net672 net638
+ VSS VSS VDD VDD cpuregs\[12\]\[2\] sky130_fd_sc_hd__edfxtp_1
Xcpuregs\[12\]\[30\]$_DFFE_PP_ clknet_leaf_151_clk cpuregs_wrdata\[30\]
+ net638 VSS VSS VDD VDD cpuregs\[12\]\[30\] sky130_fd_sc_hd__edfxtp_1
Xcpuregs\[12\]\[31\]$_DFFE_PP_ clknet_leaf_143_clk net598
+ net638 VSS VSS VDD VDD cpuregs\[12\]\[31\] sky130_fd_sc_hd__edfxtp_1
Xcpuregs\[12\]\[3\]$_DFFE_PP_ clknet_leaf_152_clk net673 net638
+ VSS VSS VDD VDD cpuregs\[12\]\[3\] sky130_fd_sc_hd__edfxtp_1
Xcpuregs\[12\]\[4\]$_DFFE_PP_ clknet_leaf_153_clk net659 net638
+ VSS VSS VDD VDD cpuregs\[12\]\[4\] sky130_fd_sc_hd__edfxtp_1
Xcpuregs\[12\]\[5\]$_DFFE_PP_ clknet_leaf_10_clk net674 net638
+ VSS VSS VDD VDD cpuregs\[12\]\[5\] sky130_fd_sc_hd__edfxtp_1
Xcpuregs\[12\]\[6\]$_DFFE_PP_ clknet_leaf_42_clk cpuregs_wrdata\[6\]
+ net638 VSS VSS VDD VDD cpuregs\[12\]\[6\] sky130_fd_sc_hd__edfxtp_1
Xcpuregs\[12\]\[7\]$_DFFE_PP_ clknet_leaf_50_clk cpuregs_wrdata\[7\]
+ net638 VSS VSS VDD VDD cpuregs\[12\]\[7\] sky130_fd_sc_hd__edfxtp_1
Xcpuregs\[12\]\[8\]$_DFFE_PP_ clknet_leaf_27_clk net660 net638
+ VSS VSS VDD VDD cpuregs\[12\]\[8\] sky130_fd_sc_hd__edfxtp_1
Xcpuregs\[12\]\[9\]$_DFFE_PP_ clknet_leaf_5_clk net613 net638
+ VSS VSS VDD VDD cpuregs\[12\]\[9\] sky130_fd_sc_hd__edfxtp_1
Xcpuregs\[13\]\[0\]$_DFFE_PP_ clknet_leaf_23_clk cpuregs_wrdata\[0\]
+ net640 VSS VSS VDD VDD cpuregs\[13\]\[0\] sky130_fd_sc_hd__edfxtp_1
Xcpuregs\[13\]\[10\]$_DFFE_PP_ clknet_leaf_17_clk net654 net640
+ VSS VSS VDD VDD cpuregs\[13\]\[10\] sky130_fd_sc_hd__edfxtp_1
Xcpuregs\[13\]\[11\]$_DFFE_PP_ clknet_leaf_11_clk net614 net640
+ VSS VSS VDD VDD cpuregs\[13\]\[11\] sky130_fd_sc_hd__edfxtp_1
Xcpuregs\[13\]\[12\]$_DFFE_PP_ clknet_leaf_157_clk net655
+ net640 VSS VSS VDD VDD cpuregs\[13\]\[12\] sky130_fd_sc_hd__edfxtp_1
Xcpuregs\[13\]\[13\]$_DFFE_PP_ clknet_leaf_7_clk net615 net640
+ VSS VSS VDD VDD cpuregs\[13\]\[13\] sky130_fd_sc_hd__edfxtp_1
Xcpuregs\[13\]\[14\]$_DFFE_PP_ clknet_leaf_39_clk net616 net640
+ VSS VSS VDD VDD cpuregs\[13\]\[14\] sky130_fd_sc_hd__edfxtp_1
Xcpuregs\[13\]\[15\]$_DFFE_PP_ clknet_leaf_75_clk cpuregs_wrdata\[15\]
+ net640 VSS VSS VDD VDD cpuregs\[13\]\[15\] sky130_fd_sc_hd__edfxtp_1
Xcpuregs\[13\]\[16\]$_DFFE_PP_ clknet_leaf_32_clk cpuregs_wrdata\[16\]
+ net640 VSS VSS VDD VDD cpuregs\[13\]\[16\] sky130_fd_sc_hd__edfxtp_1
Xcpuregs\[13\]\[17\]$_DFFE_PP_ clknet_leaf_24_clk cpuregs_wrdata\[17\]
+ net640 VSS VSS VDD VDD cpuregs\[13\]\[17\] sky130_fd_sc_hd__edfxtp_1
Xcpuregs\[13\]\[18\]$_DFFE_PP_ clknet_leaf_15_clk net617 net640
+ VSS VSS VDD VDD cpuregs\[13\]\[18\] sky130_fd_sc_hd__edfxtp_1
Xcpuregs\[13\]\[19\]$_DFFE_PP_ clknet_leaf_21_clk net606 net640
+ VSS VSS VDD VDD cpuregs\[13\]\[19\] sky130_fd_sc_hd__edfxtp_1
Xcpuregs\[13\]\[1\]$_DFFE_PP_ clknet_leaf_149_clk cpuregs_wrdata\[1\]
+ net640 VSS VSS VDD VDD cpuregs\[13\]\[1\] sky130_fd_sc_hd__edfxtp_1
Xcpuregs\[13\]\[20\]$_DFFE_PP_ clknet_leaf_58_clk net610 net640
+ VSS VSS VDD VDD cpuregs\[13\]\[20\] sky130_fd_sc_hd__edfxtp_1
Xcpuregs\[13\]\[21\]$_DFFE_PP_ clknet_leaf_39_clk net607 net640
+ VSS VSS VDD VDD cpuregs\[13\]\[21\] sky130_fd_sc_hd__edfxtp_1
Xcpuregs\[13\]\[22\]$_DFFE_PP_ clknet_leaf_52_clk net608 net640
+ VSS VSS VDD VDD cpuregs\[13\]\[22\] sky130_fd_sc_hd__edfxtp_1
Xcpuregs\[13\]\[23\]$_DFFE_PP_ clknet_leaf_55_clk net603 net640
+ VSS VSS VDD VDD cpuregs\[13\]\[23\] sky130_fd_sc_hd__edfxtp_1
Xcpuregs\[13\]\[24\]$_DFFE_PP_ clknet_leaf_59_clk net600 net640
+ VSS VSS VDD VDD cpuregs\[13\]\[24\] sky130_fd_sc_hd__edfxtp_1
Xcpuregs\[13\]\[25\]$_DFFE_PP_ clknet_leaf_65_clk net604 net640
+ VSS VSS VDD VDD cpuregs\[13\]\[25\] sky130_fd_sc_hd__edfxtp_1
Xcpuregs\[13\]\[26\]$_DFFE_PP_ clknet_leaf_64_clk net605 net640
+ VSS VSS VDD VDD cpuregs\[13\]\[26\] sky130_fd_sc_hd__edfxtp_1
Xcpuregs\[13\]\[27\]$_DFFE_PP_ clknet_leaf_43_clk net601 net640
+ VSS VSS VDD VDD cpuregs\[13\]\[27\] sky130_fd_sc_hd__edfxtp_1
Xcpuregs\[13\]\[28\]$_DFFE_PP_ clknet_leaf_67_clk net602 net640
+ VSS VSS VDD VDD cpuregs\[13\]\[28\] sky130_fd_sc_hd__edfxtp_1
Xcpuregs\[13\]\[29\]$_DFFE_PP_ clknet_leaf_72_clk cpuregs_wrdata\[29\]
+ net640 VSS VSS VDD VDD cpuregs\[13\]\[29\] sky130_fd_sc_hd__edfxtp_1
Xcpuregs\[13\]\[2\]$_DFFE_PP_ clknet_leaf_0_clk net672 net640
+ VSS VSS VDD VDD cpuregs\[13\]\[2\] sky130_fd_sc_hd__edfxtp_1
Xcpuregs\[13\]\[30\]$_DFFE_PP_ clknet_leaf_153_clk cpuregs_wrdata\[30\]
+ net640 VSS VSS VDD VDD cpuregs\[13\]\[30\] sky130_fd_sc_hd__edfxtp_1
Xcpuregs\[13\]\[31\]$_DFFE_PP_ clknet_leaf_143_clk net598
+ net640 VSS VSS VDD VDD cpuregs\[13\]\[31\] sky130_fd_sc_hd__edfxtp_1
Xcpuregs\[13\]\[3\]$_DFFE_PP_ clknet_leaf_154_clk net673 net640
+ VSS VSS VDD VDD cpuregs\[13\]\[3\] sky130_fd_sc_hd__edfxtp_1
Xcpuregs\[13\]\[4\]$_DFFE_PP_ clknet_leaf_153_clk net659 net640
+ VSS VSS VDD VDD cpuregs\[13\]\[4\] sky130_fd_sc_hd__edfxtp_1
Xcpuregs\[13\]\[5\]$_DFFE_PP_ clknet_leaf_10_clk net674 net640
+ VSS VSS VDD VDD cpuregs\[13\]\[5\] sky130_fd_sc_hd__edfxtp_1
Xcpuregs\[13\]\[6\]$_DFFE_PP_ clknet_leaf_48_clk cpuregs_wrdata\[6\]
+ net640 VSS VSS VDD VDD cpuregs\[13\]\[6\] sky130_fd_sc_hd__edfxtp_1
Xcpuregs\[13\]\[7\]$_DFFE_PP_ clknet_leaf_48_clk cpuregs_wrdata\[7\]
+ net640 VSS VSS VDD VDD cpuregs\[13\]\[7\] sky130_fd_sc_hd__edfxtp_1
Xcpuregs\[13\]\[8\]$_DFFE_PP_ clknet_leaf_33_clk net660 net640
+ VSS VSS VDD VDD cpuregs\[13\]\[8\] sky130_fd_sc_hd__edfxtp_1
Xcpuregs\[13\]\[9\]$_DFFE_PP_ clknet_leaf_5_clk net613 net640
+ VSS VSS VDD VDD cpuregs\[13\]\[9\] sky130_fd_sc_hd__edfxtp_1
Xcpuregs\[14\]\[0\]$_DFFE_PP_ clknet_leaf_22_clk cpuregs_wrdata\[0\]
+ net641 VSS VSS VDD VDD cpuregs\[14\]\[0\] sky130_fd_sc_hd__edfxtp_1
Xcpuregs\[14\]\[10\]$_DFFE_PP_ clknet_leaf_17_clk net654 net641
+ VSS VSS VDD VDD cpuregs\[14\]\[10\] sky130_fd_sc_hd__edfxtp_1
Xcpuregs\[14\]\[11\]$_DFFE_PP_ clknet_leaf_8_clk net614 net641
+ VSS VSS VDD VDD cpuregs\[14\]\[11\] sky130_fd_sc_hd__edfxtp_1
Xcpuregs\[14\]\[12\]$_DFFE_PP_ clknet_leaf_156_clk net655
+ net641 VSS VSS VDD VDD cpuregs\[14\]\[12\] sky130_fd_sc_hd__edfxtp_1
Xcpuregs\[14\]\[13\]$_DFFE_PP_ clknet_leaf_4_clk net615 net641
+ VSS VSS VDD VDD cpuregs\[14\]\[13\] sky130_fd_sc_hd__edfxtp_1
Xcpuregs\[14\]\[14\]$_DFFE_PP_ clknet_leaf_35_clk net616 net641
+ VSS VSS VDD VDD cpuregs\[14\]\[14\] sky130_fd_sc_hd__edfxtp_1
Xcpuregs\[14\]\[15\]$_DFFE_PP_ clknet_leaf_76_clk cpuregs_wrdata\[15\]
+ net641 VSS VSS VDD VDD cpuregs\[14\]\[15\] sky130_fd_sc_hd__edfxtp_1
Xcpuregs\[14\]\[16\]$_DFFE_PP_ clknet_leaf_32_clk cpuregs_wrdata\[16\]
+ net641 VSS VSS VDD VDD cpuregs\[14\]\[16\] sky130_fd_sc_hd__edfxtp_1
Xcpuregs\[14\]\[17\]$_DFFE_PP_ clknet_leaf_25_clk cpuregs_wrdata\[17\]
+ net641 VSS VSS VDD VDD cpuregs\[14\]\[17\] sky130_fd_sc_hd__edfxtp_1
Xcpuregs\[14\]\[18\]$_DFFE_PP_ clknet_leaf_15_clk net617 net641
+ VSS VSS VDD VDD cpuregs\[14\]\[18\] sky130_fd_sc_hd__edfxtp_1
Xcpuregs\[14\]\[19\]$_DFFE_PP_ clknet_leaf_19_clk net606 net641
+ VSS VSS VDD VDD cpuregs\[14\]\[19\] sky130_fd_sc_hd__edfxtp_1
Xcpuregs\[14\]\[1\]$_DFFE_PP_ clknet_leaf_149_clk cpuregs_wrdata\[1\]
+ net641 VSS VSS VDD VDD cpuregs\[14\]\[1\] sky130_fd_sc_hd__edfxtp_1
Xcpuregs\[14\]\[20\]$_DFFE_PP_ clknet_leaf_56_clk net610 net641
+ VSS VSS VDD VDD cpuregs\[14\]\[20\] sky130_fd_sc_hd__edfxtp_1
Xcpuregs\[14\]\[21\]$_DFFE_PP_ clknet_leaf_40_clk net607 net641
+ VSS VSS VDD VDD cpuregs\[14\]\[21\] sky130_fd_sc_hd__edfxtp_1
Xcpuregs\[14\]\[22\]$_DFFE_PP_ clknet_leaf_51_clk net608 net641
+ VSS VSS VDD VDD cpuregs\[14\]\[22\] sky130_fd_sc_hd__edfxtp_1
Xcpuregs\[14\]\[23\]$_DFFE_PP_ clknet_leaf_55_clk net603 net641
+ VSS VSS VDD VDD cpuregs\[14\]\[23\] sky130_fd_sc_hd__edfxtp_1
Xcpuregs\[14\]\[24\]$_DFFE_PP_ clknet_leaf_59_clk net600 net641
+ VSS VSS VDD VDD cpuregs\[14\]\[24\] sky130_fd_sc_hd__edfxtp_1
Xcpuregs\[14\]\[25\]$_DFFE_PP_ clknet_leaf_65_clk net604 net641
+ VSS VSS VDD VDD cpuregs\[14\]\[25\] sky130_fd_sc_hd__edfxtp_1
Xcpuregs\[14\]\[26\]$_DFFE_PP_ clknet_leaf_65_clk net605 net641
+ VSS VSS VDD VDD cpuregs\[14\]\[26\] sky130_fd_sc_hd__edfxtp_1
Xcpuregs\[14\]\[27\]$_DFFE_PP_ clknet_leaf_43_clk net601 net641
+ VSS VSS VDD VDD cpuregs\[14\]\[27\] sky130_fd_sc_hd__edfxtp_1
Xcpuregs\[14\]\[28\]$_DFFE_PP_ clknet_leaf_73_clk net602 net641
+ VSS VSS VDD VDD cpuregs\[14\]\[28\] sky130_fd_sc_hd__edfxtp_1
Xcpuregs\[14\]\[29\]$_DFFE_PP_ clknet_leaf_75_clk cpuregs_wrdata\[29\]
+ net641 VSS VSS VDD VDD cpuregs\[14\]\[29\] sky130_fd_sc_hd__edfxtp_1
Xcpuregs\[14\]\[2\]$_DFFE_PP_ clknet_leaf_0_clk net672 net641
+ VSS VSS VDD VDD cpuregs\[14\]\[2\] sky130_fd_sc_hd__edfxtp_1
Xcpuregs\[14\]\[30\]$_DFFE_PP_ clknet_leaf_153_clk cpuregs_wrdata\[30\]
+ net641 VSS VSS VDD VDD cpuregs\[14\]\[30\] sky130_fd_sc_hd__edfxtp_1
Xcpuregs\[14\]\[31\]$_DFFE_PP_ clknet_leaf_143_clk net598
+ net641 VSS VSS VDD VDD cpuregs\[14\]\[31\] sky130_fd_sc_hd__edfxtp_1
Xcpuregs\[14\]\[3\]$_DFFE_PP_ clknet_leaf_152_clk net673 net641
+ VSS VSS VDD VDD cpuregs\[14\]\[3\] sky130_fd_sc_hd__edfxtp_1
Xcpuregs\[14\]\[4\]$_DFFE_PP_ clknet_leaf_153_clk net659 net641
+ VSS VSS VDD VDD cpuregs\[14\]\[4\] sky130_fd_sc_hd__edfxtp_1
Xcpuregs\[14\]\[5\]$_DFFE_PP_ clknet_leaf_10_clk net674 net641
+ VSS VSS VDD VDD cpuregs\[14\]\[5\] sky130_fd_sc_hd__edfxtp_1
Xcpuregs\[14\]\[6\]$_DFFE_PP_ clknet_leaf_41_clk cpuregs_wrdata\[6\]
+ net641 VSS VSS VDD VDD cpuregs\[14\]\[6\] sky130_fd_sc_hd__edfxtp_1
Xcpuregs\[14\]\[7\]$_DFFE_PP_ clknet_leaf_50_clk cpuregs_wrdata\[7\]
+ net641 VSS VSS VDD VDD cpuregs\[14\]\[7\] sky130_fd_sc_hd__edfxtp_1
Xcpuregs\[14\]\[8\]$_DFFE_PP_ clknet_leaf_34_clk net660 net641
+ VSS VSS VDD VDD cpuregs\[14\]\[8\] sky130_fd_sc_hd__edfxtp_1
Xcpuregs\[14\]\[9\]$_DFFE_PP_ clknet_leaf_5_clk net613 net641
+ VSS VSS VDD VDD cpuregs\[14\]\[9\] sky130_fd_sc_hd__edfxtp_1
Xcpuregs\[15\]\[0\]$_DFFE_PP_ clknet_leaf_22_clk cpuregs_wrdata\[0\]
+ net643 VSS VSS VDD VDD cpuregs\[15\]\[0\] sky130_fd_sc_hd__edfxtp_1
Xcpuregs\[15\]\[10\]$_DFFE_PP_ clknet_leaf_17_clk net654 net643
+ VSS VSS VDD VDD cpuregs\[15\]\[10\] sky130_fd_sc_hd__edfxtp_1
Xcpuregs\[15\]\[11\]$_DFFE_PP_ clknet_leaf_11_clk net614 net643
+ VSS VSS VDD VDD cpuregs\[15\]\[11\] sky130_fd_sc_hd__edfxtp_1
Xcpuregs\[15\]\[12\]$_DFFE_PP_ clknet_leaf_156_clk net655
+ net643 VSS VSS VDD VDD cpuregs\[15\]\[12\] sky130_fd_sc_hd__edfxtp_1
Xcpuregs\[15\]\[13\]$_DFFE_PP_ clknet_leaf_7_clk net615 net643
+ VSS VSS VDD VDD cpuregs\[15\]\[13\] sky130_fd_sc_hd__edfxtp_1
Xcpuregs\[15\]\[14\]$_DFFE_PP_ clknet_leaf_35_clk net616 net643
+ VSS VSS VDD VDD cpuregs\[15\]\[14\] sky130_fd_sc_hd__edfxtp_1
Xcpuregs\[15\]\[15\]$_DFFE_PP_ clknet_leaf_75_clk cpuregs_wrdata\[15\]
+ net643 VSS VSS VDD VDD cpuregs\[15\]\[15\] sky130_fd_sc_hd__edfxtp_1
Xcpuregs\[15\]\[16\]$_DFFE_PP_ clknet_leaf_32_clk cpuregs_wrdata\[16\]
+ net643 VSS VSS VDD VDD cpuregs\[15\]\[16\] sky130_fd_sc_hd__edfxtp_1
Xcpuregs\[15\]\[17\]$_DFFE_PP_ clknet_leaf_24_clk cpuregs_wrdata\[17\]
+ net643 VSS VSS VDD VDD cpuregs\[15\]\[17\] sky130_fd_sc_hd__edfxtp_1
Xcpuregs\[15\]\[18\]$_DFFE_PP_ clknet_leaf_14_clk net617 net643
+ VSS VSS VDD VDD cpuregs\[15\]\[18\] sky130_fd_sc_hd__edfxtp_1
Xcpuregs\[15\]\[19\]$_DFFE_PP_ clknet_leaf_21_clk net606 net643
+ VSS VSS VDD VDD cpuregs\[15\]\[19\] sky130_fd_sc_hd__edfxtp_1
Xcpuregs\[15\]\[1\]$_DFFE_PP_ clknet_leaf_149_clk cpuregs_wrdata\[1\]
+ net643 VSS VSS VDD VDD cpuregs\[15\]\[1\] sky130_fd_sc_hd__edfxtp_1
Xcpuregs\[15\]\[20\]$_DFFE_PP_ clknet_leaf_55_clk net610 net643
+ VSS VSS VDD VDD cpuregs\[15\]\[20\] sky130_fd_sc_hd__edfxtp_1
Xcpuregs\[15\]\[21\]$_DFFE_PP_ clknet_leaf_40_clk net607 net643
+ VSS VSS VDD VDD cpuregs\[15\]\[21\] sky130_fd_sc_hd__edfxtp_1
Xcpuregs\[15\]\[22\]$_DFFE_PP_ clknet_leaf_52_clk net608 net643
+ VSS VSS VDD VDD cpuregs\[15\]\[22\] sky130_fd_sc_hd__edfxtp_1
Xcpuregs\[15\]\[23\]$_DFFE_PP_ clknet_leaf_55_clk net603 net643
+ VSS VSS VDD VDD cpuregs\[15\]\[23\] sky130_fd_sc_hd__edfxtp_1
Xcpuregs\[15\]\[24\]$_DFFE_PP_ clknet_leaf_58_clk net600 net643
+ VSS VSS VDD VDD cpuregs\[15\]\[24\] sky130_fd_sc_hd__edfxtp_1
Xcpuregs\[15\]\[25\]$_DFFE_PP_ clknet_leaf_65_clk net604 net643
+ VSS VSS VDD VDD cpuregs\[15\]\[25\] sky130_fd_sc_hd__edfxtp_1
Xcpuregs\[15\]\[26\]$_DFFE_PP_ clknet_leaf_64_clk net605 net643
+ VSS VSS VDD VDD cpuregs\[15\]\[26\] sky130_fd_sc_hd__edfxtp_1
Xcpuregs\[15\]\[27\]$_DFFE_PP_ clknet_leaf_43_clk net601 net643
+ VSS VSS VDD VDD cpuregs\[15\]\[27\] sky130_fd_sc_hd__edfxtp_1
Xcpuregs\[15\]\[28\]$_DFFE_PP_ clknet_leaf_67_clk net602 net643
+ VSS VSS VDD VDD cpuregs\[15\]\[28\] sky130_fd_sc_hd__edfxtp_1
Xcpuregs\[15\]\[29\]$_DFFE_PP_ clknet_leaf_72_clk cpuregs_wrdata\[29\]
+ net643 VSS VSS VDD VDD cpuregs\[15\]\[29\] sky130_fd_sc_hd__edfxtp_1
Xcpuregs\[15\]\[2\]$_DFFE_PP_ clknet_leaf_159_clk net672 net643
+ VSS VSS VDD VDD cpuregs\[15\]\[2\] sky130_fd_sc_hd__edfxtp_1
Xcpuregs\[15\]\[30\]$_DFFE_PP_ clknet_leaf_153_clk cpuregs_wrdata\[30\]
+ net643 VSS VSS VDD VDD cpuregs\[15\]\[30\] sky130_fd_sc_hd__edfxtp_1
Xcpuregs\[15\]\[31\]$_DFFE_PP_ clknet_leaf_143_clk net598
+ net643 VSS VSS VDD VDD cpuregs\[15\]\[31\] sky130_fd_sc_hd__edfxtp_1
Xcpuregs\[15\]\[3\]$_DFFE_PP_ clknet_leaf_156_clk net673 net643
+ VSS VSS VDD VDD cpuregs\[15\]\[3\] sky130_fd_sc_hd__edfxtp_1
Xcpuregs\[15\]\[4\]$_DFFE_PP_ clknet_leaf_153_clk net659 net643
+ VSS VSS VDD VDD cpuregs\[15\]\[4\] sky130_fd_sc_hd__edfxtp_1
Xcpuregs\[15\]\[5\]$_DFFE_PP_ clknet_leaf_10_clk net674 net643
+ VSS VSS VDD VDD cpuregs\[15\]\[5\] sky130_fd_sc_hd__edfxtp_1
Xcpuregs\[15\]\[6\]$_DFFE_PP_ clknet_leaf_48_clk cpuregs_wrdata\[6\]
+ net643 VSS VSS VDD VDD cpuregs\[15\]\[6\] sky130_fd_sc_hd__edfxtp_1
Xcpuregs\[15\]\[7\]$_DFFE_PP_ clknet_leaf_48_clk cpuregs_wrdata\[7\]
+ net643 VSS VSS VDD VDD cpuregs\[15\]\[7\] sky130_fd_sc_hd__edfxtp_1
Xcpuregs\[15\]\[8\]$_DFFE_PP_ clknet_leaf_13_clk net660 net643
+ VSS VSS VDD VDD cpuregs\[15\]\[8\] sky130_fd_sc_hd__edfxtp_1
Xcpuregs\[15\]\[9\]$_DFFE_PP_ clknet_leaf_5_clk net613 net643
+ VSS VSS VDD VDD cpuregs\[15\]\[9\] sky130_fd_sc_hd__edfxtp_1
Xcpuregs\[16\]\[0\]$_DFFE_PP_ clknet_leaf_22_clk cpuregs_wrdata\[0\]
+ net646 VSS VSS VDD VDD cpuregs\[16\]\[0\] sky130_fd_sc_hd__edfxtp_1
Xcpuregs\[16\]\[10\]$_DFFE_PP_ clknet_leaf_19_clk net654 net646
+ VSS VSS VDD VDD cpuregs\[16\]\[10\] sky130_fd_sc_hd__edfxtp_1
Xcpuregs\[16\]\[11\]$_DFFE_PP_ clknet_leaf_8_clk net614 _0839_
+ VSS VSS VDD VDD cpuregs\[16\]\[11\] sky130_fd_sc_hd__edfxtp_1
Xcpuregs\[16\]\[12\]$_DFFE_PP_ clknet_leaf_2_clk net655 _0839_
+ VSS VSS VDD VDD cpuregs\[16\]\[12\] sky130_fd_sc_hd__edfxtp_1
Xcpuregs\[16\]\[13\]$_DFFE_PP_ clknet_leaf_8_clk net615 _0839_
+ VSS VSS VDD VDD cpuregs\[16\]\[13\] sky130_fd_sc_hd__edfxtp_1
Xcpuregs\[16\]\[14\]$_DFFE_PP_ clknet_leaf_39_clk net616 net646
+ VSS VSS VDD VDD cpuregs\[16\]\[14\] sky130_fd_sc_hd__edfxtp_1
Xcpuregs\[16\]\[15\]$_DFFE_PP_ clknet_leaf_72_clk cpuregs_wrdata\[15\]
+ net646 VSS VSS VDD VDD cpuregs\[16\]\[15\] sky130_fd_sc_hd__edfxtp_1
Xcpuregs\[16\]\[16\]$_DFFE_PP_ clknet_leaf_71_clk cpuregs_wrdata\[16\]
+ net646 VSS VSS VDD VDD cpuregs\[16\]\[16\] sky130_fd_sc_hd__edfxtp_1
Xcpuregs\[16\]\[17\]$_DFFE_PP_ clknet_leaf_76_clk cpuregs_wrdata\[17\]
+ net646 VSS VSS VDD VDD cpuregs\[16\]\[17\] sky130_fd_sc_hd__edfxtp_1
Xcpuregs\[16\]\[18\]$_DFFE_PP_ clknet_leaf_13_clk net617 net646
+ VSS VSS VDD VDD cpuregs\[16\]\[18\] sky130_fd_sc_hd__edfxtp_1
Xcpuregs\[16\]\[19\]$_DFFE_PP_ clknet_leaf_26_clk net606 net646
+ VSS VSS VDD VDD cpuregs\[16\]\[19\] sky130_fd_sc_hd__edfxtp_1
Xcpuregs\[16\]\[1\]$_DFFE_PP_ clknet_leaf_148_clk cpuregs_wrdata\[1\]
+ _0839_ VSS VSS VDD VDD cpuregs\[16\]\[1\] sky130_fd_sc_hd__edfxtp_1
Xcpuregs\[16\]\[20\]$_DFFE_PP_ clknet_leaf_59_clk net610 net646
+ VSS VSS VDD VDD cpuregs\[16\]\[20\] sky130_fd_sc_hd__edfxtp_1
Xcpuregs\[16\]\[21\]$_DFFE_PP_ clknet_leaf_42_clk net607 net646
+ VSS VSS VDD VDD cpuregs\[16\]\[21\] sky130_fd_sc_hd__edfxtp_1
Xcpuregs\[16\]\[22\]$_DFFE_PP_ clknet_leaf_52_clk net608 net646
+ VSS VSS VDD VDD cpuregs\[16\]\[22\] sky130_fd_sc_hd__edfxtp_1
Xcpuregs\[16\]\[23\]$_DFFE_PP_ clknet_leaf_54_clk net603 net646
+ VSS VSS VDD VDD cpuregs\[16\]\[23\] sky130_fd_sc_hd__edfxtp_1
Xcpuregs\[16\]\[24\]$_DFFE_PP_ clknet_leaf_61_clk net600 net646
+ VSS VSS VDD VDD cpuregs\[16\]\[24\] sky130_fd_sc_hd__edfxtp_1
Xcpuregs\[16\]\[25\]$_DFFE_PP_ clknet_leaf_64_clk net604 net646
+ VSS VSS VDD VDD cpuregs\[16\]\[25\] sky130_fd_sc_hd__edfxtp_1
Xcpuregs\[16\]\[26\]$_DFFE_PP_ clknet_leaf_63_clk net605 net646
+ VSS VSS VDD VDD cpuregs\[16\]\[26\] sky130_fd_sc_hd__edfxtp_1
Xcpuregs\[16\]\[27\]$_DFFE_PP_ clknet_leaf_70_clk net601 net646
+ VSS VSS VDD VDD cpuregs\[16\]\[27\] sky130_fd_sc_hd__edfxtp_1
Xcpuregs\[16\]\[28\]$_DFFE_PP_ clknet_leaf_67_clk net602 net646
+ VSS VSS VDD VDD cpuregs\[16\]\[28\] sky130_fd_sc_hd__edfxtp_1
Xcpuregs\[16\]\[29\]$_DFFE_PP_ clknet_leaf_73_clk cpuregs_wrdata\[29\]
+ net646 VSS VSS VDD VDD cpuregs\[16\]\[29\] sky130_fd_sc_hd__edfxtp_1
Xcpuregs\[16\]\[2\]$_DFFE_PP_ clknet_leaf_1_clk net672 _0839_
+ VSS VSS VDD VDD cpuregs\[16\]\[2\] sky130_fd_sc_hd__edfxtp_1
Xcpuregs\[16\]\[30\]$_DFFE_PP_ clknet_leaf_148_clk cpuregs_wrdata\[30\]
+ _0839_ VSS VSS VDD VDD cpuregs\[16\]\[30\] sky130_fd_sc_hd__edfxtp_1
Xcpuregs\[16\]\[31\]$_DFFE_PP_ clknet_leaf_141_clk net598
+ net646 VSS VSS VDD VDD cpuregs\[16\]\[31\] sky130_fd_sc_hd__edfxtp_1
Xcpuregs\[16\]\[3\]$_DFFE_PP_ clknet_leaf_154_clk net673 _0839_
+ VSS VSS VDD VDD cpuregs\[16\]\[3\] sky130_fd_sc_hd__edfxtp_1
Xcpuregs\[16\]\[4\]$_DFFE_PP_ clknet_leaf_146_clk net659 _0839_
+ VSS VSS VDD VDD cpuregs\[16\]\[4\] sky130_fd_sc_hd__edfxtp_1
Xcpuregs\[16\]\[5\]$_DFFE_PP_ clknet_leaf_36_clk net674 net646
+ VSS VSS VDD VDD cpuregs\[16\]\[5\] sky130_fd_sc_hd__edfxtp_1
Xcpuregs\[16\]\[6\]$_DFFE_PP_ clknet_leaf_48_clk cpuregs_wrdata\[6\]
+ net646 VSS VSS VDD VDD cpuregs\[16\]\[6\] sky130_fd_sc_hd__edfxtp_1
Xcpuregs\[16\]\[7\]$_DFFE_PP_ clknet_leaf_50_clk cpuregs_wrdata\[7\]
+ net646 VSS VSS VDD VDD cpuregs\[16\]\[7\] sky130_fd_sc_hd__edfxtp_1
Xcpuregs\[16\]\[8\]$_DFFE_PP_ clknet_leaf_32_clk net660 net646
+ VSS VSS VDD VDD cpuregs\[16\]\[8\] sky130_fd_sc_hd__edfxtp_1
Xcpuregs\[16\]\[9\]$_DFFE_PP_ clknet_leaf_5_clk net613 _0839_
+ VSS VSS VDD VDD cpuregs\[16\]\[9\] sky130_fd_sc_hd__edfxtp_1
Xcpuregs\[17\]\[0\]$_DFFE_PP_ clknet_leaf_21_clk cpuregs_wrdata\[0\]
+ net647 VSS VSS VDD VDD cpuregs\[17\]\[0\] sky130_fd_sc_hd__edfxtp_1
Xcpuregs\[17\]\[10\]$_DFFE_PP_ clknet_leaf_19_clk net654 net647
+ VSS VSS VDD VDD cpuregs\[17\]\[10\] sky130_fd_sc_hd__edfxtp_1
Xcpuregs\[17\]\[11\]$_DFFE_PP_ clknet_leaf_8_clk net614 _0840_
+ VSS VSS VDD VDD cpuregs\[17\]\[11\] sky130_fd_sc_hd__edfxtp_1
Xcpuregs\[17\]\[12\]$_DFFE_PP_ clknet_leaf_3_clk net655 _0840_
+ VSS VSS VDD VDD cpuregs\[17\]\[12\] sky130_fd_sc_hd__edfxtp_1
Xcpuregs\[17\]\[13\]$_DFFE_PP_ clknet_leaf_8_clk net615 _0840_
+ VSS VSS VDD VDD cpuregs\[17\]\[13\] sky130_fd_sc_hd__edfxtp_1
Xcpuregs\[17\]\[14\]$_DFFE_PP_ clknet_leaf_39_clk net616 net647
+ VSS VSS VDD VDD cpuregs\[17\]\[14\] sky130_fd_sc_hd__edfxtp_1
Xcpuregs\[17\]\[15\]$_DFFE_PP_ clknet_leaf_71_clk cpuregs_wrdata\[15\]
+ net647 VSS VSS VDD VDD cpuregs\[17\]\[15\] sky130_fd_sc_hd__edfxtp_1
Xcpuregs\[17\]\[16\]$_DFFE_PP_ clknet_leaf_30_clk cpuregs_wrdata\[16\]
+ net647 VSS VSS VDD VDD cpuregs\[17\]\[16\] sky130_fd_sc_hd__edfxtp_1
Xcpuregs\[17\]\[17\]$_DFFE_PP_ clknet_leaf_76_clk cpuregs_wrdata\[17\]
+ net647 VSS VSS VDD VDD cpuregs\[17\]\[17\] sky130_fd_sc_hd__edfxtp_1
Xcpuregs\[17\]\[18\]$_DFFE_PP_ clknet_leaf_13_clk net617 net647
+ VSS VSS VDD VDD cpuregs\[17\]\[18\] sky130_fd_sc_hd__edfxtp_1
Xcpuregs\[17\]\[19\]$_DFFE_PP_ clknet_leaf_26_clk net606 net647
+ VSS VSS VDD VDD cpuregs\[17\]\[19\] sky130_fd_sc_hd__edfxtp_1
Xcpuregs\[17\]\[1\]$_DFFE_PP_ clknet_leaf_148_clk cpuregs_wrdata\[1\]
+ _0840_ VSS VSS VDD VDD cpuregs\[17\]\[1\] sky130_fd_sc_hd__edfxtp_1
Xcpuregs\[17\]\[20\]$_DFFE_PP_ clknet_leaf_59_clk net610 net647
+ VSS VSS VDD VDD cpuregs\[17\]\[20\] sky130_fd_sc_hd__edfxtp_1
Xcpuregs\[17\]\[21\]$_DFFE_PP_ clknet_leaf_42_clk net607 net647
+ VSS VSS VDD VDD cpuregs\[17\]\[21\] sky130_fd_sc_hd__edfxtp_1
Xcpuregs\[17\]\[22\]$_DFFE_PP_ clknet_leaf_52_clk net608 net647
+ VSS VSS VDD VDD cpuregs\[17\]\[22\] sky130_fd_sc_hd__edfxtp_1
Xcpuregs\[17\]\[23\]$_DFFE_PP_ clknet_leaf_53_clk net603 net647
+ VSS VSS VDD VDD cpuregs\[17\]\[23\] sky130_fd_sc_hd__edfxtp_1
Xcpuregs\[17\]\[24\]$_DFFE_PP_ clknet_leaf_60_clk net600 net647
+ VSS VSS VDD VDD cpuregs\[17\]\[24\] sky130_fd_sc_hd__edfxtp_1
Xcpuregs\[17\]\[25\]$_DFFE_PP_ clknet_leaf_62_clk net604 net647
+ VSS VSS VDD VDD cpuregs\[17\]\[25\] sky130_fd_sc_hd__edfxtp_1
Xcpuregs\[17\]\[26\]$_DFFE_PP_ clknet_leaf_62_clk net605 net647
+ VSS VSS VDD VDD cpuregs\[17\]\[26\] sky130_fd_sc_hd__edfxtp_1
Xcpuregs\[17\]\[27\]$_DFFE_PP_ clknet_leaf_70_clk net601 net647
+ VSS VSS VDD VDD cpuregs\[17\]\[27\] sky130_fd_sc_hd__edfxtp_1
Xcpuregs\[17\]\[28\]$_DFFE_PP_ clknet_leaf_67_clk net602 net647
+ VSS VSS VDD VDD cpuregs\[17\]\[28\] sky130_fd_sc_hd__edfxtp_1
Xcpuregs\[17\]\[29\]$_DFFE_PP_ clknet_leaf_72_clk cpuregs_wrdata\[29\]
+ net647 VSS VSS VDD VDD cpuregs\[17\]\[29\] sky130_fd_sc_hd__edfxtp_1
Xcpuregs\[17\]\[2\]$_DFFE_PP_ clknet_leaf_0_clk net672 _0840_
+ VSS VSS VDD VDD cpuregs\[17\]\[2\] sky130_fd_sc_hd__edfxtp_1
Xcpuregs\[17\]\[30\]$_DFFE_PP_ clknet_leaf_146_clk cpuregs_wrdata\[30\]
+ _0840_ VSS VSS VDD VDD cpuregs\[17\]\[30\] sky130_fd_sc_hd__edfxtp_1
Xcpuregs\[17\]\[31\]$_DFFE_PP_ clknet_leaf_141_clk net598
+ net647 VSS VSS VDD VDD cpuregs\[17\]\[31\] sky130_fd_sc_hd__edfxtp_1
Xcpuregs\[17\]\[3\]$_DFFE_PP_ clknet_leaf_155_clk net673 _0840_
+ VSS VSS VDD VDD cpuregs\[17\]\[3\] sky130_fd_sc_hd__edfxtp_1
Xcpuregs\[17\]\[4\]$_DFFE_PP_ clknet_leaf_146_clk net659 _0840_
+ VSS VSS VDD VDD cpuregs\[17\]\[4\] sky130_fd_sc_hd__edfxtp_1
Xcpuregs\[17\]\[5\]$_DFFE_PP_ clknet_leaf_36_clk net674 net647
+ VSS VSS VDD VDD cpuregs\[17\]\[5\] sky130_fd_sc_hd__edfxtp_1
Xcpuregs\[17\]\[6\]$_DFFE_PP_ clknet_leaf_48_clk cpuregs_wrdata\[6\]
+ net647 VSS VSS VDD VDD cpuregs\[17\]\[6\] sky130_fd_sc_hd__edfxtp_1
Xcpuregs\[17\]\[7\]$_DFFE_PP_ clknet_leaf_50_clk cpuregs_wrdata\[7\]
+ net647 VSS VSS VDD VDD cpuregs\[17\]\[7\] sky130_fd_sc_hd__edfxtp_1
Xcpuregs\[17\]\[8\]$_DFFE_PP_ clknet_leaf_32_clk net660 net647
+ VSS VSS VDD VDD cpuregs\[17\]\[8\] sky130_fd_sc_hd__edfxtp_1
Xcpuregs\[17\]\[9\]$_DFFE_PP_ clknet_leaf_5_clk net613 _0840_
+ VSS VSS VDD VDD cpuregs\[17\]\[9\] sky130_fd_sc_hd__edfxtp_1
Xcpuregs\[18\]\[0\]$_DFFE_PP_ clknet_leaf_21_clk cpuregs_wrdata\[0\]
+ net648 VSS VSS VDD VDD cpuregs\[18\]\[0\] sky130_fd_sc_hd__edfxtp_1
Xcpuregs\[18\]\[10\]$_DFFE_PP_ clknet_leaf_14_clk net654 net648
+ VSS VSS VDD VDD cpuregs\[18\]\[10\] sky130_fd_sc_hd__edfxtp_1
Xcpuregs\[18\]\[11\]$_DFFE_PP_ clknet_leaf_8_clk net614 net648
+ VSS VSS VDD VDD cpuregs\[18\]\[11\] sky130_fd_sc_hd__edfxtp_1
Xcpuregs\[18\]\[12\]$_DFFE_PP_ clknet_leaf_3_clk net655 net648
+ VSS VSS VDD VDD cpuregs\[18\]\[12\] sky130_fd_sc_hd__edfxtp_1
Xcpuregs\[18\]\[13\]$_DFFE_PP_ clknet_leaf_7_clk net615 net648
+ VSS VSS VDD VDD cpuregs\[18\]\[13\] sky130_fd_sc_hd__edfxtp_1
Xcpuregs\[18\]\[14\]$_DFFE_PP_ clknet_leaf_38_clk net616 net648
+ VSS VSS VDD VDD cpuregs\[18\]\[14\] sky130_fd_sc_hd__edfxtp_1
Xcpuregs\[18\]\[15\]$_DFFE_PP_ clknet_leaf_71_clk cpuregs_wrdata\[15\]
+ net648 VSS VSS VDD VDD cpuregs\[18\]\[15\] sky130_fd_sc_hd__edfxtp_1
Xcpuregs\[18\]\[16\]$_DFFE_PP_ clknet_leaf_30_clk cpuregs_wrdata\[16\]
+ net648 VSS VSS VDD VDD cpuregs\[18\]\[16\] sky130_fd_sc_hd__edfxtp_1
Xcpuregs\[18\]\[17\]$_DFFE_PP_ clknet_leaf_25_clk cpuregs_wrdata\[17\]
+ net648 VSS VSS VDD VDD cpuregs\[18\]\[17\] sky130_fd_sc_hd__edfxtp_1
Xcpuregs\[18\]\[18\]$_DFFE_PP_ clknet_leaf_12_clk net617 net648
+ VSS VSS VDD VDD cpuregs\[18\]\[18\] sky130_fd_sc_hd__edfxtp_1
Xcpuregs\[18\]\[19\]$_DFFE_PP_ clknet_leaf_26_clk net606 net648
+ VSS VSS VDD VDD cpuregs\[18\]\[19\] sky130_fd_sc_hd__edfxtp_1
Xcpuregs\[18\]\[1\]$_DFFE_PP_ clknet_leaf_147_clk cpuregs_wrdata\[1\]
+ net648 VSS VSS VDD VDD cpuregs\[18\]\[1\] sky130_fd_sc_hd__edfxtp_1
Xcpuregs\[18\]\[20\]$_DFFE_PP_ clknet_leaf_54_clk net610 net648
+ VSS VSS VDD VDD cpuregs\[18\]\[20\] sky130_fd_sc_hd__edfxtp_1
Xcpuregs\[18\]\[21\]$_DFFE_PP_ clknet_leaf_41_clk net607 net648
+ VSS VSS VDD VDD cpuregs\[18\]\[21\] sky130_fd_sc_hd__edfxtp_1
Xcpuregs\[18\]\[22\]$_DFFE_PP_ clknet_leaf_52_clk net608 net648
+ VSS VSS VDD VDD cpuregs\[18\]\[22\] sky130_fd_sc_hd__edfxtp_1
Xcpuregs\[18\]\[23\]$_DFFE_PP_ clknet_leaf_53_clk net603 net648
+ VSS VSS VDD VDD cpuregs\[18\]\[23\] sky130_fd_sc_hd__edfxtp_1
Xcpuregs\[18\]\[24\]$_DFFE_PP_ clknet_leaf_59_clk net600 net648
+ VSS VSS VDD VDD cpuregs\[18\]\[24\] sky130_fd_sc_hd__edfxtp_1
Xcpuregs\[18\]\[25\]$_DFFE_PP_ clknet_leaf_65_clk net604 net648
+ VSS VSS VDD VDD cpuregs\[18\]\[25\] sky130_fd_sc_hd__edfxtp_1
Xcpuregs\[18\]\[26\]$_DFFE_PP_ clknet_leaf_62_clk net605 net648
+ VSS VSS VDD VDD cpuregs\[18\]\[26\] sky130_fd_sc_hd__edfxtp_1
Xcpuregs\[18\]\[27\]$_DFFE_PP_ clknet_leaf_70_clk net601 net648
+ VSS VSS VDD VDD cpuregs\[18\]\[27\] sky130_fd_sc_hd__edfxtp_1
Xcpuregs\[18\]\[28\]$_DFFE_PP_ clknet_leaf_67_clk net602 net648
+ VSS VSS VDD VDD cpuregs\[18\]\[28\] sky130_fd_sc_hd__edfxtp_1
Xcpuregs\[18\]\[29\]$_DFFE_PP_ clknet_leaf_73_clk cpuregs_wrdata\[29\]
+ net648 VSS VSS VDD VDD cpuregs\[18\]\[29\] sky130_fd_sc_hd__edfxtp_1
Xcpuregs\[18\]\[2\]$_DFFE_PP_ clknet_leaf_0_clk net672 net648
+ VSS VSS VDD VDD cpuregs\[18\]\[2\] sky130_fd_sc_hd__edfxtp_1
Xcpuregs\[18\]\[30\]$_DFFE_PP_ clknet_leaf_146_clk cpuregs_wrdata\[30\]
+ net648 VSS VSS VDD VDD cpuregs\[18\]\[30\] sky130_fd_sc_hd__edfxtp_1
Xcpuregs\[18\]\[31\]$_DFFE_PP_ clknet_leaf_142_clk net598
+ net648 VSS VSS VDD VDD cpuregs\[18\]\[31\] sky130_fd_sc_hd__edfxtp_1
Xcpuregs\[18\]\[3\]$_DFFE_PP_ clknet_leaf_155_clk net673 net648
+ VSS VSS VDD VDD cpuregs\[18\]\[3\] sky130_fd_sc_hd__edfxtp_1
Xcpuregs\[18\]\[4\]$_DFFE_PP_ clknet_leaf_146_clk net659 net648
+ VSS VSS VDD VDD cpuregs\[18\]\[4\] sky130_fd_sc_hd__edfxtp_1
Xcpuregs\[18\]\[5\]$_DFFE_PP_ clknet_leaf_37_clk net674 net648
+ VSS VSS VDD VDD cpuregs\[18\]\[5\] sky130_fd_sc_hd__edfxtp_1
Xcpuregs\[18\]\[6\]$_DFFE_PP_ clknet_leaf_48_clk cpuregs_wrdata\[6\]
+ net648 VSS VSS VDD VDD cpuregs\[18\]\[6\] sky130_fd_sc_hd__edfxtp_1
Xcpuregs\[18\]\[7\]$_DFFE_PP_ clknet_leaf_50_clk cpuregs_wrdata\[7\]
+ net648 VSS VSS VDD VDD cpuregs\[18\]\[7\] sky130_fd_sc_hd__edfxtp_1
Xcpuregs\[18\]\[8\]$_DFFE_PP_ clknet_leaf_32_clk net660 net648
+ VSS VSS VDD VDD cpuregs\[18\]\[8\] sky130_fd_sc_hd__edfxtp_1
Xcpuregs\[18\]\[9\]$_DFFE_PP_ clknet_leaf_5_clk net613 net648
+ VSS VSS VDD VDD cpuregs\[18\]\[9\] sky130_fd_sc_hd__edfxtp_1
Xcpuregs\[19\]\[0\]$_DFFE_PP_ clknet_leaf_21_clk cpuregs_wrdata\[0\]
+ net650 VSS VSS VDD VDD cpuregs\[19\]\[0\] sky130_fd_sc_hd__edfxtp_1
Xcpuregs\[19\]\[10\]$_DFFE_PP_ clknet_leaf_19_clk net654 net650
+ VSS VSS VDD VDD cpuregs\[19\]\[10\] sky130_fd_sc_hd__edfxtp_1
Xcpuregs\[19\]\[11\]$_DFFE_PP_ clknet_leaf_8_clk net614 _0842_
+ VSS VSS VDD VDD cpuregs\[19\]\[11\] sky130_fd_sc_hd__edfxtp_1
Xcpuregs\[19\]\[12\]$_DFFE_PP_ clknet_leaf_2_clk net655 _0842_
+ VSS VSS VDD VDD cpuregs\[19\]\[12\] sky130_fd_sc_hd__edfxtp_1
Xcpuregs\[19\]\[13\]$_DFFE_PP_ clknet_leaf_7_clk net615 _0842_
+ VSS VSS VDD VDD cpuregs\[19\]\[13\] sky130_fd_sc_hd__edfxtp_1
Xcpuregs\[19\]\[14\]$_DFFE_PP_ clknet_leaf_38_clk net616 net650
+ VSS VSS VDD VDD cpuregs\[19\]\[14\] sky130_fd_sc_hd__edfxtp_1
Xcpuregs\[19\]\[15\]$_DFFE_PP_ clknet_leaf_29_clk cpuregs_wrdata\[15\]
+ net650 VSS VSS VDD VDD cpuregs\[19\]\[15\] sky130_fd_sc_hd__edfxtp_1
Xcpuregs\[19\]\[16\]$_DFFE_PP_ clknet_leaf_30_clk cpuregs_wrdata\[16\]
+ net650 VSS VSS VDD VDD cpuregs\[19\]\[16\] sky130_fd_sc_hd__edfxtp_1
Xcpuregs\[19\]\[17\]$_DFFE_PP_ clknet_leaf_25_clk cpuregs_wrdata\[17\]
+ net650 VSS VSS VDD VDD cpuregs\[19\]\[17\] sky130_fd_sc_hd__edfxtp_1
Xcpuregs\[19\]\[18\]$_DFFE_PP_ clknet_leaf_13_clk net617 net650
+ VSS VSS VDD VDD cpuregs\[19\]\[18\] sky130_fd_sc_hd__edfxtp_1
Xcpuregs\[19\]\[19\]$_DFFE_PP_ clknet_leaf_27_clk net606 net650
+ VSS VSS VDD VDD cpuregs\[19\]\[19\] sky130_fd_sc_hd__edfxtp_1
Xcpuregs\[19\]\[1\]$_DFFE_PP_ clknet_leaf_149_clk cpuregs_wrdata\[1\]
+ _0842_ VSS VSS VDD VDD cpuregs\[19\]\[1\] sky130_fd_sc_hd__edfxtp_1
Xcpuregs\[19\]\[20\]$_DFFE_PP_ clknet_leaf_54_clk net610 net650
+ VSS VSS VDD VDD cpuregs\[19\]\[20\] sky130_fd_sc_hd__edfxtp_1
Xcpuregs\[19\]\[21\]$_DFFE_PP_ clknet_leaf_41_clk net607 net650
+ VSS VSS VDD VDD cpuregs\[19\]\[21\] sky130_fd_sc_hd__edfxtp_1
Xcpuregs\[19\]\[22\]$_DFFE_PP_ clknet_leaf_52_clk net608 net650
+ VSS VSS VDD VDD cpuregs\[19\]\[22\] sky130_fd_sc_hd__edfxtp_1
Xcpuregs\[19\]\[23\]$_DFFE_PP_ clknet_leaf_53_clk net603 net650
+ VSS VSS VDD VDD cpuregs\[19\]\[23\] sky130_fd_sc_hd__edfxtp_1
Xcpuregs\[19\]\[24\]$_DFFE_PP_ clknet_leaf_59_clk net600 net650
+ VSS VSS VDD VDD cpuregs\[19\]\[24\] sky130_fd_sc_hd__edfxtp_1
Xcpuregs\[19\]\[25\]$_DFFE_PP_ clknet_leaf_65_clk net604 net650
+ VSS VSS VDD VDD cpuregs\[19\]\[25\] sky130_fd_sc_hd__edfxtp_1
Xcpuregs\[19\]\[26\]$_DFFE_PP_ clknet_leaf_62_clk net605 net650
+ VSS VSS VDD VDD cpuregs\[19\]\[26\] sky130_fd_sc_hd__edfxtp_1
Xcpuregs\[19\]\[27\]$_DFFE_PP_ clknet_leaf_70_clk net601 net650
+ VSS VSS VDD VDD cpuregs\[19\]\[27\] sky130_fd_sc_hd__edfxtp_1
Xcpuregs\[19\]\[28\]$_DFFE_PP_ clknet_leaf_67_clk net602 net650
+ VSS VSS VDD VDD cpuregs\[19\]\[28\] sky130_fd_sc_hd__edfxtp_1
Xcpuregs\[19\]\[29\]$_DFFE_PP_ clknet_leaf_72_clk cpuregs_wrdata\[29\]
+ net650 VSS VSS VDD VDD cpuregs\[19\]\[29\] sky130_fd_sc_hd__edfxtp_1
Xcpuregs\[19\]\[2\]$_DFFE_PP_ clknet_leaf_0_clk net672 _0842_
+ VSS VSS VDD VDD cpuregs\[19\]\[2\] sky130_fd_sc_hd__edfxtp_1
Xcpuregs\[19\]\[30\]$_DFFE_PP_ clknet_leaf_146_clk cpuregs_wrdata\[30\]
+ _0842_ VSS VSS VDD VDD cpuregs\[19\]\[30\] sky130_fd_sc_hd__edfxtp_1
Xcpuregs\[19\]\[31\]$_DFFE_PP_ clknet_leaf_141_clk net598
+ net650 VSS VSS VDD VDD cpuregs\[19\]\[31\] sky130_fd_sc_hd__edfxtp_1
Xcpuregs\[19\]\[3\]$_DFFE_PP_ clknet_leaf_155_clk net673 _0842_
+ VSS VSS VDD VDD cpuregs\[19\]\[3\] sky130_fd_sc_hd__edfxtp_1
Xcpuregs\[19\]\[4\]$_DFFE_PP_ clknet_leaf_146_clk net659 _0842_
+ VSS VSS VDD VDD cpuregs\[19\]\[4\] sky130_fd_sc_hd__edfxtp_1
Xcpuregs\[19\]\[5\]$_DFFE_PP_ clknet_leaf_37_clk net674 net650
+ VSS VSS VDD VDD cpuregs\[19\]\[5\] sky130_fd_sc_hd__edfxtp_1
Xcpuregs\[19\]\[6\]$_DFFE_PP_ clknet_leaf_48_clk cpuregs_wrdata\[6\]
+ net650 VSS VSS VDD VDD cpuregs\[19\]\[6\] sky130_fd_sc_hd__edfxtp_1
Xcpuregs\[19\]\[7\]$_DFFE_PP_ clknet_leaf_51_clk cpuregs_wrdata\[7\]
+ net650 VSS VSS VDD VDD cpuregs\[19\]\[7\] sky130_fd_sc_hd__edfxtp_1
Xcpuregs\[19\]\[8\]$_DFFE_PP_ clknet_leaf_32_clk net660 net650
+ VSS VSS VDD VDD cpuregs\[19\]\[8\] sky130_fd_sc_hd__edfxtp_1
Xcpuregs\[19\]\[9\]$_DFFE_PP_ clknet_leaf_6_clk net613 _0842_
+ VSS VSS VDD VDD cpuregs\[19\]\[9\] sky130_fd_sc_hd__edfxtp_1
Xcpuregs\[1\]\[0\]$_DFFE_PP_ clknet_leaf_141_clk cpuregs_wrdata\[0\]
+ net621 VSS VSS VDD VDD cpuregs\[1\]\[0\] sky130_fd_sc_hd__edfxtp_1
Xcpuregs\[1\]\[10\]$_DFFE_PP_ clknet_leaf_18_clk net654 net621
+ VSS VSS VDD VDD cpuregs\[1\]\[10\] sky130_fd_sc_hd__edfxtp_1
Xcpuregs\[1\]\[11\]$_DFFE_PP_ clknet_leaf_11_clk net614 net621
+ VSS VSS VDD VDD cpuregs\[1\]\[11\] sky130_fd_sc_hd__edfxtp_1
Xcpuregs\[1\]\[12\]$_DFFE_PP_ clknet_leaf_157_clk net655 net621
+ VSS VSS VDD VDD cpuregs\[1\]\[12\] sky130_fd_sc_hd__edfxtp_1
Xcpuregs\[1\]\[13\]$_DFFE_PP_ clknet_leaf_15_clk net615 net621
+ VSS VSS VDD VDD cpuregs\[1\]\[13\] sky130_fd_sc_hd__edfxtp_1
Xcpuregs\[1\]\[14\]$_DFFE_PP_ clknet_leaf_35_clk net616 net621
+ VSS VSS VDD VDD cpuregs\[1\]\[14\] sky130_fd_sc_hd__edfxtp_1
Xcpuregs\[1\]\[15\]$_DFFE_PP_ clknet_leaf_75_clk cpuregs_wrdata\[15\]
+ net621 VSS VSS VDD VDD cpuregs\[1\]\[15\] sky130_fd_sc_hd__edfxtp_1
Xcpuregs\[1\]\[16\]$_DFFE_PP_ clknet_leaf_28_clk cpuregs_wrdata\[16\]
+ net621 VSS VSS VDD VDD cpuregs\[1\]\[16\] sky130_fd_sc_hd__edfxtp_1
Xcpuregs\[1\]\[17\]$_DFFE_PP_ clknet_leaf_77_clk cpuregs_wrdata\[17\]
+ net621 VSS VSS VDD VDD cpuregs\[1\]\[17\] sky130_fd_sc_hd__edfxtp_1
Xcpuregs\[1\]\[18\]$_DFFE_PP_ clknet_leaf_13_clk net617 net621
+ VSS VSS VDD VDD cpuregs\[1\]\[18\] sky130_fd_sc_hd__edfxtp_1
Xcpuregs\[1\]\[19\]$_DFFE_PP_ clknet_leaf_26_clk net606 net621
+ VSS VSS VDD VDD cpuregs\[1\]\[19\] sky130_fd_sc_hd__edfxtp_1
Xcpuregs\[1\]\[1\]$_DFFE_PP_ clknet_leaf_150_clk cpuregs_wrdata\[1\]
+ net621 VSS VSS VDD VDD cpuregs\[1\]\[1\] sky130_fd_sc_hd__edfxtp_1
Xcpuregs\[1\]\[20\]$_DFFE_PP_ clknet_leaf_60_clk net610 net621
+ VSS VSS VDD VDD cpuregs\[1\]\[20\] sky130_fd_sc_hd__edfxtp_1
Xcpuregs\[1\]\[21\]$_DFFE_PP_ clknet_leaf_43_clk net607 net621
+ VSS VSS VDD VDD cpuregs\[1\]\[21\] sky130_fd_sc_hd__edfxtp_1
Xcpuregs\[1\]\[22\]$_DFFE_PP_ clknet_leaf_53_clk net608 net621
+ VSS VSS VDD VDD cpuregs\[1\]\[22\] sky130_fd_sc_hd__edfxtp_1
Xcpuregs\[1\]\[23\]$_DFFE_PP_ clknet_leaf_54_clk net603 net621
+ VSS VSS VDD VDD cpuregs\[1\]\[23\] sky130_fd_sc_hd__edfxtp_1
Xcpuregs\[1\]\[24\]$_DFFE_PP_ clknet_leaf_61_clk net600 net621
+ VSS VSS VDD VDD cpuregs\[1\]\[24\] sky130_fd_sc_hd__edfxtp_1
Xcpuregs\[1\]\[25\]$_DFFE_PP_ clknet_leaf_64_clk net604 net621
+ VSS VSS VDD VDD cpuregs\[1\]\[25\] sky130_fd_sc_hd__edfxtp_1
Xcpuregs\[1\]\[26\]$_DFFE_PP_ clknet_leaf_63_clk net605 net621
+ VSS VSS VDD VDD cpuregs\[1\]\[26\] sky130_fd_sc_hd__edfxtp_1
Xcpuregs\[1\]\[27\]$_DFFE_PP_ clknet_leaf_70_clk net601 net621
+ VSS VSS VDD VDD cpuregs\[1\]\[27\] sky130_fd_sc_hd__edfxtp_1
Xcpuregs\[1\]\[28\]$_DFFE_PP_ clknet_leaf_66_clk net602 net621
+ VSS VSS VDD VDD cpuregs\[1\]\[28\] sky130_fd_sc_hd__edfxtp_1
Xcpuregs\[1\]\[29\]$_DFFE_PP_ clknet_leaf_74_clk cpuregs_wrdata\[29\]
+ net621 VSS VSS VDD VDD cpuregs\[1\]\[29\] sky130_fd_sc_hd__edfxtp_1
Xcpuregs\[1\]\[2\]$_DFFE_PP_ clknet_leaf_157_clk net672 net621
+ VSS VSS VDD VDD cpuregs\[1\]\[2\] sky130_fd_sc_hd__edfxtp_1
Xcpuregs\[1\]\[30\]$_DFFE_PP_ clknet_leaf_150_clk cpuregs_wrdata\[30\]
+ net621 VSS VSS VDD VDD cpuregs\[1\]\[30\] sky130_fd_sc_hd__edfxtp_1
Xcpuregs\[1\]\[31\]$_DFFE_PP_ clknet_leaf_142_clk net598 net621
+ VSS VSS VDD VDD cpuregs\[1\]\[31\] sky130_fd_sc_hd__edfxtp_1
Xcpuregs\[1\]\[3\]$_DFFE_PP_ clknet_leaf_152_clk net673 net621
+ VSS VSS VDD VDD cpuregs\[1\]\[3\] sky130_fd_sc_hd__edfxtp_1
Xcpuregs\[1\]\[4\]$_DFFE_PP_ clknet_leaf_151_clk net659 net621
+ VSS VSS VDD VDD cpuregs\[1\]\[4\] sky130_fd_sc_hd__edfxtp_1
Xcpuregs\[1\]\[5\]$_DFFE_PP_ clknet_leaf_36_clk net674 net621
+ VSS VSS VDD VDD cpuregs\[1\]\[5\] sky130_fd_sc_hd__edfxtp_1
Xcpuregs\[1\]\[6\]$_DFFE_PP_ clknet_leaf_47_clk cpuregs_wrdata\[6\]
+ net621 VSS VSS VDD VDD cpuregs\[1\]\[6\] sky130_fd_sc_hd__edfxtp_1
Xcpuregs\[1\]\[7\]$_DFFE_PP_ clknet_leaf_51_clk cpuregs_wrdata\[7\]
+ net621 VSS VSS VDD VDD cpuregs\[1\]\[7\] sky130_fd_sc_hd__edfxtp_1
Xcpuregs\[1\]\[8\]$_DFFE_PP_ clknet_leaf_28_clk net660 net621
+ VSS VSS VDD VDD cpuregs\[1\]\[8\] sky130_fd_sc_hd__edfxtp_1
Xcpuregs\[1\]\[9\]$_DFFE_PP_ clknet_leaf_15_clk net613 net621
+ VSS VSS VDD VDD cpuregs\[1\]\[9\] sky130_fd_sc_hd__edfxtp_1
Xcpuregs\[20\]\[0\]$_DFFE_PP_ clknet_leaf_24_clk cpuregs_wrdata\[0\]
+ net651 VSS VSS VDD VDD cpuregs\[20\]\[0\] sky130_fd_sc_hd__edfxtp_1
Xcpuregs\[20\]\[10\]$_DFFE_PP_ clknet_leaf_18_clk net654 net651
+ VSS VSS VDD VDD cpuregs\[20\]\[10\] sky130_fd_sc_hd__edfxtp_1
Xcpuregs\[20\]\[11\]$_DFFE_PP_ clknet_leaf_9_clk net614 net651
+ VSS VSS VDD VDD cpuregs\[20\]\[11\] sky130_fd_sc_hd__edfxtp_1
Xcpuregs\[20\]\[12\]$_DFFE_PP_ clknet_leaf_155_clk net655
+ _0844_ VSS VSS VDD VDD cpuregs\[20\]\[12\] sky130_fd_sc_hd__edfxtp_1
Xcpuregs\[20\]\[13\]$_DFFE_PP_ clknet_leaf_7_clk net615 net651
+ VSS VSS VDD VDD cpuregs\[20\]\[13\] sky130_fd_sc_hd__edfxtp_1
Xcpuregs\[20\]\[14\]$_DFFE_PP_ clknet_leaf_38_clk net616 net651
+ VSS VSS VDD VDD cpuregs\[20\]\[14\] sky130_fd_sc_hd__edfxtp_1
Xcpuregs\[20\]\[15\]$_DFFE_PP_ clknet_leaf_29_clk cpuregs_wrdata\[15\]
+ net651 VSS VSS VDD VDD cpuregs\[20\]\[15\] sky130_fd_sc_hd__edfxtp_1
Xcpuregs\[20\]\[16\]$_DFFE_PP_ clknet_leaf_31_clk cpuregs_wrdata\[16\]
+ net651 VSS VSS VDD VDD cpuregs\[20\]\[16\] sky130_fd_sc_hd__edfxtp_1
Xcpuregs\[20\]\[17\]$_DFFE_PP_ clknet_leaf_25_clk cpuregs_wrdata\[17\]
+ net651 VSS VSS VDD VDD cpuregs\[20\]\[17\] sky130_fd_sc_hd__edfxtp_1
Xcpuregs\[20\]\[18\]$_DFFE_PP_ clknet_leaf_12_clk net617 net651
+ VSS VSS VDD VDD cpuregs\[20\]\[18\] sky130_fd_sc_hd__edfxtp_1
Xcpuregs\[20\]\[19\]$_DFFE_PP_ clknet_leaf_20_clk net606 net651
+ VSS VSS VDD VDD cpuregs\[20\]\[19\] sky130_fd_sc_hd__edfxtp_1
Xcpuregs\[20\]\[1\]$_DFFE_PP_ clknet_leaf_149_clk cpuregs_wrdata\[1\]
+ _0844_ VSS VSS VDD VDD cpuregs\[20\]\[1\] sky130_fd_sc_hd__edfxtp_1
Xcpuregs\[20\]\[20\]$_DFFE_PP_ clknet_leaf_59_clk net610 net651
+ VSS VSS VDD VDD cpuregs\[20\]\[20\] sky130_fd_sc_hd__edfxtp_1
Xcpuregs\[20\]\[21\]$_DFFE_PP_ clknet_leaf_41_clk net607 net651
+ VSS VSS VDD VDD cpuregs\[20\]\[21\] sky130_fd_sc_hd__edfxtp_1
Xcpuregs\[20\]\[22\]$_DFFE_PP_ clknet_leaf_55_clk net608 net651
+ VSS VSS VDD VDD cpuregs\[20\]\[22\] sky130_fd_sc_hd__edfxtp_1
Xcpuregs\[20\]\[23\]$_DFFE_PP_ clknet_leaf_55_clk net603 net651
+ VSS VSS VDD VDD cpuregs\[20\]\[23\] sky130_fd_sc_hd__edfxtp_1
Xcpuregs\[20\]\[24\]$_DFFE_PP_ clknet_leaf_59_clk net600 net651
+ VSS VSS VDD VDD cpuregs\[20\]\[24\] sky130_fd_sc_hd__edfxtp_1
Xcpuregs\[20\]\[25\]$_DFFE_PP_ clknet_leaf_65_clk net604 net651
+ VSS VSS VDD VDD cpuregs\[20\]\[25\] sky130_fd_sc_hd__edfxtp_1
Xcpuregs\[20\]\[26\]$_DFFE_PP_ clknet_leaf_61_clk net605 net651
+ VSS VSS VDD VDD cpuregs\[20\]\[26\] sky130_fd_sc_hd__edfxtp_1
Xcpuregs\[20\]\[27\]$_DFFE_PP_ clknet_leaf_30_clk net601 net651
+ VSS VSS VDD VDD cpuregs\[20\]\[27\] sky130_fd_sc_hd__edfxtp_1
Xcpuregs\[20\]\[28\]$_DFFE_PP_ clknet_leaf_69_clk net602 net651
+ VSS VSS VDD VDD cpuregs\[20\]\[28\] sky130_fd_sc_hd__edfxtp_1
Xcpuregs\[20\]\[29\]$_DFFE_PP_ clknet_leaf_71_clk cpuregs_wrdata\[29\]
+ net651 VSS VSS VDD VDD cpuregs\[20\]\[29\] sky130_fd_sc_hd__edfxtp_1
Xcpuregs\[20\]\[2\]$_DFFE_PP_ clknet_leaf_155_clk net672 _0844_
+ VSS VSS VDD VDD cpuregs\[20\]\[2\] sky130_fd_sc_hd__edfxtp_1
Xcpuregs\[20\]\[30\]$_DFFE_PP_ clknet_leaf_147_clk cpuregs_wrdata\[30\]
+ _0844_ VSS VSS VDD VDD cpuregs\[20\]\[30\] sky130_fd_sc_hd__edfxtp_1
Xcpuregs\[20\]\[31\]$_DFFE_PP_ clknet_leaf_144_clk net598
+ net651 VSS VSS VDD VDD cpuregs\[20\]\[31\] sky130_fd_sc_hd__edfxtp_1
Xcpuregs\[20\]\[3\]$_DFFE_PP_ clknet_leaf_154_clk net673 _0844_
+ VSS VSS VDD VDD cpuregs\[20\]\[3\] sky130_fd_sc_hd__edfxtp_1
Xcpuregs\[20\]\[4\]$_DFFE_PP_ clknet_leaf_153_clk net659 _0844_
+ VSS VSS VDD VDD cpuregs\[20\]\[4\] sky130_fd_sc_hd__edfxtp_1
Xcpuregs\[20\]\[5\]$_DFFE_PP_ clknet_leaf_37_clk net674 net651
+ VSS VSS VDD VDD cpuregs\[20\]\[5\] sky130_fd_sc_hd__edfxtp_1
Xcpuregs\[20\]\[6\]$_DFFE_PP_ clknet_leaf_49_clk cpuregs_wrdata\[6\]
+ net651 VSS VSS VDD VDD cpuregs\[20\]\[6\] sky130_fd_sc_hd__edfxtp_1
Xcpuregs\[20\]\[7\]$_DFFE_PP_ clknet_leaf_51_clk cpuregs_wrdata\[7\]
+ net651 VSS VSS VDD VDD cpuregs\[20\]\[7\] sky130_fd_sc_hd__edfxtp_1
Xcpuregs\[20\]\[8\]$_DFFE_PP_ clknet_leaf_34_clk net660 net651
+ VSS VSS VDD VDD cpuregs\[20\]\[8\] sky130_fd_sc_hd__edfxtp_1
Xcpuregs\[20\]\[9\]$_DFFE_PP_ clknet_leaf_6_clk net613 net651
+ VSS VSS VDD VDD cpuregs\[20\]\[9\] sky130_fd_sc_hd__edfxtp_1
Xcpuregs\[21\]\[0\]$_DFFE_PP_ clknet_leaf_24_clk cpuregs_wrdata\[0\]
+ net622 VSS VSS VDD VDD cpuregs\[21\]\[0\] sky130_fd_sc_hd__edfxtp_1
Xcpuregs\[21\]\[10\]$_DFFE_PP_ clknet_leaf_16_clk net654 net622
+ VSS VSS VDD VDD cpuregs\[21\]\[10\] sky130_fd_sc_hd__edfxtp_1
Xcpuregs\[21\]\[11\]$_DFFE_PP_ clknet_leaf_9_clk net614 net622
+ VSS VSS VDD VDD cpuregs\[21\]\[11\] sky130_fd_sc_hd__edfxtp_1
Xcpuregs\[21\]\[12\]$_DFFE_PP_ clknet_leaf_2_clk net655 _0845_
+ VSS VSS VDD VDD cpuregs\[21\]\[12\] sky130_fd_sc_hd__edfxtp_1
Xcpuregs\[21\]\[13\]$_DFFE_PP_ clknet_leaf_7_clk net615 net622
+ VSS VSS VDD VDD cpuregs\[21\]\[13\] sky130_fd_sc_hd__edfxtp_1
Xcpuregs\[21\]\[14\]$_DFFE_PP_ clknet_leaf_38_clk net616 net622
+ VSS VSS VDD VDD cpuregs\[21\]\[14\] sky130_fd_sc_hd__edfxtp_1
Xcpuregs\[21\]\[15\]$_DFFE_PP_ clknet_leaf_29_clk cpuregs_wrdata\[15\]
+ net622 VSS VSS VDD VDD cpuregs\[21\]\[15\] sky130_fd_sc_hd__edfxtp_1
Xcpuregs\[21\]\[16\]$_DFFE_PP_ clknet_leaf_31_clk cpuregs_wrdata\[16\]
+ net622 VSS VSS VDD VDD cpuregs\[21\]\[16\] sky130_fd_sc_hd__edfxtp_1
Xcpuregs\[21\]\[17\]$_DFFE_PP_ clknet_leaf_25_clk cpuregs_wrdata\[17\]
+ net622 VSS VSS VDD VDD cpuregs\[21\]\[17\] sky130_fd_sc_hd__edfxtp_1
Xcpuregs\[21\]\[18\]$_DFFE_PP_ clknet_leaf_12_clk net617 net622
+ VSS VSS VDD VDD cpuregs\[21\]\[18\] sky130_fd_sc_hd__edfxtp_1
Xcpuregs\[21\]\[19\]$_DFFE_PP_ clknet_leaf_27_clk net606 net622
+ VSS VSS VDD VDD cpuregs\[21\]\[19\] sky130_fd_sc_hd__edfxtp_1
Xcpuregs\[21\]\[1\]$_DFFE_PP_ clknet_leaf_147_clk cpuregs_wrdata\[1\]
+ _0845_ VSS VSS VDD VDD cpuregs\[21\]\[1\] sky130_fd_sc_hd__edfxtp_1
Xcpuregs\[21\]\[20\]$_DFFE_PP_ clknet_leaf_59_clk net610 net622
+ VSS VSS VDD VDD cpuregs\[21\]\[20\] sky130_fd_sc_hd__edfxtp_1
Xcpuregs\[21\]\[21\]$_DFFE_PP_ clknet_leaf_41_clk net607 net622
+ VSS VSS VDD VDD cpuregs\[21\]\[21\] sky130_fd_sc_hd__edfxtp_1
Xcpuregs\[21\]\[22\]$_DFFE_PP_ clknet_leaf_53_clk net608 net622
+ VSS VSS VDD VDD cpuregs\[21\]\[22\] sky130_fd_sc_hd__edfxtp_1
Xcpuregs\[21\]\[23\]$_DFFE_PP_ clknet_leaf_55_clk net603 net622
+ VSS VSS VDD VDD cpuregs\[21\]\[23\] sky130_fd_sc_hd__edfxtp_1
Xcpuregs\[21\]\[24\]$_DFFE_PP_ clknet_leaf_59_clk net600 net622
+ VSS VSS VDD VDD cpuregs\[21\]\[24\] sky130_fd_sc_hd__edfxtp_1
Xcpuregs\[21\]\[25\]$_DFFE_PP_ clknet_leaf_62_clk net604 net622
+ VSS VSS VDD VDD cpuregs\[21\]\[25\] sky130_fd_sc_hd__edfxtp_1
Xcpuregs\[21\]\[26\]$_DFFE_PP_ clknet_leaf_61_clk net605 net622
+ VSS VSS VDD VDD cpuregs\[21\]\[26\] sky130_fd_sc_hd__edfxtp_1
Xcpuregs\[21\]\[27\]$_DFFE_PP_ clknet_leaf_45_clk net601 net622
+ VSS VSS VDD VDD cpuregs\[21\]\[27\] sky130_fd_sc_hd__edfxtp_1
Xcpuregs\[21\]\[28\]$_DFFE_PP_ clknet_leaf_69_clk net602 net622
+ VSS VSS VDD VDD cpuregs\[21\]\[28\] sky130_fd_sc_hd__edfxtp_1
Xcpuregs\[21\]\[29\]$_DFFE_PP_ clknet_leaf_71_clk cpuregs_wrdata\[29\]
+ net622 VSS VSS VDD VDD cpuregs\[21\]\[29\] sky130_fd_sc_hd__edfxtp_1
Xcpuregs\[21\]\[2\]$_DFFE_PP_ clknet_leaf_156_clk net672 _0845_
+ VSS VSS VDD VDD cpuregs\[21\]\[2\] sky130_fd_sc_hd__edfxtp_1
Xcpuregs\[21\]\[30\]$_DFFE_PP_ clknet_leaf_147_clk cpuregs_wrdata\[30\]
+ _0845_ VSS VSS VDD VDD cpuregs\[21\]\[30\] sky130_fd_sc_hd__edfxtp_1
Xcpuregs\[21\]\[31\]$_DFFE_PP_ clknet_leaf_18_clk net598 net622
+ VSS VSS VDD VDD cpuregs\[21\]\[31\] sky130_fd_sc_hd__edfxtp_1
Xcpuregs\[21\]\[3\]$_DFFE_PP_ clknet_leaf_155_clk net673 _0845_
+ VSS VSS VDD VDD cpuregs\[21\]\[3\] sky130_fd_sc_hd__edfxtp_1
Xcpuregs\[21\]\[4\]$_DFFE_PP_ clknet_leaf_154_clk net659 _0845_
+ VSS VSS VDD VDD cpuregs\[21\]\[4\] sky130_fd_sc_hd__edfxtp_1
Xcpuregs\[21\]\[5\]$_DFFE_PP_ clknet_leaf_36_clk net674 net622
+ VSS VSS VDD VDD cpuregs\[21\]\[5\] sky130_fd_sc_hd__edfxtp_1
Xcpuregs\[21\]\[6\]$_DFFE_PP_ clknet_leaf_49_clk cpuregs_wrdata\[6\]
+ net622 VSS VSS VDD VDD cpuregs\[21\]\[6\] sky130_fd_sc_hd__edfxtp_1
Xcpuregs\[21\]\[7\]$_DFFE_PP_ clknet_leaf_51_clk cpuregs_wrdata\[7\]
+ net622 VSS VSS VDD VDD cpuregs\[21\]\[7\] sky130_fd_sc_hd__edfxtp_1
Xcpuregs\[21\]\[8\]$_DFFE_PP_ clknet_leaf_34_clk net660 net622
+ VSS VSS VDD VDD cpuregs\[21\]\[8\] sky130_fd_sc_hd__edfxtp_1
Xcpuregs\[21\]\[9\]$_DFFE_PP_ clknet_leaf_6_clk net613 net622
+ VSS VSS VDD VDD cpuregs\[21\]\[9\] sky130_fd_sc_hd__edfxtp_1
Xcpuregs\[22\]\[0\]$_DFFE_PP_ clknet_leaf_21_clk cpuregs_wrdata\[0\]
+ net637 VSS VSS VDD VDD cpuregs\[22\]\[0\] sky130_fd_sc_hd__edfxtp_1
Xcpuregs\[22\]\[10\]$_DFFE_PP_ clknet_leaf_16_clk net654 net637
+ VSS VSS VDD VDD cpuregs\[22\]\[10\] sky130_fd_sc_hd__edfxtp_1
Xcpuregs\[22\]\[11\]$_DFFE_PP_ clknet_leaf_9_clk net614 net637
+ VSS VSS VDD VDD cpuregs\[22\]\[11\] sky130_fd_sc_hd__edfxtp_1
Xcpuregs\[22\]\[12\]$_DFFE_PP_ clknet_leaf_2_clk net655 _0846_
+ VSS VSS VDD VDD cpuregs\[22\]\[12\] sky130_fd_sc_hd__edfxtp_1
Xcpuregs\[22\]\[13\]$_DFFE_PP_ clknet_leaf_7_clk net615 net637
+ VSS VSS VDD VDD cpuregs\[22\]\[13\] sky130_fd_sc_hd__edfxtp_1
Xcpuregs\[22\]\[14\]$_DFFE_PP_ clknet_leaf_38_clk net616 net637
+ VSS VSS VDD VDD cpuregs\[22\]\[14\] sky130_fd_sc_hd__edfxtp_1
Xcpuregs\[22\]\[15\]$_DFFE_PP_ clknet_leaf_29_clk cpuregs_wrdata\[15\]
+ net637 VSS VSS VDD VDD cpuregs\[22\]\[15\] sky130_fd_sc_hd__edfxtp_1
Xcpuregs\[22\]\[16\]$_DFFE_PP_ clknet_leaf_31_clk cpuregs_wrdata\[16\]
+ net637 VSS VSS VDD VDD cpuregs\[22\]\[16\] sky130_fd_sc_hd__edfxtp_1
Xcpuregs\[22\]\[17\]$_DFFE_PP_ clknet_leaf_25_clk cpuregs_wrdata\[17\]
+ net637 VSS VSS VDD VDD cpuregs\[22\]\[17\] sky130_fd_sc_hd__edfxtp_1
Xcpuregs\[22\]\[18\]$_DFFE_PP_ clknet_leaf_12_clk net617 net637
+ VSS VSS VDD VDD cpuregs\[22\]\[18\] sky130_fd_sc_hd__edfxtp_1
Xcpuregs\[22\]\[19\]$_DFFE_PP_ clknet_leaf_27_clk net606 net637
+ VSS VSS VDD VDD cpuregs\[22\]\[19\] sky130_fd_sc_hd__edfxtp_1
Xcpuregs\[22\]\[1\]$_DFFE_PP_ clknet_leaf_149_clk cpuregs_wrdata\[1\]
+ _0846_ VSS VSS VDD VDD cpuregs\[22\]\[1\] sky130_fd_sc_hd__edfxtp_1
Xcpuregs\[22\]\[20\]$_DFFE_PP_ clknet_leaf_54_clk net610 net637
+ VSS VSS VDD VDD cpuregs\[22\]\[20\] sky130_fd_sc_hd__edfxtp_1
Xcpuregs\[22\]\[21\]$_DFFE_PP_ clknet_leaf_41_clk net607 net637
+ VSS VSS VDD VDD cpuregs\[22\]\[21\] sky130_fd_sc_hd__edfxtp_1
Xcpuregs\[22\]\[22\]$_DFFE_PP_ clknet_leaf_52_clk net608 net637
+ VSS VSS VDD VDD cpuregs\[22\]\[22\] sky130_fd_sc_hd__edfxtp_1
Xcpuregs\[22\]\[23\]$_DFFE_PP_ clknet_leaf_55_clk net603 net637
+ VSS VSS VDD VDD cpuregs\[22\]\[23\] sky130_fd_sc_hd__edfxtp_1
Xcpuregs\[22\]\[24\]$_DFFE_PP_ clknet_leaf_59_clk net600 net637
+ VSS VSS VDD VDD cpuregs\[22\]\[24\] sky130_fd_sc_hd__edfxtp_1
Xcpuregs\[22\]\[25\]$_DFFE_PP_ clknet_leaf_62_clk net604 net637
+ VSS VSS VDD VDD cpuregs\[22\]\[25\] sky130_fd_sc_hd__edfxtp_1
Xcpuregs\[22\]\[26\]$_DFFE_PP_ clknet_leaf_62_clk net605 net637
+ VSS VSS VDD VDD cpuregs\[22\]\[26\] sky130_fd_sc_hd__edfxtp_1
Xcpuregs\[22\]\[27\]$_DFFE_PP_ clknet_leaf_44_clk net601 net637
+ VSS VSS VDD VDD cpuregs\[22\]\[27\] sky130_fd_sc_hd__edfxtp_1
Xcpuregs\[22\]\[28\]$_DFFE_PP_ clknet_leaf_69_clk net602 net637
+ VSS VSS VDD VDD cpuregs\[22\]\[28\] sky130_fd_sc_hd__edfxtp_1
Xcpuregs\[22\]\[29\]$_DFFE_PP_ clknet_leaf_71_clk cpuregs_wrdata\[29\]
+ net637 VSS VSS VDD VDD cpuregs\[22\]\[29\] sky130_fd_sc_hd__edfxtp_1
Xcpuregs\[22\]\[2\]$_DFFE_PP_ clknet_leaf_1_clk net672 _0846_
+ VSS VSS VDD VDD cpuregs\[22\]\[2\] sky130_fd_sc_hd__edfxtp_1
Xcpuregs\[22\]\[30\]$_DFFE_PP_ clknet_leaf_147_clk cpuregs_wrdata\[30\]
+ _0846_ VSS VSS VDD VDD cpuregs\[22\]\[30\] sky130_fd_sc_hd__edfxtp_1
Xcpuregs\[22\]\[31\]$_DFFE_PP_ clknet_leaf_18_clk net598 net637
+ VSS VSS VDD VDD cpuregs\[22\]\[31\] sky130_fd_sc_hd__edfxtp_1
Xcpuregs\[22\]\[3\]$_DFFE_PP_ clknet_leaf_155_clk net673 _0846_
+ VSS VSS VDD VDD cpuregs\[22\]\[3\] sky130_fd_sc_hd__edfxtp_1
Xcpuregs\[22\]\[4\]$_DFFE_PP_ clknet_leaf_153_clk net659 _0846_
+ VSS VSS VDD VDD cpuregs\[22\]\[4\] sky130_fd_sc_hd__edfxtp_1
Xcpuregs\[22\]\[5\]$_DFFE_PP_ clknet_leaf_37_clk net674 net637
+ VSS VSS VDD VDD cpuregs\[22\]\[5\] sky130_fd_sc_hd__edfxtp_1
Xcpuregs\[22\]\[6\]$_DFFE_PP_ clknet_leaf_49_clk cpuregs_wrdata\[6\]
+ net637 VSS VSS VDD VDD cpuregs\[22\]\[6\] sky130_fd_sc_hd__edfxtp_1
Xcpuregs\[22\]\[7\]$_DFFE_PP_ clknet_leaf_49_clk cpuregs_wrdata\[7\]
+ net637 VSS VSS VDD VDD cpuregs\[22\]\[7\] sky130_fd_sc_hd__edfxtp_1
Xcpuregs\[22\]\[8\]$_DFFE_PP_ clknet_leaf_35_clk net660 net637
+ VSS VSS VDD VDD cpuregs\[22\]\[8\] sky130_fd_sc_hd__edfxtp_1
Xcpuregs\[22\]\[9\]$_DFFE_PP_ clknet_leaf_6_clk net613 net637
+ VSS VSS VDD VDD cpuregs\[22\]\[9\] sky130_fd_sc_hd__edfxtp_1
Xcpuregs\[23\]\[0\]$_DFFE_PP_ clknet_leaf_21_clk cpuregs_wrdata\[0\]
+ net642 VSS VSS VDD VDD cpuregs\[23\]\[0\] sky130_fd_sc_hd__edfxtp_1
Xcpuregs\[23\]\[10\]$_DFFE_PP_ clknet_leaf_16_clk net654 net642
+ VSS VSS VDD VDD cpuregs\[23\]\[10\] sky130_fd_sc_hd__edfxtp_1
Xcpuregs\[23\]\[11\]$_DFFE_PP_ clknet_leaf_9_clk net614 net642
+ VSS VSS VDD VDD cpuregs\[23\]\[11\] sky130_fd_sc_hd__edfxtp_1
Xcpuregs\[23\]\[12\]$_DFFE_PP_ clknet_leaf_2_clk net655 _0847_
+ VSS VSS VDD VDD cpuregs\[23\]\[12\] sky130_fd_sc_hd__edfxtp_1
Xcpuregs\[23\]\[13\]$_DFFE_PP_ clknet_leaf_7_clk net615 net642
+ VSS VSS VDD VDD cpuregs\[23\]\[13\] sky130_fd_sc_hd__edfxtp_1
Xcpuregs\[23\]\[14\]$_DFFE_PP_ clknet_leaf_38_clk net616 net642
+ VSS VSS VDD VDD cpuregs\[23\]\[14\] sky130_fd_sc_hd__edfxtp_1
Xcpuregs\[23\]\[15\]$_DFFE_PP_ clknet_leaf_29_clk cpuregs_wrdata\[15\]
+ net642 VSS VSS VDD VDD cpuregs\[23\]\[15\] sky130_fd_sc_hd__edfxtp_1
Xcpuregs\[23\]\[16\]$_DFFE_PP_ clknet_leaf_31_clk cpuregs_wrdata\[16\]
+ net642 VSS VSS VDD VDD cpuregs\[23\]\[16\] sky130_fd_sc_hd__edfxtp_1
Xcpuregs\[23\]\[17\]$_DFFE_PP_ clknet_leaf_25_clk cpuregs_wrdata\[17\]
+ net642 VSS VSS VDD VDD cpuregs\[23\]\[17\] sky130_fd_sc_hd__edfxtp_1
Xcpuregs\[23\]\[18\]$_DFFE_PP_ clknet_leaf_12_clk net617 net642
+ VSS VSS VDD VDD cpuregs\[23\]\[18\] sky130_fd_sc_hd__edfxtp_1
Xcpuregs\[23\]\[19\]$_DFFE_PP_ clknet_leaf_20_clk net606 net642
+ VSS VSS VDD VDD cpuregs\[23\]\[19\] sky130_fd_sc_hd__edfxtp_1
Xcpuregs\[23\]\[1\]$_DFFE_PP_ clknet_leaf_150_clk cpuregs_wrdata\[1\]
+ _0847_ VSS VSS VDD VDD cpuregs\[23\]\[1\] sky130_fd_sc_hd__edfxtp_1
Xcpuregs\[23\]\[20\]$_DFFE_PP_ clknet_leaf_54_clk net610 net642
+ VSS VSS VDD VDD cpuregs\[23\]\[20\] sky130_fd_sc_hd__edfxtp_1
Xcpuregs\[23\]\[21\]$_DFFE_PP_ clknet_leaf_40_clk net607 net642
+ VSS VSS VDD VDD cpuregs\[23\]\[21\] sky130_fd_sc_hd__edfxtp_1
Xcpuregs\[23\]\[22\]$_DFFE_PP_ clknet_leaf_52_clk net608 net642
+ VSS VSS VDD VDD cpuregs\[23\]\[22\] sky130_fd_sc_hd__edfxtp_1
Xcpuregs\[23\]\[23\]$_DFFE_PP_ clknet_leaf_55_clk net603 net642
+ VSS VSS VDD VDD cpuregs\[23\]\[23\] sky130_fd_sc_hd__edfxtp_1
Xcpuregs\[23\]\[24\]$_DFFE_PP_ clknet_leaf_59_clk net600 net642
+ VSS VSS VDD VDD cpuregs\[23\]\[24\] sky130_fd_sc_hd__edfxtp_1
Xcpuregs\[23\]\[25\]$_DFFE_PP_ clknet_leaf_62_clk net604 net642
+ VSS VSS VDD VDD cpuregs\[23\]\[25\] sky130_fd_sc_hd__edfxtp_1
Xcpuregs\[23\]\[26\]$_DFFE_PP_ clknet_leaf_61_clk net605 net642
+ VSS VSS VDD VDD cpuregs\[23\]\[26\] sky130_fd_sc_hd__edfxtp_1
Xcpuregs\[23\]\[27\]$_DFFE_PP_ clknet_leaf_45_clk net601 net642
+ VSS VSS VDD VDD cpuregs\[23\]\[27\] sky130_fd_sc_hd__edfxtp_1
Xcpuregs\[23\]\[28\]$_DFFE_PP_ clknet_leaf_69_clk net602 net642
+ VSS VSS VDD VDD cpuregs\[23\]\[28\] sky130_fd_sc_hd__edfxtp_1
Xcpuregs\[23\]\[29\]$_DFFE_PP_ clknet_leaf_71_clk cpuregs_wrdata\[29\]
+ net642 VSS VSS VDD VDD cpuregs\[23\]\[29\] sky130_fd_sc_hd__edfxtp_1
Xcpuregs\[23\]\[2\]$_DFFE_PP_ clknet_leaf_1_clk net672 _0847_
+ VSS VSS VDD VDD cpuregs\[23\]\[2\] sky130_fd_sc_hd__edfxtp_1
Xcpuregs\[23\]\[30\]$_DFFE_PP_ clknet_leaf_146_clk cpuregs_wrdata\[30\]
+ _0847_ VSS VSS VDD VDD cpuregs\[23\]\[30\] sky130_fd_sc_hd__edfxtp_1
Xcpuregs\[23\]\[31\]$_DFFE_PP_ clknet_leaf_18_clk net598 net642
+ VSS VSS VDD VDD cpuregs\[23\]\[31\] sky130_fd_sc_hd__edfxtp_1
Xcpuregs\[23\]\[3\]$_DFFE_PP_ clknet_leaf_155_clk net673 _0847_
+ VSS VSS VDD VDD cpuregs\[23\]\[3\] sky130_fd_sc_hd__edfxtp_1
Xcpuregs\[23\]\[4\]$_DFFE_PP_ clknet_leaf_154_clk net659 _0847_
+ VSS VSS VDD VDD cpuregs\[23\]\[4\] sky130_fd_sc_hd__edfxtp_1
Xcpuregs\[23\]\[5\]$_DFFE_PP_ clknet_leaf_37_clk net674 net642
+ VSS VSS VDD VDD cpuregs\[23\]\[5\] sky130_fd_sc_hd__edfxtp_1
Xcpuregs\[23\]\[6\]$_DFFE_PP_ clknet_leaf_48_clk cpuregs_wrdata\[6\]
+ net642 VSS VSS VDD VDD cpuregs\[23\]\[6\] sky130_fd_sc_hd__edfxtp_1
Xcpuregs\[23\]\[7\]$_DFFE_PP_ clknet_leaf_50_clk cpuregs_wrdata\[7\]
+ net642 VSS VSS VDD VDD cpuregs\[23\]\[7\] sky130_fd_sc_hd__edfxtp_1
Xcpuregs\[23\]\[8\]$_DFFE_PP_ clknet_leaf_34_clk net660 net642
+ VSS VSS VDD VDD cpuregs\[23\]\[8\] sky130_fd_sc_hd__edfxtp_1
Xcpuregs\[23\]\[9\]$_DFFE_PP_ clknet_leaf_6_clk net613 net642
+ VSS VSS VDD VDD cpuregs\[23\]\[9\] sky130_fd_sc_hd__edfxtp_1
Xcpuregs\[24\]\[0\]$_DFFE_PP_ clknet_leaf_22_clk cpuregs_wrdata\[0\]
+ net649 VSS VSS VDD VDD cpuregs\[24\]\[0\] sky130_fd_sc_hd__edfxtp_1
Xcpuregs\[24\]\[10\]$_DFFE_PP_ clknet_leaf_16_clk net654 net649
+ VSS VSS VDD VDD cpuregs\[24\]\[10\] sky130_fd_sc_hd__edfxtp_1
Xcpuregs\[24\]\[11\]$_DFFE_PP_ clknet_leaf_9_clk net614 net649
+ VSS VSS VDD VDD cpuregs\[24\]\[11\] sky130_fd_sc_hd__edfxtp_1
Xcpuregs\[24\]\[12\]$_DFFE_PP_ clknet_leaf_2_clk net655 net649
+ VSS VSS VDD VDD cpuregs\[24\]\[12\] sky130_fd_sc_hd__edfxtp_1
Xcpuregs\[24\]\[13\]$_DFFE_PP_ clknet_leaf_6_clk net615 net649
+ VSS VSS VDD VDD cpuregs\[24\]\[13\] sky130_fd_sc_hd__edfxtp_1
Xcpuregs\[24\]\[14\]$_DFFE_PP_ clknet_leaf_36_clk net616 net649
+ VSS VSS VDD VDD cpuregs\[24\]\[14\] sky130_fd_sc_hd__edfxtp_1
Xcpuregs\[24\]\[15\]$_DFFE_PP_ clknet_leaf_25_clk cpuregs_wrdata\[15\]
+ net649 VSS VSS VDD VDD cpuregs\[24\]\[15\] sky130_fd_sc_hd__edfxtp_1
Xcpuregs\[24\]\[16\]$_DFFE_PP_ clknet_leaf_31_clk cpuregs_wrdata\[16\]
+ net649 VSS VSS VDD VDD cpuregs\[24\]\[16\] sky130_fd_sc_hd__edfxtp_1
Xcpuregs\[24\]\[17\]$_DFFE_PP_ clknet_leaf_24_clk cpuregs_wrdata\[17\]
+ net649 VSS VSS VDD VDD cpuregs\[24\]\[17\] sky130_fd_sc_hd__edfxtp_1
Xcpuregs\[24\]\[18\]$_DFFE_PP_ clknet_leaf_14_clk net617 net649
+ VSS VSS VDD VDD cpuregs\[24\]\[18\] sky130_fd_sc_hd__edfxtp_1
Xcpuregs\[24\]\[19\]$_DFFE_PP_ clknet_leaf_20_clk net606 net649
+ VSS VSS VDD VDD cpuregs\[24\]\[19\] sky130_fd_sc_hd__edfxtp_1
Xcpuregs\[24\]\[1\]$_DFFE_PP_ clknet_leaf_148_clk cpuregs_wrdata\[1\]
+ _0848_ VSS VSS VDD VDD cpuregs\[24\]\[1\] sky130_fd_sc_hd__edfxtp_1
Xcpuregs\[24\]\[20\]$_DFFE_PP_ clknet_leaf_57_clk net610 net649
+ VSS VSS VDD VDD cpuregs\[24\]\[20\] sky130_fd_sc_hd__edfxtp_1
Xcpuregs\[24\]\[21\]$_DFFE_PP_ clknet_leaf_40_clk net607 net649
+ VSS VSS VDD VDD cpuregs\[24\]\[21\] sky130_fd_sc_hd__edfxtp_1
Xcpuregs\[24\]\[22\]$_DFFE_PP_ clknet_leaf_45_clk net608 net649
+ VSS VSS VDD VDD cpuregs\[24\]\[22\] sky130_fd_sc_hd__edfxtp_1
Xcpuregs\[24\]\[23\]$_DFFE_PP_ clknet_leaf_45_clk net603 net649
+ VSS VSS VDD VDD cpuregs\[24\]\[23\] sky130_fd_sc_hd__edfxtp_1
Xcpuregs\[24\]\[24\]$_DFFE_PP_ clknet_leaf_70_clk net600 net649
+ VSS VSS VDD VDD cpuregs\[24\]\[24\] sky130_fd_sc_hd__edfxtp_1
Xcpuregs\[24\]\[25\]$_DFFE_PP_ clknet_leaf_67_clk net604 net649
+ VSS VSS VDD VDD cpuregs\[24\]\[25\] sky130_fd_sc_hd__edfxtp_1
Xcpuregs\[24\]\[26\]$_DFFE_PP_ clknet_leaf_69_clk net605 net649
+ VSS VSS VDD VDD cpuregs\[24\]\[26\] sky130_fd_sc_hd__edfxtp_1
Xcpuregs\[24\]\[27\]$_DFFE_PP_ clknet_leaf_44_clk net601 net649
+ VSS VSS VDD VDD cpuregs\[24\]\[27\] sky130_fd_sc_hd__edfxtp_1
Xcpuregs\[24\]\[28\]$_DFFE_PP_ clknet_leaf_69_clk net602 net649
+ VSS VSS VDD VDD cpuregs\[24\]\[28\] sky130_fd_sc_hd__edfxtp_1
Xcpuregs\[24\]\[29\]$_DFFE_PP_ clknet_leaf_71_clk cpuregs_wrdata\[29\]
+ net649 VSS VSS VDD VDD cpuregs\[24\]\[29\] sky130_fd_sc_hd__edfxtp_1
Xcpuregs\[24\]\[2\]$_DFFE_PP_ clknet_leaf_0_clk net672 net649
+ VSS VSS VDD VDD cpuregs\[24\]\[2\] sky130_fd_sc_hd__edfxtp_1
Xcpuregs\[24\]\[30\]$_DFFE_PP_ clknet_leaf_145_clk cpuregs_wrdata\[30\]
+ net649 VSS VSS VDD VDD cpuregs\[24\]\[30\] sky130_fd_sc_hd__edfxtp_1
Xcpuregs\[24\]\[31\]$_DFFE_PP_ clknet_leaf_144_clk net598
+ net649 VSS VSS VDD VDD cpuregs\[24\]\[31\] sky130_fd_sc_hd__edfxtp_1
Xcpuregs\[24\]\[3\]$_DFFE_PP_ clknet_leaf_17_clk net673 net649
+ VSS VSS VDD VDD cpuregs\[24\]\[3\] sky130_fd_sc_hd__edfxtp_1
Xcpuregs\[24\]\[4\]$_DFFE_PP_ clknet_leaf_145_clk net659 net649
+ VSS VSS VDD VDD cpuregs\[24\]\[4\] sky130_fd_sc_hd__edfxtp_1
Xcpuregs\[24\]\[5\]$_DFFE_PP_ clknet_leaf_10_clk net674 net649
+ VSS VSS VDD VDD cpuregs\[24\]\[5\] sky130_fd_sc_hd__edfxtp_1
Xcpuregs\[24\]\[6\]$_DFFE_PP_ clknet_leaf_41_clk cpuregs_wrdata\[6\]
+ net649 VSS VSS VDD VDD cpuregs\[24\]\[6\] sky130_fd_sc_hd__edfxtp_1
Xcpuregs\[24\]\[7\]$_DFFE_PP_ clknet_leaf_49_clk cpuregs_wrdata\[7\]
+ net649 VSS VSS VDD VDD cpuregs\[24\]\[7\] sky130_fd_sc_hd__edfxtp_1
Xcpuregs\[24\]\[8\]$_DFFE_PP_ clknet_leaf_34_clk net660 net649
+ VSS VSS VDD VDD cpuregs\[24\]\[8\] sky130_fd_sc_hd__edfxtp_1
Xcpuregs\[24\]\[9\]$_DFFE_PP_ clknet_leaf_160_clk net613 net649
+ VSS VSS VDD VDD cpuregs\[24\]\[9\] sky130_fd_sc_hd__edfxtp_1
Xcpuregs\[25\]\[0\]$_DFFE_PP_ clknet_leaf_21_clk cpuregs_wrdata\[0\]
+ net644 VSS VSS VDD VDD cpuregs\[25\]\[0\] sky130_fd_sc_hd__edfxtp_1
Xcpuregs\[25\]\[10\]$_DFFE_PP_ clknet_leaf_16_clk net654 net644
+ VSS VSS VDD VDD cpuregs\[25\]\[10\] sky130_fd_sc_hd__edfxtp_1
Xcpuregs\[25\]\[11\]$_DFFE_PP_ clknet_leaf_9_clk net614 net644
+ VSS VSS VDD VDD cpuregs\[25\]\[11\] sky130_fd_sc_hd__edfxtp_1
Xcpuregs\[25\]\[12\]$_DFFE_PP_ clknet_leaf_1_clk net655 net644
+ VSS VSS VDD VDD cpuregs\[25\]\[12\] sky130_fd_sc_hd__edfxtp_1
Xcpuregs\[25\]\[13\]$_DFFE_PP_ clknet_leaf_6_clk net615 net644
+ VSS VSS VDD VDD cpuregs\[25\]\[13\] sky130_fd_sc_hd__edfxtp_1
Xcpuregs\[25\]\[14\]$_DFFE_PP_ clknet_leaf_39_clk net616 net644
+ VSS VSS VDD VDD cpuregs\[25\]\[14\] sky130_fd_sc_hd__edfxtp_1
Xcpuregs\[25\]\[15\]$_DFFE_PP_ clknet_leaf_28_clk cpuregs_wrdata\[15\]
+ net644 VSS VSS VDD VDD cpuregs\[25\]\[15\] sky130_fd_sc_hd__edfxtp_1
Xcpuregs\[25\]\[16\]$_DFFE_PP_ clknet_leaf_32_clk cpuregs_wrdata\[16\]
+ net644 VSS VSS VDD VDD cpuregs\[25\]\[16\] sky130_fd_sc_hd__edfxtp_1
Xcpuregs\[25\]\[17\]$_DFFE_PP_ clknet_leaf_26_clk cpuregs_wrdata\[17\]
+ net644 VSS VSS VDD VDD cpuregs\[25\]\[17\] sky130_fd_sc_hd__edfxtp_1
Xcpuregs\[25\]\[18\]$_DFFE_PP_ clknet_leaf_14_clk net617 net644
+ VSS VSS VDD VDD cpuregs\[25\]\[18\] sky130_fd_sc_hd__edfxtp_1
Xcpuregs\[25\]\[19\]$_DFFE_PP_ clknet_leaf_20_clk net606 net644
+ VSS VSS VDD VDD cpuregs\[25\]\[19\] sky130_fd_sc_hd__edfxtp_1
Xcpuregs\[25\]\[1\]$_DFFE_PP_ clknet_leaf_148_clk cpuregs_wrdata\[1\]
+ _0849_ VSS VSS VDD VDD cpuregs\[25\]\[1\] sky130_fd_sc_hd__edfxtp_1
Xcpuregs\[25\]\[20\]$_DFFE_PP_ clknet_leaf_57_clk net610 net644
+ VSS VSS VDD VDD cpuregs\[25\]\[20\] sky130_fd_sc_hd__edfxtp_1
Xcpuregs\[25\]\[21\]$_DFFE_PP_ clknet_leaf_40_clk net607 net644
+ VSS VSS VDD VDD cpuregs\[25\]\[21\] sky130_fd_sc_hd__edfxtp_1
Xcpuregs\[25\]\[22\]$_DFFE_PP_ clknet_leaf_46_clk net608 net644
+ VSS VSS VDD VDD cpuregs\[25\]\[22\] sky130_fd_sc_hd__edfxtp_1
Xcpuregs\[25\]\[23\]$_DFFE_PP_ clknet_leaf_45_clk net603 net644
+ VSS VSS VDD VDD cpuregs\[25\]\[23\] sky130_fd_sc_hd__edfxtp_1
Xcpuregs\[25\]\[24\]$_DFFE_PP_ clknet_leaf_70_clk net600 net644
+ VSS VSS VDD VDD cpuregs\[25\]\[24\] sky130_fd_sc_hd__edfxtp_1
Xcpuregs\[25\]\[25\]$_DFFE_PP_ clknet_leaf_68_clk net604 net644
+ VSS VSS VDD VDD cpuregs\[25\]\[25\] sky130_fd_sc_hd__edfxtp_1
Xcpuregs\[25\]\[26\]$_DFFE_PP_ clknet_leaf_69_clk net605 net644
+ VSS VSS VDD VDD cpuregs\[25\]\[26\] sky130_fd_sc_hd__edfxtp_1
Xcpuregs\[25\]\[27\]$_DFFE_PP_ clknet_leaf_44_clk net601 net644
+ VSS VSS VDD VDD cpuregs\[25\]\[27\] sky130_fd_sc_hd__edfxtp_1
Xcpuregs\[25\]\[28\]$_DFFE_PP_ clknet_leaf_69_clk net602 net644
+ VSS VSS VDD VDD cpuregs\[25\]\[28\] sky130_fd_sc_hd__edfxtp_1
Xcpuregs\[25\]\[29\]$_DFFE_PP_ clknet_leaf_71_clk cpuregs_wrdata\[29\]
+ net644 VSS VSS VDD VDD cpuregs\[25\]\[29\] sky130_fd_sc_hd__edfxtp_1
Xcpuregs\[25\]\[2\]$_DFFE_PP_ clknet_leaf_160_clk net672 net644
+ VSS VSS VDD VDD cpuregs\[25\]\[2\] sky130_fd_sc_hd__edfxtp_1
Xcpuregs\[25\]\[30\]$_DFFE_PP_ clknet_leaf_145_clk cpuregs_wrdata\[30\]
+ net644 VSS VSS VDD VDD cpuregs\[25\]\[30\] sky130_fd_sc_hd__edfxtp_1
Xcpuregs\[25\]\[31\]$_DFFE_PP_ clknet_leaf_144_clk net598
+ net644 VSS VSS VDD VDD cpuregs\[25\]\[31\] sky130_fd_sc_hd__edfxtp_1
Xcpuregs\[25\]\[3\]$_DFFE_PP_ clknet_leaf_155_clk net673 net644
+ VSS VSS VDD VDD cpuregs\[25\]\[3\] sky130_fd_sc_hd__edfxtp_1
Xcpuregs\[25\]\[4\]$_DFFE_PP_ clknet_leaf_145_clk net659 net644
+ VSS VSS VDD VDD cpuregs\[25\]\[4\] sky130_fd_sc_hd__edfxtp_1
Xcpuregs\[25\]\[5\]$_DFFE_PP_ clknet_leaf_10_clk net674 net644
+ VSS VSS VDD VDD cpuregs\[25\]\[5\] sky130_fd_sc_hd__edfxtp_1
Xcpuregs\[25\]\[6\]$_DFFE_PP_ clknet_leaf_41_clk cpuregs_wrdata\[6\]
+ net644 VSS VSS VDD VDD cpuregs\[25\]\[6\] sky130_fd_sc_hd__edfxtp_1
Xcpuregs\[25\]\[7\]$_DFFE_PP_ clknet_leaf_49_clk cpuregs_wrdata\[7\]
+ net644 VSS VSS VDD VDD cpuregs\[25\]\[7\] sky130_fd_sc_hd__edfxtp_1
Xcpuregs\[25\]\[8\]$_DFFE_PP_ clknet_leaf_34_clk net660 net644
+ VSS VSS VDD VDD cpuregs\[25\]\[8\] sky130_fd_sc_hd__edfxtp_1
Xcpuregs\[25\]\[9\]$_DFFE_PP_ clknet_leaf_160_clk net613 net644
+ VSS VSS VDD VDD cpuregs\[25\]\[9\] sky130_fd_sc_hd__edfxtp_1
Xcpuregs\[26\]\[0\]$_DFFE_PP_ clknet_leaf_18_clk cpuregs_wrdata\[0\]
+ net639 VSS VSS VDD VDD cpuregs\[26\]\[0\] sky130_fd_sc_hd__edfxtp_1
Xcpuregs\[26\]\[10\]$_DFFE_PP_ clknet_leaf_16_clk net654 net639
+ VSS VSS VDD VDD cpuregs\[26\]\[10\] sky130_fd_sc_hd__edfxtp_1
Xcpuregs\[26\]\[11\]$_DFFE_PP_ clknet_leaf_9_clk net614 net639
+ VSS VSS VDD VDD cpuregs\[26\]\[11\] sky130_fd_sc_hd__edfxtp_1
Xcpuregs\[26\]\[12\]$_DFFE_PP_ clknet_leaf_1_clk net655 net639
+ VSS VSS VDD VDD cpuregs\[26\]\[12\] sky130_fd_sc_hd__edfxtp_1
Xcpuregs\[26\]\[13\]$_DFFE_PP_ clknet_leaf_6_clk net615 net639
+ VSS VSS VDD VDD cpuregs\[26\]\[13\] sky130_fd_sc_hd__edfxtp_1
Xcpuregs\[26\]\[14\]$_DFFE_PP_ clknet_leaf_38_clk net616 net639
+ VSS VSS VDD VDD cpuregs\[26\]\[14\] sky130_fd_sc_hd__edfxtp_1
Xcpuregs\[26\]\[15\]$_DFFE_PP_ clknet_leaf_28_clk cpuregs_wrdata\[15\]
+ net639 VSS VSS VDD VDD cpuregs\[26\]\[15\] sky130_fd_sc_hd__edfxtp_1
Xcpuregs\[26\]\[16\]$_DFFE_PP_ clknet_leaf_31_clk cpuregs_wrdata\[16\]
+ net639 VSS VSS VDD VDD cpuregs\[26\]\[16\] sky130_fd_sc_hd__edfxtp_1
Xcpuregs\[26\]\[17\]$_DFFE_PP_ clknet_leaf_26_clk cpuregs_wrdata\[17\]
+ net639 VSS VSS VDD VDD cpuregs\[26\]\[17\] sky130_fd_sc_hd__edfxtp_1
Xcpuregs\[26\]\[18\]$_DFFE_PP_ clknet_leaf_14_clk net617 net639
+ VSS VSS VDD VDD cpuregs\[26\]\[18\] sky130_fd_sc_hd__edfxtp_1
Xcpuregs\[26\]\[19\]$_DFFE_PP_ clknet_leaf_20_clk net606 net639
+ VSS VSS VDD VDD cpuregs\[26\]\[19\] sky130_fd_sc_hd__edfxtp_1
Xcpuregs\[26\]\[1\]$_DFFE_PP_ clknet_leaf_148_clk cpuregs_wrdata\[1\]
+ net639 VSS VSS VDD VDD cpuregs\[26\]\[1\] sky130_fd_sc_hd__edfxtp_1
Xcpuregs\[26\]\[20\]$_DFFE_PP_ clknet_leaf_56_clk net610 net639
+ VSS VSS VDD VDD cpuregs\[26\]\[20\] sky130_fd_sc_hd__edfxtp_1
Xcpuregs\[26\]\[21\]$_DFFE_PP_ clknet_leaf_40_clk net607 net639
+ VSS VSS VDD VDD cpuregs\[26\]\[21\] sky130_fd_sc_hd__edfxtp_1
Xcpuregs\[26\]\[22\]$_DFFE_PP_ clknet_leaf_46_clk net608 net639
+ VSS VSS VDD VDD cpuregs\[26\]\[22\] sky130_fd_sc_hd__edfxtp_1
Xcpuregs\[26\]\[23\]$_DFFE_PP_ clknet_leaf_45_clk net603 net639
+ VSS VSS VDD VDD cpuregs\[26\]\[23\] sky130_fd_sc_hd__edfxtp_1
Xcpuregs\[26\]\[24\]$_DFFE_PP_ clknet_leaf_57_clk net600 net639
+ VSS VSS VDD VDD cpuregs\[26\]\[24\] sky130_fd_sc_hd__edfxtp_1
Xcpuregs\[26\]\[25\]$_DFFE_PP_ clknet_leaf_68_clk net604 net639
+ VSS VSS VDD VDD cpuregs\[26\]\[25\] sky130_fd_sc_hd__edfxtp_1
Xcpuregs\[26\]\[26\]$_DFFE_PP_ clknet_leaf_68_clk net605 net639
+ VSS VSS VDD VDD cpuregs\[26\]\[26\] sky130_fd_sc_hd__edfxtp_1
Xcpuregs\[26\]\[27\]$_DFFE_PP_ clknet_leaf_44_clk net601 net639
+ VSS VSS VDD VDD cpuregs\[26\]\[27\] sky130_fd_sc_hd__edfxtp_1
Xcpuregs\[26\]\[28\]$_DFFE_PP_ clknet_leaf_69_clk net602 net639
+ VSS VSS VDD VDD cpuregs\[26\]\[28\] sky130_fd_sc_hd__edfxtp_1
Xcpuregs\[26\]\[29\]$_DFFE_PP_ clknet_leaf_71_clk cpuregs_wrdata\[29\]
+ net639 VSS VSS VDD VDD cpuregs\[26\]\[29\] sky130_fd_sc_hd__edfxtp_1
Xcpuregs\[26\]\[2\]$_DFFE_PP_ clknet_leaf_160_clk net672 net639
+ VSS VSS VDD VDD cpuregs\[26\]\[2\] sky130_fd_sc_hd__edfxtp_1
Xcpuregs\[26\]\[30\]$_DFFE_PP_ clknet_leaf_146_clk cpuregs_wrdata\[30\]
+ net639 VSS VSS VDD VDD cpuregs\[26\]\[30\] sky130_fd_sc_hd__edfxtp_1
Xcpuregs\[26\]\[31\]$_DFFE_PP_ clknet_leaf_144_clk net598
+ net639 VSS VSS VDD VDD cpuregs\[26\]\[31\] sky130_fd_sc_hd__edfxtp_1
Xcpuregs\[26\]\[3\]$_DFFE_PP_ clknet_leaf_2_clk net673 net639
+ VSS VSS VDD VDD cpuregs\[26\]\[3\] sky130_fd_sc_hd__edfxtp_1
Xcpuregs\[26\]\[4\]$_DFFE_PP_ clknet_leaf_145_clk net659 net639
+ VSS VSS VDD VDD cpuregs\[26\]\[4\] sky130_fd_sc_hd__edfxtp_1
Xcpuregs\[26\]\[5\]$_DFFE_PP_ clknet_leaf_10_clk net674 net639
+ VSS VSS VDD VDD cpuregs\[26\]\[5\] sky130_fd_sc_hd__edfxtp_1
Xcpuregs\[26\]\[6\]$_DFFE_PP_ clknet_leaf_41_clk cpuregs_wrdata\[6\]
+ net639 VSS VSS VDD VDD cpuregs\[26\]\[6\] sky130_fd_sc_hd__edfxtp_1
Xcpuregs\[26\]\[7\]$_DFFE_PP_ clknet_leaf_49_clk cpuregs_wrdata\[7\]
+ net639 VSS VSS VDD VDD cpuregs\[26\]\[7\] sky130_fd_sc_hd__edfxtp_1
Xcpuregs\[26\]\[8\]$_DFFE_PP_ clknet_leaf_34_clk net660 net639
+ VSS VSS VDD VDD cpuregs\[26\]\[8\] sky130_fd_sc_hd__edfxtp_1
Xcpuregs\[26\]\[9\]$_DFFE_PP_ clknet_leaf_160_clk net613 net639
+ VSS VSS VDD VDD cpuregs\[26\]\[9\] sky130_fd_sc_hd__edfxtp_1
Xcpuregs\[27\]\[0\]$_DFFE_PP_ clknet_leaf_21_clk cpuregs_wrdata\[0\]
+ net634 VSS VSS VDD VDD cpuregs\[27\]\[0\] sky130_fd_sc_hd__edfxtp_1
Xcpuregs\[27\]\[10\]$_DFFE_PP_ clknet_leaf_16_clk net654 net634
+ VSS VSS VDD VDD cpuregs\[27\]\[10\] sky130_fd_sc_hd__edfxtp_1
Xcpuregs\[27\]\[11\]$_DFFE_PP_ clknet_leaf_9_clk net614 net634
+ VSS VSS VDD VDD cpuregs\[27\]\[11\] sky130_fd_sc_hd__edfxtp_1
Xcpuregs\[27\]\[12\]$_DFFE_PP_ clknet_leaf_1_clk net655 net634
+ VSS VSS VDD VDD cpuregs\[27\]\[12\] sky130_fd_sc_hd__edfxtp_1
Xcpuregs\[27\]\[13\]$_DFFE_PP_ clknet_leaf_6_clk net615 net634
+ VSS VSS VDD VDD cpuregs\[27\]\[13\] sky130_fd_sc_hd__edfxtp_1
Xcpuregs\[27\]\[14\]$_DFFE_PP_ clknet_leaf_38_clk net616 net634
+ VSS VSS VDD VDD cpuregs\[27\]\[14\] sky130_fd_sc_hd__edfxtp_1
Xcpuregs\[27\]\[15\]$_DFFE_PP_ clknet_leaf_28_clk cpuregs_wrdata\[15\]
+ net634 VSS VSS VDD VDD cpuregs\[27\]\[15\] sky130_fd_sc_hd__edfxtp_1
Xcpuregs\[27\]\[16\]$_DFFE_PP_ clknet_leaf_31_clk cpuregs_wrdata\[16\]
+ net634 VSS VSS VDD VDD cpuregs\[27\]\[16\] sky130_fd_sc_hd__edfxtp_1
Xcpuregs\[27\]\[17\]$_DFFE_PP_ clknet_leaf_25_clk cpuregs_wrdata\[17\]
+ net634 VSS VSS VDD VDD cpuregs\[27\]\[17\] sky130_fd_sc_hd__edfxtp_1
Xcpuregs\[27\]\[18\]$_DFFE_PP_ clknet_leaf_14_clk net617 net634
+ VSS VSS VDD VDD cpuregs\[27\]\[18\] sky130_fd_sc_hd__edfxtp_1
Xcpuregs\[27\]\[19\]$_DFFE_PP_ clknet_leaf_20_clk net606 net634
+ VSS VSS VDD VDD cpuregs\[27\]\[19\] sky130_fd_sc_hd__edfxtp_1
Xcpuregs\[27\]\[1\]$_DFFE_PP_ clknet_leaf_147_clk cpuregs_wrdata\[1\]
+ net634 VSS VSS VDD VDD cpuregs\[27\]\[1\] sky130_fd_sc_hd__edfxtp_1
Xcpuregs\[27\]\[20\]$_DFFE_PP_ clknet_leaf_57_clk net610 net634
+ VSS VSS VDD VDD cpuregs\[27\]\[20\] sky130_fd_sc_hd__edfxtp_1
Xcpuregs\[27\]\[21\]$_DFFE_PP_ clknet_leaf_40_clk net607 net634
+ VSS VSS VDD VDD cpuregs\[27\]\[21\] sky130_fd_sc_hd__edfxtp_1
Xcpuregs\[27\]\[22\]$_DFFE_PP_ clknet_leaf_46_clk net608 net634
+ VSS VSS VDD VDD cpuregs\[27\]\[22\] sky130_fd_sc_hd__edfxtp_1
Xcpuregs\[27\]\[23\]$_DFFE_PP_ clknet_leaf_45_clk net603 net634
+ VSS VSS VDD VDD cpuregs\[27\]\[23\] sky130_fd_sc_hd__edfxtp_1
Xcpuregs\[27\]\[24\]$_DFFE_PP_ clknet_leaf_70_clk net600 net634
+ VSS VSS VDD VDD cpuregs\[27\]\[24\] sky130_fd_sc_hd__edfxtp_1
Xcpuregs\[27\]\[25\]$_DFFE_PP_ clknet_leaf_68_clk net604 net634
+ VSS VSS VDD VDD cpuregs\[27\]\[25\] sky130_fd_sc_hd__edfxtp_1
Xcpuregs\[27\]\[26\]$_DFFE_PP_ clknet_leaf_68_clk net605 net634
+ VSS VSS VDD VDD cpuregs\[27\]\[26\] sky130_fd_sc_hd__edfxtp_1
Xcpuregs\[27\]\[27\]$_DFFE_PP_ clknet_leaf_44_clk net601 net634
+ VSS VSS VDD VDD cpuregs\[27\]\[27\] sky130_fd_sc_hd__edfxtp_1
Xcpuregs\[27\]\[28\]$_DFFE_PP_ clknet_leaf_69_clk net602 net634
+ VSS VSS VDD VDD cpuregs\[27\]\[28\] sky130_fd_sc_hd__edfxtp_1
Xcpuregs\[27\]\[29\]$_DFFE_PP_ clknet_leaf_71_clk cpuregs_wrdata\[29\]
+ net634 VSS VSS VDD VDD cpuregs\[27\]\[29\] sky130_fd_sc_hd__edfxtp_1
Xcpuregs\[27\]\[2\]$_DFFE_PP_ clknet_leaf_160_clk net672 net634
+ VSS VSS VDD VDD cpuregs\[27\]\[2\] sky130_fd_sc_hd__edfxtp_1
Xcpuregs\[27\]\[30\]$_DFFE_PP_ clknet_leaf_146_clk cpuregs_wrdata\[30\]
+ net634 VSS VSS VDD VDD cpuregs\[27\]\[30\] sky130_fd_sc_hd__edfxtp_1
Xcpuregs\[27\]\[31\]$_DFFE_PP_ clknet_leaf_144_clk net598
+ net634 VSS VSS VDD VDD cpuregs\[27\]\[31\] sky130_fd_sc_hd__edfxtp_1
Xcpuregs\[27\]\[3\]$_DFFE_PP_ clknet_leaf_2_clk net673 net634
+ VSS VSS VDD VDD cpuregs\[27\]\[3\] sky130_fd_sc_hd__edfxtp_1
Xcpuregs\[27\]\[4\]$_DFFE_PP_ clknet_leaf_145_clk net659 net634
+ VSS VSS VDD VDD cpuregs\[27\]\[4\] sky130_fd_sc_hd__edfxtp_1
Xcpuregs\[27\]\[5\]$_DFFE_PP_ clknet_leaf_10_clk net674 net634
+ VSS VSS VDD VDD cpuregs\[27\]\[5\] sky130_fd_sc_hd__edfxtp_1
Xcpuregs\[27\]\[6\]$_DFFE_PP_ clknet_leaf_41_clk cpuregs_wrdata\[6\]
+ net634 VSS VSS VDD VDD cpuregs\[27\]\[6\] sky130_fd_sc_hd__edfxtp_1
Xcpuregs\[27\]\[7\]$_DFFE_PP_ clknet_leaf_49_clk cpuregs_wrdata\[7\]
+ net634 VSS VSS VDD VDD cpuregs\[27\]\[7\] sky130_fd_sc_hd__edfxtp_1
Xcpuregs\[27\]\[8\]$_DFFE_PP_ clknet_leaf_34_clk net660 net634
+ VSS VSS VDD VDD cpuregs\[27\]\[8\] sky130_fd_sc_hd__edfxtp_1
Xcpuregs\[27\]\[9\]$_DFFE_PP_ clknet_leaf_160_clk net613 net634
+ VSS VSS VDD VDD cpuregs\[27\]\[9\] sky130_fd_sc_hd__edfxtp_1
Xcpuregs\[28\]\[0\]$_DFFE_PP_ clknet_leaf_22_clk cpuregs_wrdata\[0\]
+ net629 VSS VSS VDD VDD cpuregs\[28\]\[0\] sky130_fd_sc_hd__edfxtp_1
Xcpuregs\[28\]\[10\]$_DFFE_PP_ clknet_leaf_16_clk net654 net629
+ VSS VSS VDD VDD cpuregs\[28\]\[10\] sky130_fd_sc_hd__edfxtp_1
Xcpuregs\[28\]\[11\]$_DFFE_PP_ clknet_leaf_8_clk net614 net629
+ VSS VSS VDD VDD cpuregs\[28\]\[11\] sky130_fd_sc_hd__edfxtp_1
Xcpuregs\[28\]\[12\]$_DFFE_PP_ clknet_leaf_2_clk net655 net629
+ VSS VSS VDD VDD cpuregs\[28\]\[12\] sky130_fd_sc_hd__edfxtp_1
Xcpuregs\[28\]\[13\]$_DFFE_PP_ clknet_leaf_6_clk net615 net629
+ VSS VSS VDD VDD cpuregs\[28\]\[13\] sky130_fd_sc_hd__edfxtp_1
Xcpuregs\[28\]\[14\]$_DFFE_PP_ clknet_leaf_38_clk net616 net629
+ VSS VSS VDD VDD cpuregs\[28\]\[14\] sky130_fd_sc_hd__edfxtp_1
Xcpuregs\[28\]\[15\]$_DFFE_PP_ clknet_leaf_76_clk cpuregs_wrdata\[15\]
+ net629 VSS VSS VDD VDD cpuregs\[28\]\[15\] sky130_fd_sc_hd__edfxtp_1
Xcpuregs\[28\]\[16\]$_DFFE_PP_ clknet_leaf_31_clk cpuregs_wrdata\[16\]
+ net629 VSS VSS VDD VDD cpuregs\[28\]\[16\] sky130_fd_sc_hd__edfxtp_1
Xcpuregs\[28\]\[17\]$_DFFE_PP_ clknet_leaf_24_clk cpuregs_wrdata\[17\]
+ net629 VSS VSS VDD VDD cpuregs\[28\]\[17\] sky130_fd_sc_hd__edfxtp_1
Xcpuregs\[28\]\[18\]$_DFFE_PP_ clknet_leaf_12_clk net617 net629
+ VSS VSS VDD VDD cpuregs\[28\]\[18\] sky130_fd_sc_hd__edfxtp_1
Xcpuregs\[28\]\[19\]$_DFFE_PP_ clknet_leaf_19_clk net606 net629
+ VSS VSS VDD VDD cpuregs\[28\]\[19\] sky130_fd_sc_hd__edfxtp_1
Xcpuregs\[28\]\[1\]$_DFFE_PP_ clknet_leaf_143_clk cpuregs_wrdata\[1\]
+ _0852_ VSS VSS VDD VDD cpuregs\[28\]\[1\] sky130_fd_sc_hd__edfxtp_1
Xcpuregs\[28\]\[20\]$_DFFE_PP_ clknet_leaf_57_clk net610 net629
+ VSS VSS VDD VDD cpuregs\[28\]\[20\] sky130_fd_sc_hd__edfxtp_1
Xcpuregs\[28\]\[21\]$_DFFE_PP_ clknet_leaf_40_clk net607 net629
+ VSS VSS VDD VDD cpuregs\[28\]\[21\] sky130_fd_sc_hd__edfxtp_1
Xcpuregs\[28\]\[22\]$_DFFE_PP_ clknet_leaf_47_clk net608 net629
+ VSS VSS VDD VDD cpuregs\[28\]\[22\] sky130_fd_sc_hd__edfxtp_1
Xcpuregs\[28\]\[23\]$_DFFE_PP_ clknet_leaf_56_clk net603 net629
+ VSS VSS VDD VDD cpuregs\[28\]\[23\] sky130_fd_sc_hd__edfxtp_1
Xcpuregs\[28\]\[24\]$_DFFE_PP_ clknet_leaf_58_clk net600 net629
+ VSS VSS VDD VDD cpuregs\[28\]\[24\] sky130_fd_sc_hd__edfxtp_1
Xcpuregs\[28\]\[25\]$_DFFE_PP_ clknet_leaf_65_clk net604 net629
+ VSS VSS VDD VDD cpuregs\[28\]\[25\] sky130_fd_sc_hd__edfxtp_1
Xcpuregs\[28\]\[26\]$_DFFE_PP_ clknet_leaf_68_clk net605 net629
+ VSS VSS VDD VDD cpuregs\[28\]\[26\] sky130_fd_sc_hd__edfxtp_1
Xcpuregs\[28\]\[27\]$_DFFE_PP_ clknet_leaf_45_clk net601 net629
+ VSS VSS VDD VDD cpuregs\[28\]\[27\] sky130_fd_sc_hd__edfxtp_1
Xcpuregs\[28\]\[28\]$_DFFE_PP_ clknet_leaf_73_clk net602 net629
+ VSS VSS VDD VDD cpuregs\[28\]\[28\] sky130_fd_sc_hd__edfxtp_1
Xcpuregs\[28\]\[29\]$_DFFE_PP_ clknet_leaf_72_clk cpuregs_wrdata\[29\]
+ net629 VSS VSS VDD VDD cpuregs\[28\]\[29\] sky130_fd_sc_hd__edfxtp_1
Xcpuregs\[28\]\[2\]$_DFFE_PP_ clknet_leaf_1_clk net672 net629
+ VSS VSS VDD VDD cpuregs\[28\]\[2\] sky130_fd_sc_hd__edfxtp_1
Xcpuregs\[28\]\[30\]$_DFFE_PP_ clknet_leaf_145_clk cpuregs_wrdata\[30\]
+ net629 VSS VSS VDD VDD cpuregs\[28\]\[30\] sky130_fd_sc_hd__edfxtp_1
Xcpuregs\[28\]\[31\]$_DFFE_PP_ clknet_leaf_144_clk net598
+ net629 VSS VSS VDD VDD cpuregs\[28\]\[31\] sky130_fd_sc_hd__edfxtp_1
Xcpuregs\[28\]\[3\]$_DFFE_PP_ clknet_leaf_17_clk net673 net629
+ VSS VSS VDD VDD cpuregs\[28\]\[3\] sky130_fd_sc_hd__edfxtp_1
Xcpuregs\[28\]\[4\]$_DFFE_PP_ clknet_leaf_145_clk net659 net629
+ VSS VSS VDD VDD cpuregs\[28\]\[4\] sky130_fd_sc_hd__edfxtp_1
Xcpuregs\[28\]\[5\]$_DFFE_PP_ clknet_leaf_37_clk net674 net629
+ VSS VSS VDD VDD cpuregs\[28\]\[5\] sky130_fd_sc_hd__edfxtp_1
Xcpuregs\[28\]\[6\]$_DFFE_PP_ clknet_leaf_48_clk cpuregs_wrdata\[6\]
+ net629 VSS VSS VDD VDD cpuregs\[28\]\[6\] sky130_fd_sc_hd__edfxtp_1
Xcpuregs\[28\]\[7\]$_DFFE_PP_ clknet_leaf_49_clk cpuregs_wrdata\[7\]
+ net629 VSS VSS VDD VDD cpuregs\[28\]\[7\] sky130_fd_sc_hd__edfxtp_1
Xcpuregs\[28\]\[8\]$_DFFE_PP_ clknet_leaf_13_clk net660 net629
+ VSS VSS VDD VDD cpuregs\[28\]\[8\] sky130_fd_sc_hd__edfxtp_1
Xcpuregs\[28\]\[9\]$_DFFE_PP_ clknet_leaf_160_clk net613 net629
+ VSS VSS VDD VDD cpuregs\[28\]\[9\] sky130_fd_sc_hd__edfxtp_1
Xcpuregs\[29\]\[0\]$_DFFE_PP_ clknet_leaf_22_clk cpuregs_wrdata\[0\]
+ net625 VSS VSS VDD VDD cpuregs\[29\]\[0\] sky130_fd_sc_hd__edfxtp_1
Xcpuregs\[29\]\[10\]$_DFFE_PP_ clknet_leaf_16_clk net654 net625
+ VSS VSS VDD VDD cpuregs\[29\]\[10\] sky130_fd_sc_hd__edfxtp_1
Xcpuregs\[29\]\[11\]$_DFFE_PP_ clknet_leaf_9_clk net614 net625
+ VSS VSS VDD VDD cpuregs\[29\]\[11\] sky130_fd_sc_hd__edfxtp_1
Xcpuregs\[29\]\[12\]$_DFFE_PP_ clknet_leaf_3_clk net655 net625
+ VSS VSS VDD VDD cpuregs\[29\]\[12\] sky130_fd_sc_hd__edfxtp_1
Xcpuregs\[29\]\[13\]$_DFFE_PP_ clknet_leaf_7_clk net615 net625
+ VSS VSS VDD VDD cpuregs\[29\]\[13\] sky130_fd_sc_hd__edfxtp_1
Xcpuregs\[29\]\[14\]$_DFFE_PP_ clknet_leaf_38_clk net616 net625
+ VSS VSS VDD VDD cpuregs\[29\]\[14\] sky130_fd_sc_hd__edfxtp_1
Xcpuregs\[29\]\[15\]$_DFFE_PP_ clknet_leaf_76_clk cpuregs_wrdata\[15\]
+ net625 VSS VSS VDD VDD cpuregs\[29\]\[15\] sky130_fd_sc_hd__edfxtp_1
Xcpuregs\[29\]\[16\]$_DFFE_PP_ clknet_leaf_31_clk cpuregs_wrdata\[16\]
+ net625 VSS VSS VDD VDD cpuregs\[29\]\[16\] sky130_fd_sc_hd__edfxtp_1
Xcpuregs\[29\]\[17\]$_DFFE_PP_ clknet_leaf_24_clk cpuregs_wrdata\[17\]
+ net625 VSS VSS VDD VDD cpuregs\[29\]\[17\] sky130_fd_sc_hd__edfxtp_1
Xcpuregs\[29\]\[18\]$_DFFE_PP_ clknet_leaf_12_clk net617 net625
+ VSS VSS VDD VDD cpuregs\[29\]\[18\] sky130_fd_sc_hd__edfxtp_1
Xcpuregs\[29\]\[19\]$_DFFE_PP_ clknet_leaf_19_clk net606 net625
+ VSS VSS VDD VDD cpuregs\[29\]\[19\] sky130_fd_sc_hd__edfxtp_1
Xcpuregs\[29\]\[1\]$_DFFE_PP_ clknet_leaf_143_clk cpuregs_wrdata\[1\]
+ _0853_ VSS VSS VDD VDD cpuregs\[29\]\[1\] sky130_fd_sc_hd__edfxtp_1
Xcpuregs\[29\]\[20\]$_DFFE_PP_ clknet_leaf_58_clk net610 net625
+ VSS VSS VDD VDD cpuregs\[29\]\[20\] sky130_fd_sc_hd__edfxtp_1
Xcpuregs\[29\]\[21\]$_DFFE_PP_ clknet_leaf_40_clk net607 net625
+ VSS VSS VDD VDD cpuregs\[29\]\[21\] sky130_fd_sc_hd__edfxtp_1
Xcpuregs\[29\]\[22\]$_DFFE_PP_ clknet_leaf_47_clk net608 net625
+ VSS VSS VDD VDD cpuregs\[29\]\[22\] sky130_fd_sc_hd__edfxtp_1
Xcpuregs\[29\]\[23\]$_DFFE_PP_ clknet_leaf_56_clk net603 net625
+ VSS VSS VDD VDD cpuregs\[29\]\[23\] sky130_fd_sc_hd__edfxtp_1
Xcpuregs\[29\]\[24\]$_DFFE_PP_ clknet_leaf_58_clk net600 net625
+ VSS VSS VDD VDD cpuregs\[29\]\[24\] sky130_fd_sc_hd__edfxtp_1
Xcpuregs\[29\]\[25\]$_DFFE_PP_ clknet_leaf_65_clk net604 net625
+ VSS VSS VDD VDD cpuregs\[29\]\[25\] sky130_fd_sc_hd__edfxtp_1
Xcpuregs\[29\]\[26\]$_DFFE_PP_ clknet_leaf_58_clk net605 net625
+ VSS VSS VDD VDD cpuregs\[29\]\[26\] sky130_fd_sc_hd__edfxtp_1
Xcpuregs\[29\]\[27\]$_DFFE_PP_ clknet_leaf_45_clk net601 net625
+ VSS VSS VDD VDD cpuregs\[29\]\[27\] sky130_fd_sc_hd__edfxtp_1
Xcpuregs\[29\]\[28\]$_DFFE_PP_ clknet_leaf_73_clk net602 net625
+ VSS VSS VDD VDD cpuregs\[29\]\[28\] sky130_fd_sc_hd__edfxtp_1
Xcpuregs\[29\]\[29\]$_DFFE_PP_ clknet_leaf_72_clk cpuregs_wrdata\[29\]
+ net625 VSS VSS VDD VDD cpuregs\[29\]\[29\] sky130_fd_sc_hd__edfxtp_1
Xcpuregs\[29\]\[2\]$_DFFE_PP_ clknet_leaf_5_clk net672 net625
+ VSS VSS VDD VDD cpuregs\[29\]\[2\] sky130_fd_sc_hd__edfxtp_1
Xcpuregs\[29\]\[30\]$_DFFE_PP_ clknet_leaf_144_clk cpuregs_wrdata\[30\]
+ net625 VSS VSS VDD VDD cpuregs\[29\]\[30\] sky130_fd_sc_hd__edfxtp_1
Xcpuregs\[29\]\[31\]$_DFFE_PP_ clknet_leaf_144_clk net598
+ net625 VSS VSS VDD VDD cpuregs\[29\]\[31\] sky130_fd_sc_hd__edfxtp_1
Xcpuregs\[29\]\[3\]$_DFFE_PP_ clknet_leaf_17_clk net673 net625
+ VSS VSS VDD VDD cpuregs\[29\]\[3\] sky130_fd_sc_hd__edfxtp_1
Xcpuregs\[29\]\[4\]$_DFFE_PP_ clknet_leaf_145_clk net659 net625
+ VSS VSS VDD VDD cpuregs\[29\]\[4\] sky130_fd_sc_hd__edfxtp_1
Xcpuregs\[29\]\[5\]$_DFFE_PP_ clknet_leaf_37_clk net674 net625
+ VSS VSS VDD VDD cpuregs\[29\]\[5\] sky130_fd_sc_hd__edfxtp_1
Xcpuregs\[29\]\[6\]$_DFFE_PP_ clknet_leaf_41_clk cpuregs_wrdata\[6\]
+ net625 VSS VSS VDD VDD cpuregs\[29\]\[6\] sky130_fd_sc_hd__edfxtp_1
Xcpuregs\[29\]\[7\]$_DFFE_PP_ clknet_leaf_50_clk cpuregs_wrdata\[7\]
+ net625 VSS VSS VDD VDD cpuregs\[29\]\[7\] sky130_fd_sc_hd__edfxtp_1
Xcpuregs\[29\]\[8\]$_DFFE_PP_ clknet_leaf_34_clk net660 net625
+ VSS VSS VDD VDD cpuregs\[29\]\[8\] sky130_fd_sc_hd__edfxtp_1
Xcpuregs\[29\]\[9\]$_DFFE_PP_ clknet_leaf_6_clk net613 net625
+ VSS VSS VDD VDD cpuregs\[29\]\[9\] sky130_fd_sc_hd__edfxtp_1
Xcpuregs\[2\]\[0\]$_DFFE_PP_ clknet_leaf_141_clk cpuregs_wrdata\[0\]
+ net624 VSS VSS VDD VDD cpuregs\[2\]\[0\] sky130_fd_sc_hd__edfxtp_1
Xcpuregs\[2\]\[10\]$_DFFE_PP_ clknet_leaf_19_clk net654 net624
+ VSS VSS VDD VDD cpuregs\[2\]\[10\] sky130_fd_sc_hd__edfxtp_1
Xcpuregs\[2\]\[11\]$_DFFE_PP_ clknet_leaf_11_clk net614 net624
+ VSS VSS VDD VDD cpuregs\[2\]\[11\] sky130_fd_sc_hd__edfxtp_1
Xcpuregs\[2\]\[12\]$_DFFE_PP_ clknet_leaf_157_clk net655 net624
+ VSS VSS VDD VDD cpuregs\[2\]\[12\] sky130_fd_sc_hd__edfxtp_1
Xcpuregs\[2\]\[13\]$_DFFE_PP_ clknet_leaf_15_clk net615 net624
+ VSS VSS VDD VDD cpuregs\[2\]\[13\] sky130_fd_sc_hd__edfxtp_1
Xcpuregs\[2\]\[14\]$_DFFE_PP_ clknet_leaf_35_clk net616 net624
+ VSS VSS VDD VDD cpuregs\[2\]\[14\] sky130_fd_sc_hd__edfxtp_1
Xcpuregs\[2\]\[15\]$_DFFE_PP_ clknet_leaf_75_clk cpuregs_wrdata\[15\]
+ net624 VSS VSS VDD VDD cpuregs\[2\]\[15\] sky130_fd_sc_hd__edfxtp_1
Xcpuregs\[2\]\[16\]$_DFFE_PP_ clknet_leaf_28_clk cpuregs_wrdata\[16\]
+ net624 VSS VSS VDD VDD cpuregs\[2\]\[16\] sky130_fd_sc_hd__edfxtp_1
Xcpuregs\[2\]\[17\]$_DFFE_PP_ clknet_leaf_23_clk cpuregs_wrdata\[17\]
+ net624 VSS VSS VDD VDD cpuregs\[2\]\[17\] sky130_fd_sc_hd__edfxtp_1
Xcpuregs\[2\]\[18\]$_DFFE_PP_ clknet_leaf_13_clk net617 net624
+ VSS VSS VDD VDD cpuregs\[2\]\[18\] sky130_fd_sc_hd__edfxtp_1
Xcpuregs\[2\]\[19\]$_DFFE_PP_ clknet_leaf_26_clk net606 net624
+ VSS VSS VDD VDD cpuregs\[2\]\[19\] sky130_fd_sc_hd__edfxtp_1
Xcpuregs\[2\]\[1\]$_DFFE_PP_ clknet_leaf_149_clk cpuregs_wrdata\[1\]
+ net624 VSS VSS VDD VDD cpuregs\[2\]\[1\] sky130_fd_sc_hd__edfxtp_1
Xcpuregs\[2\]\[20\]$_DFFE_PP_ clknet_leaf_60_clk net610 net624
+ VSS VSS VDD VDD cpuregs\[2\]\[20\] sky130_fd_sc_hd__edfxtp_1
Xcpuregs\[2\]\[21\]$_DFFE_PP_ clknet_leaf_42_clk net607 net624
+ VSS VSS VDD VDD cpuregs\[2\]\[21\] sky130_fd_sc_hd__edfxtp_1
Xcpuregs\[2\]\[22\]$_DFFE_PP_ clknet_leaf_53_clk net608 net624
+ VSS VSS VDD VDD cpuregs\[2\]\[22\] sky130_fd_sc_hd__edfxtp_1
Xcpuregs\[2\]\[23\]$_DFFE_PP_ clknet_leaf_53_clk net603 net624
+ VSS VSS VDD VDD cpuregs\[2\]\[23\] sky130_fd_sc_hd__edfxtp_1
Xcpuregs\[2\]\[24\]$_DFFE_PP_ clknet_leaf_61_clk net600 net624
+ VSS VSS VDD VDD cpuregs\[2\]\[24\] sky130_fd_sc_hd__edfxtp_1
Xcpuregs\[2\]\[25\]$_DFFE_PP_ clknet_leaf_64_clk net604 net624
+ VSS VSS VDD VDD cpuregs\[2\]\[25\] sky130_fd_sc_hd__edfxtp_1
Xcpuregs\[2\]\[26\]$_DFFE_PP_ clknet_leaf_63_clk net605 net624
+ VSS VSS VDD VDD cpuregs\[2\]\[26\] sky130_fd_sc_hd__edfxtp_1
Xcpuregs\[2\]\[27\]$_DFFE_PP_ clknet_leaf_70_clk net601 net624
+ VSS VSS VDD VDD cpuregs\[2\]\[27\] sky130_fd_sc_hd__edfxtp_1
Xcpuregs\[2\]\[28\]$_DFFE_PP_ clknet_leaf_66_clk net602 net624
+ VSS VSS VDD VDD cpuregs\[2\]\[28\] sky130_fd_sc_hd__edfxtp_1
Xcpuregs\[2\]\[29\]$_DFFE_PP_ clknet_leaf_74_clk cpuregs_wrdata\[29\]
+ net624 VSS VSS VDD VDD cpuregs\[2\]\[29\] sky130_fd_sc_hd__edfxtp_1
Xcpuregs\[2\]\[2\]$_DFFE_PP_ clknet_leaf_159_clk net672 net624
+ VSS VSS VDD VDD cpuregs\[2\]\[2\] sky130_fd_sc_hd__edfxtp_1
Xcpuregs\[2\]\[30\]$_DFFE_PP_ clknet_leaf_150_clk cpuregs_wrdata\[30\]
+ net624 VSS VSS VDD VDD cpuregs\[2\]\[30\] sky130_fd_sc_hd__edfxtp_1
Xcpuregs\[2\]\[31\]$_DFFE_PP_ clknet_leaf_142_clk net598 net624
+ VSS VSS VDD VDD cpuregs\[2\]\[31\] sky130_fd_sc_hd__edfxtp_1
Xcpuregs\[2\]\[3\]$_DFFE_PP_ clknet_leaf_152_clk net673 net624
+ VSS VSS VDD VDD cpuregs\[2\]\[3\] sky130_fd_sc_hd__edfxtp_1
Xcpuregs\[2\]\[4\]$_DFFE_PP_ clknet_leaf_151_clk net659 net624
+ VSS VSS VDD VDD cpuregs\[2\]\[4\] sky130_fd_sc_hd__edfxtp_1
Xcpuregs\[2\]\[5\]$_DFFE_PP_ clknet_leaf_36_clk net674 net624
+ VSS VSS VDD VDD cpuregs\[2\]\[5\] sky130_fd_sc_hd__edfxtp_1
Xcpuregs\[2\]\[6\]$_DFFE_PP_ clknet_leaf_47_clk cpuregs_wrdata\[6\]
+ net624 VSS VSS VDD VDD cpuregs\[2\]\[6\] sky130_fd_sc_hd__edfxtp_1
Xcpuregs\[2\]\[7\]$_DFFE_PP_ clknet_leaf_50_clk cpuregs_wrdata\[7\]
+ net624 VSS VSS VDD VDD cpuregs\[2\]\[7\] sky130_fd_sc_hd__edfxtp_1
Xcpuregs\[2\]\[8\]$_DFFE_PP_ clknet_leaf_27_clk net660 net624
+ VSS VSS VDD VDD cpuregs\[2\]\[8\] sky130_fd_sc_hd__edfxtp_1
Xcpuregs\[2\]\[9\]$_DFFE_PP_ clknet_leaf_3_clk net613 net624
+ VSS VSS VDD VDD cpuregs\[2\]\[9\] sky130_fd_sc_hd__edfxtp_1
Xcpuregs\[30\]\[0\]$_DFFE_PP_ clknet_leaf_22_clk cpuregs_wrdata\[0\]
+ net623 VSS VSS VDD VDD cpuregs\[30\]\[0\] sky130_fd_sc_hd__edfxtp_1
Xcpuregs\[30\]\[10\]$_DFFE_PP_ clknet_leaf_15_clk net654 net623
+ VSS VSS VDD VDD cpuregs\[30\]\[10\] sky130_fd_sc_hd__edfxtp_1
Xcpuregs\[30\]\[11\]$_DFFE_PP_ clknet_leaf_9_clk net614 net623
+ VSS VSS VDD VDD cpuregs\[30\]\[11\] sky130_fd_sc_hd__edfxtp_1
Xcpuregs\[30\]\[12\]$_DFFE_PP_ clknet_leaf_3_clk net655 net623
+ VSS VSS VDD VDD cpuregs\[30\]\[12\] sky130_fd_sc_hd__edfxtp_1
Xcpuregs\[30\]\[13\]$_DFFE_PP_ clknet_leaf_7_clk net615 net623
+ VSS VSS VDD VDD cpuregs\[30\]\[13\] sky130_fd_sc_hd__edfxtp_1
Xcpuregs\[30\]\[14\]$_DFFE_PP_ clknet_leaf_38_clk net616 net623
+ VSS VSS VDD VDD cpuregs\[30\]\[14\] sky130_fd_sc_hd__edfxtp_1
Xcpuregs\[30\]\[15\]$_DFFE_PP_ clknet_leaf_76_clk cpuregs_wrdata\[15\]
+ net623 VSS VSS VDD VDD cpuregs\[30\]\[15\] sky130_fd_sc_hd__edfxtp_1
Xcpuregs\[30\]\[16\]$_DFFE_PP_ clknet_leaf_31_clk cpuregs_wrdata\[16\]
+ net623 VSS VSS VDD VDD cpuregs\[30\]\[16\] sky130_fd_sc_hd__edfxtp_1
Xcpuregs\[30\]\[17\]$_DFFE_PP_ clknet_leaf_24_clk cpuregs_wrdata\[17\]
+ net623 VSS VSS VDD VDD cpuregs\[30\]\[17\] sky130_fd_sc_hd__edfxtp_1
Xcpuregs\[30\]\[18\]$_DFFE_PP_ clknet_leaf_12_clk net617 net623
+ VSS VSS VDD VDD cpuregs\[30\]\[18\] sky130_fd_sc_hd__edfxtp_1
Xcpuregs\[30\]\[19\]$_DFFE_PP_ clknet_leaf_19_clk net606 net623
+ VSS VSS VDD VDD cpuregs\[30\]\[19\] sky130_fd_sc_hd__edfxtp_1
Xcpuregs\[30\]\[1\]$_DFFE_PP_ clknet_leaf_143_clk cpuregs_wrdata\[1\]
+ _0855_ VSS VSS VDD VDD cpuregs\[30\]\[1\] sky130_fd_sc_hd__edfxtp_1
Xcpuregs\[30\]\[20\]$_DFFE_PP_ clknet_leaf_56_clk net610 net623
+ VSS VSS VDD VDD cpuregs\[30\]\[20\] sky130_fd_sc_hd__edfxtp_1
Xcpuregs\[30\]\[21\]$_DFFE_PP_ clknet_leaf_40_clk net607 net623
+ VSS VSS VDD VDD cpuregs\[30\]\[21\] sky130_fd_sc_hd__edfxtp_1
Xcpuregs\[30\]\[22\]$_DFFE_PP_ clknet_leaf_46_clk net608 net623
+ VSS VSS VDD VDD cpuregs\[30\]\[22\] sky130_fd_sc_hd__edfxtp_1
Xcpuregs\[30\]\[23\]$_DFFE_PP_ clknet_leaf_56_clk net603 net623
+ VSS VSS VDD VDD cpuregs\[30\]\[23\] sky130_fd_sc_hd__edfxtp_1
Xcpuregs\[30\]\[24\]$_DFFE_PP_ clknet_leaf_58_clk net600 net623
+ VSS VSS VDD VDD cpuregs\[30\]\[24\] sky130_fd_sc_hd__edfxtp_1
Xcpuregs\[30\]\[25\]$_DFFE_PP_ clknet_leaf_68_clk net604 net623
+ VSS VSS VDD VDD cpuregs\[30\]\[25\] sky130_fd_sc_hd__edfxtp_1
Xcpuregs\[30\]\[26\]$_DFFE_PP_ clknet_leaf_68_clk net605 net623
+ VSS VSS VDD VDD cpuregs\[30\]\[26\] sky130_fd_sc_hd__edfxtp_1
Xcpuregs\[30\]\[27\]$_DFFE_PP_ clknet_leaf_45_clk net601 net623
+ VSS VSS VDD VDD cpuregs\[30\]\[27\] sky130_fd_sc_hd__edfxtp_1
Xcpuregs\[30\]\[28\]$_DFFE_PP_ clknet_leaf_69_clk net602 net623
+ VSS VSS VDD VDD cpuregs\[30\]\[28\] sky130_fd_sc_hd__edfxtp_1
Xcpuregs\[30\]\[29\]$_DFFE_PP_ clknet_leaf_72_clk cpuregs_wrdata\[29\]
+ net623 VSS VSS VDD VDD cpuregs\[30\]\[29\] sky130_fd_sc_hd__edfxtp_1
Xcpuregs\[30\]\[2\]$_DFFE_PP_ clknet_leaf_160_clk net672 net623
+ VSS VSS VDD VDD cpuregs\[30\]\[2\] sky130_fd_sc_hd__edfxtp_1
Xcpuregs\[30\]\[30\]$_DFFE_PP_ clknet_leaf_145_clk cpuregs_wrdata\[30\]
+ net623 VSS VSS VDD VDD cpuregs\[30\]\[30\] sky130_fd_sc_hd__edfxtp_1
Xcpuregs\[30\]\[31\]$_DFFE_PP_ clknet_leaf_144_clk net598
+ net623 VSS VSS VDD VDD cpuregs\[30\]\[31\] sky130_fd_sc_hd__edfxtp_1
Xcpuregs\[30\]\[3\]$_DFFE_PP_ clknet_leaf_16_clk net673 net623
+ VSS VSS VDD VDD cpuregs\[30\]\[3\] sky130_fd_sc_hd__edfxtp_1
Xcpuregs\[30\]\[4\]$_DFFE_PP_ clknet_leaf_145_clk net659 net623
+ VSS VSS VDD VDD cpuregs\[30\]\[4\] sky130_fd_sc_hd__edfxtp_1
Xcpuregs\[30\]\[5\]$_DFFE_PP_ clknet_leaf_37_clk net674 net623
+ VSS VSS VDD VDD cpuregs\[30\]\[5\] sky130_fd_sc_hd__edfxtp_1
Xcpuregs\[30\]\[6\]$_DFFE_PP_ clknet_leaf_41_clk cpuregs_wrdata\[6\]
+ net623 VSS VSS VDD VDD cpuregs\[30\]\[6\] sky130_fd_sc_hd__edfxtp_1
Xcpuregs\[30\]\[7\]$_DFFE_PP_ clknet_leaf_49_clk cpuregs_wrdata\[7\]
+ net623 VSS VSS VDD VDD cpuregs\[30\]\[7\] sky130_fd_sc_hd__edfxtp_1
Xcpuregs\[30\]\[8\]$_DFFE_PP_ clknet_leaf_34_clk net660 net623
+ VSS VSS VDD VDD cpuregs\[30\]\[8\] sky130_fd_sc_hd__edfxtp_1
Xcpuregs\[30\]\[9\]$_DFFE_PP_ clknet_leaf_6_clk net613 net623
+ VSS VSS VDD VDD cpuregs\[30\]\[9\] sky130_fd_sc_hd__edfxtp_1
Xcpuregs\[31\]\[0\]$_DFFE_PP_ clknet_leaf_22_clk cpuregs_wrdata\[0\]
+ net645 VSS VSS VDD VDD cpuregs\[31\]\[0\] sky130_fd_sc_hd__edfxtp_1
Xcpuregs\[31\]\[10\]$_DFFE_PP_ clknet_leaf_15_clk net654 net645
+ VSS VSS VDD VDD cpuregs\[31\]\[10\] sky130_fd_sc_hd__edfxtp_1
Xcpuregs\[31\]\[11\]$_DFFE_PP_ clknet_leaf_9_clk net614 net645
+ VSS VSS VDD VDD cpuregs\[31\]\[11\] sky130_fd_sc_hd__edfxtp_1
Xcpuregs\[31\]\[12\]$_DFFE_PP_ clknet_leaf_3_clk net655 net645
+ VSS VSS VDD VDD cpuregs\[31\]\[12\] sky130_fd_sc_hd__edfxtp_1
Xcpuregs\[31\]\[13\]$_DFFE_PP_ clknet_leaf_6_clk net615 net645
+ VSS VSS VDD VDD cpuregs\[31\]\[13\] sky130_fd_sc_hd__edfxtp_1
Xcpuregs\[31\]\[14\]$_DFFE_PP_ clknet_leaf_38_clk net616 net645
+ VSS VSS VDD VDD cpuregs\[31\]\[14\] sky130_fd_sc_hd__edfxtp_1
Xcpuregs\[31\]\[15\]$_DFFE_PP_ clknet_leaf_76_clk cpuregs_wrdata\[15\]
+ net645 VSS VSS VDD VDD cpuregs\[31\]\[15\] sky130_fd_sc_hd__edfxtp_1
Xcpuregs\[31\]\[16\]$_DFFE_PP_ clknet_leaf_31_clk cpuregs_wrdata\[16\]
+ net645 VSS VSS VDD VDD cpuregs\[31\]\[16\] sky130_fd_sc_hd__edfxtp_1
Xcpuregs\[31\]\[17\]$_DFFE_PP_ clknet_leaf_24_clk cpuregs_wrdata\[17\]
+ net645 VSS VSS VDD VDD cpuregs\[31\]\[17\] sky130_fd_sc_hd__edfxtp_1
Xcpuregs\[31\]\[18\]$_DFFE_PP_ clknet_leaf_12_clk net617 net645
+ VSS VSS VDD VDD cpuregs\[31\]\[18\] sky130_fd_sc_hd__edfxtp_1
Xcpuregs\[31\]\[19\]$_DFFE_PP_ clknet_leaf_19_clk net606 net645
+ VSS VSS VDD VDD cpuregs\[31\]\[19\] sky130_fd_sc_hd__edfxtp_1
Xcpuregs\[31\]\[1\]$_DFFE_PP_ clknet_leaf_143_clk cpuregs_wrdata\[1\]
+ _0856_ VSS VSS VDD VDD cpuregs\[31\]\[1\] sky130_fd_sc_hd__edfxtp_1
Xcpuregs\[31\]\[20\]$_DFFE_PP_ clknet_leaf_56_clk net610 net645
+ VSS VSS VDD VDD cpuregs\[31\]\[20\] sky130_fd_sc_hd__edfxtp_1
Xcpuregs\[31\]\[21\]$_DFFE_PP_ clknet_leaf_40_clk net607 net645
+ VSS VSS VDD VDD cpuregs\[31\]\[21\] sky130_fd_sc_hd__edfxtp_1
Xcpuregs\[31\]\[22\]$_DFFE_PP_ clknet_leaf_47_clk net608 net645
+ VSS VSS VDD VDD cpuregs\[31\]\[22\] sky130_fd_sc_hd__edfxtp_1
Xcpuregs\[31\]\[23\]$_DFFE_PP_ clknet_leaf_56_clk net603 net645
+ VSS VSS VDD VDD cpuregs\[31\]\[23\] sky130_fd_sc_hd__edfxtp_1
Xcpuregs\[31\]\[24\]$_DFFE_PP_ clknet_leaf_58_clk net600 net645
+ VSS VSS VDD VDD cpuregs\[31\]\[24\] sky130_fd_sc_hd__edfxtp_1
Xcpuregs\[31\]\[25\]$_DFFE_PP_ clknet_leaf_65_clk net604 net645
+ VSS VSS VDD VDD cpuregs\[31\]\[25\] sky130_fd_sc_hd__edfxtp_1
Xcpuregs\[31\]\[26\]$_DFFE_PP_ clknet_leaf_68_clk net605 net645
+ VSS VSS VDD VDD cpuregs\[31\]\[26\] sky130_fd_sc_hd__edfxtp_1
Xcpuregs\[31\]\[27\]$_DFFE_PP_ clknet_leaf_44_clk net601 net645
+ VSS VSS VDD VDD cpuregs\[31\]\[27\] sky130_fd_sc_hd__edfxtp_1
Xcpuregs\[31\]\[28\]$_DFFE_PP_ clknet_leaf_69_clk net602 net645
+ VSS VSS VDD VDD cpuregs\[31\]\[28\] sky130_fd_sc_hd__edfxtp_1
Xcpuregs\[31\]\[29\]$_DFFE_PP_ clknet_leaf_72_clk cpuregs_wrdata\[29\]
+ net645 VSS VSS VDD VDD cpuregs\[31\]\[29\] sky130_fd_sc_hd__edfxtp_1
Xcpuregs\[31\]\[2\]$_DFFE_PP_ clknet_leaf_0_clk net672 net645
+ VSS VSS VDD VDD cpuregs\[31\]\[2\] sky130_fd_sc_hd__edfxtp_1
Xcpuregs\[31\]\[30\]$_DFFE_PP_ clknet_leaf_144_clk cpuregs_wrdata\[30\]
+ net645 VSS VSS VDD VDD cpuregs\[31\]\[30\] sky130_fd_sc_hd__edfxtp_1
Xcpuregs\[31\]\[31\]$_DFFE_PP_ clknet_leaf_144_clk net598
+ net645 VSS VSS VDD VDD cpuregs\[31\]\[31\] sky130_fd_sc_hd__edfxtp_1
Xcpuregs\[31\]\[3\]$_DFFE_PP_ clknet_leaf_16_clk net673 net645
+ VSS VSS VDD VDD cpuregs\[31\]\[3\] sky130_fd_sc_hd__edfxtp_1
Xcpuregs\[31\]\[4\]$_DFFE_PP_ clknet_leaf_17_clk net659 net645
+ VSS VSS VDD VDD cpuregs\[31\]\[4\] sky130_fd_sc_hd__edfxtp_1
Xcpuregs\[31\]\[5\]$_DFFE_PP_ clknet_leaf_37_clk net674 net645
+ VSS VSS VDD VDD cpuregs\[31\]\[5\] sky130_fd_sc_hd__edfxtp_1
Xcpuregs\[31\]\[6\]$_DFFE_PP_ clknet_leaf_48_clk cpuregs_wrdata\[6\]
+ net645 VSS VSS VDD VDD cpuregs\[31\]\[6\] sky130_fd_sc_hd__edfxtp_1
Xcpuregs\[31\]\[7\]$_DFFE_PP_ clknet_leaf_49_clk cpuregs_wrdata\[7\]
+ net645 VSS VSS VDD VDD cpuregs\[31\]\[7\] sky130_fd_sc_hd__edfxtp_1
Xcpuregs\[31\]\[8\]$_DFFE_PP_ clknet_leaf_34_clk net660 net645
+ VSS VSS VDD VDD cpuregs\[31\]\[8\] sky130_fd_sc_hd__edfxtp_1
Xcpuregs\[31\]\[9\]$_DFFE_PP_ clknet_leaf_160_clk net613 net645
+ VSS VSS VDD VDD cpuregs\[31\]\[9\] sky130_fd_sc_hd__edfxtp_1
Xcpuregs\[3\]\[0\]$_DFFE_PP_ clknet_leaf_141_clk cpuregs_wrdata\[0\]
+ net626 VSS VSS VDD VDD cpuregs\[3\]\[0\] sky130_fd_sc_hd__edfxtp_1
Xcpuregs\[3\]\[10\]$_DFFE_PP_ clknet_leaf_19_clk net654 net626
+ VSS VSS VDD VDD cpuregs\[3\]\[10\] sky130_fd_sc_hd__edfxtp_1
Xcpuregs\[3\]\[11\]$_DFFE_PP_ clknet_leaf_11_clk net614 net626
+ VSS VSS VDD VDD cpuregs\[3\]\[11\] sky130_fd_sc_hd__edfxtp_1
Xcpuregs\[3\]\[12\]$_DFFE_PP_ clknet_leaf_157_clk net655 net626
+ VSS VSS VDD VDD cpuregs\[3\]\[12\] sky130_fd_sc_hd__edfxtp_1
Xcpuregs\[3\]\[13\]$_DFFE_PP_ clknet_leaf_15_clk net615 net626
+ VSS VSS VDD VDD cpuregs\[3\]\[13\] sky130_fd_sc_hd__edfxtp_1
Xcpuregs\[3\]\[14\]$_DFFE_PP_ clknet_leaf_35_clk net616 net626
+ VSS VSS VDD VDD cpuregs\[3\]\[14\] sky130_fd_sc_hd__edfxtp_1
Xcpuregs\[3\]\[15\]$_DFFE_PP_ clknet_leaf_75_clk cpuregs_wrdata\[15\]
+ net626 VSS VSS VDD VDD cpuregs\[3\]\[15\] sky130_fd_sc_hd__edfxtp_1
Xcpuregs\[3\]\[16\]$_DFFE_PP_ clknet_leaf_28_clk cpuregs_wrdata\[16\]
+ net626 VSS VSS VDD VDD cpuregs\[3\]\[16\] sky130_fd_sc_hd__edfxtp_1
Xcpuregs\[3\]\[17\]$_DFFE_PP_ clknet_leaf_23_clk cpuregs_wrdata\[17\]
+ net626 VSS VSS VDD VDD cpuregs\[3\]\[17\] sky130_fd_sc_hd__edfxtp_1
Xcpuregs\[3\]\[18\]$_DFFE_PP_ clknet_leaf_13_clk net617 net626
+ VSS VSS VDD VDD cpuregs\[3\]\[18\] sky130_fd_sc_hd__edfxtp_1
Xcpuregs\[3\]\[19\]$_DFFE_PP_ clknet_leaf_26_clk net606 net626
+ VSS VSS VDD VDD cpuregs\[3\]\[19\] sky130_fd_sc_hd__edfxtp_1
Xcpuregs\[3\]\[1\]$_DFFE_PP_ clknet_leaf_149_clk cpuregs_wrdata\[1\]
+ net626 VSS VSS VDD VDD cpuregs\[3\]\[1\] sky130_fd_sc_hd__edfxtp_1
Xcpuregs\[3\]\[20\]$_DFFE_PP_ clknet_leaf_60_clk net610 net626
+ VSS VSS VDD VDD cpuregs\[3\]\[20\] sky130_fd_sc_hd__edfxtp_1
Xcpuregs\[3\]\[21\]$_DFFE_PP_ clknet_leaf_43_clk net607 net626
+ VSS VSS VDD VDD cpuregs\[3\]\[21\] sky130_fd_sc_hd__edfxtp_1
Xcpuregs\[3\]\[22\]$_DFFE_PP_ clknet_leaf_53_clk net608 net626
+ VSS VSS VDD VDD cpuregs\[3\]\[22\] sky130_fd_sc_hd__edfxtp_1
Xcpuregs\[3\]\[23\]$_DFFE_PP_ clknet_leaf_54_clk net603 net626
+ VSS VSS VDD VDD cpuregs\[3\]\[23\] sky130_fd_sc_hd__edfxtp_1
Xcpuregs\[3\]\[24\]$_DFFE_PP_ clknet_leaf_61_clk net600 net626
+ VSS VSS VDD VDD cpuregs\[3\]\[24\] sky130_fd_sc_hd__edfxtp_1
Xcpuregs\[3\]\[25\]$_DFFE_PP_ clknet_leaf_64_clk net604 net626
+ VSS VSS VDD VDD cpuregs\[3\]\[25\] sky130_fd_sc_hd__edfxtp_1
Xcpuregs\[3\]\[26\]$_DFFE_PP_ clknet_leaf_63_clk net605 net626
+ VSS VSS VDD VDD cpuregs\[3\]\[26\] sky130_fd_sc_hd__edfxtp_1
Xcpuregs\[3\]\[27\]$_DFFE_PP_ clknet_leaf_70_clk net601 net626
+ VSS VSS VDD VDD cpuregs\[3\]\[27\] sky130_fd_sc_hd__edfxtp_1
Xcpuregs\[3\]\[28\]$_DFFE_PP_ clknet_leaf_66_clk net602 net626
+ VSS VSS VDD VDD cpuregs\[3\]\[28\] sky130_fd_sc_hd__edfxtp_1
Xcpuregs\[3\]\[29\]$_DFFE_PP_ clknet_leaf_74_clk cpuregs_wrdata\[29\]
+ net626 VSS VSS VDD VDD cpuregs\[3\]\[29\] sky130_fd_sc_hd__edfxtp_1
Xcpuregs\[3\]\[2\]$_DFFE_PP_ clknet_leaf_159_clk net672 net626
+ VSS VSS VDD VDD cpuregs\[3\]\[2\] sky130_fd_sc_hd__edfxtp_1
Xcpuregs\[3\]\[30\]$_DFFE_PP_ clknet_leaf_150_clk cpuregs_wrdata\[30\]
+ net626 VSS VSS VDD VDD cpuregs\[3\]\[30\] sky130_fd_sc_hd__edfxtp_1
Xcpuregs\[3\]\[31\]$_DFFE_PP_ clknet_leaf_142_clk net598 net626
+ VSS VSS VDD VDD cpuregs\[3\]\[31\] sky130_fd_sc_hd__edfxtp_1
Xcpuregs\[3\]\[3\]$_DFFE_PP_ clknet_leaf_152_clk net673 net626
+ VSS VSS VDD VDD cpuregs\[3\]\[3\] sky130_fd_sc_hd__edfxtp_1
Xcpuregs\[3\]\[4\]$_DFFE_PP_ clknet_leaf_151_clk net659 net626
+ VSS VSS VDD VDD cpuregs\[3\]\[4\] sky130_fd_sc_hd__edfxtp_1
Xcpuregs\[3\]\[5\]$_DFFE_PP_ clknet_leaf_36_clk net674 net626
+ VSS VSS VDD VDD cpuregs\[3\]\[5\] sky130_fd_sc_hd__edfxtp_1
Xcpuregs\[3\]\[6\]$_DFFE_PP_ clknet_leaf_47_clk cpuregs_wrdata\[6\]
+ net626 VSS VSS VDD VDD cpuregs\[3\]\[6\] sky130_fd_sc_hd__edfxtp_1
Xcpuregs\[3\]\[7\]$_DFFE_PP_ clknet_leaf_51_clk cpuregs_wrdata\[7\]
+ net626 VSS VSS VDD VDD cpuregs\[3\]\[7\] sky130_fd_sc_hd__edfxtp_1
Xcpuregs\[3\]\[8\]$_DFFE_PP_ clknet_leaf_28_clk net660 net626
+ VSS VSS VDD VDD cpuregs\[3\]\[8\] sky130_fd_sc_hd__edfxtp_1
Xcpuregs\[3\]\[9\]$_DFFE_PP_ clknet_leaf_3_clk net613 net626
+ VSS VSS VDD VDD cpuregs\[3\]\[9\] sky130_fd_sc_hd__edfxtp_1
Xcpuregs\[4\]\[0\]$_DFFE_PP_ clknet_leaf_23_clk cpuregs_wrdata\[0\]
+ net627 VSS VSS VDD VDD cpuregs\[4\]\[0\] sky130_fd_sc_hd__edfxtp_1
Xcpuregs\[4\]\[10\]$_DFFE_PP_ clknet_leaf_19_clk net654 net627
+ VSS VSS VDD VDD cpuregs\[4\]\[10\] sky130_fd_sc_hd__edfxtp_1
Xcpuregs\[4\]\[11\]$_DFFE_PP_ clknet_leaf_11_clk net614 net627
+ VSS VSS VDD VDD cpuregs\[4\]\[11\] sky130_fd_sc_hd__edfxtp_1
Xcpuregs\[4\]\[12\]$_DFFE_PP_ clknet_leaf_158_clk net655 net627
+ VSS VSS VDD VDD cpuregs\[4\]\[12\] sky130_fd_sc_hd__edfxtp_1
Xcpuregs\[4\]\[13\]$_DFFE_PP_ clknet_leaf_4_clk net615 net627
+ VSS VSS VDD VDD cpuregs\[4\]\[13\] sky130_fd_sc_hd__edfxtp_1
Xcpuregs\[4\]\[14\]$_DFFE_PP_ clknet_leaf_32_clk net616 net627
+ VSS VSS VDD VDD cpuregs\[4\]\[14\] sky130_fd_sc_hd__edfxtp_1
Xcpuregs\[4\]\[15\]$_DFFE_PP_ clknet_leaf_75_clk cpuregs_wrdata\[15\]
+ net627 VSS VSS VDD VDD cpuregs\[4\]\[15\] sky130_fd_sc_hd__edfxtp_1
Xcpuregs\[4\]\[16\]$_DFFE_PP_ clknet_leaf_29_clk cpuregs_wrdata\[16\]
+ net627 VSS VSS VDD VDD cpuregs\[4\]\[16\] sky130_fd_sc_hd__edfxtp_1
Xcpuregs\[4\]\[17\]$_DFFE_PP_ clknet_leaf_77_clk cpuregs_wrdata\[17\]
+ net627 VSS VSS VDD VDD cpuregs\[4\]\[17\] sky130_fd_sc_hd__edfxtp_1
Xcpuregs\[4\]\[18\]$_DFFE_PP_ clknet_leaf_20_clk net617 net627
+ VSS VSS VDD VDD cpuregs\[4\]\[18\] sky130_fd_sc_hd__edfxtp_1
Xcpuregs\[4\]\[19\]$_DFFE_PP_ clknet_leaf_26_clk net606 net627
+ VSS VSS VDD VDD cpuregs\[4\]\[19\] sky130_fd_sc_hd__edfxtp_1
Xcpuregs\[4\]\[1\]$_DFFE_PP_ clknet_leaf_150_clk cpuregs_wrdata\[1\]
+ net627 VSS VSS VDD VDD cpuregs\[4\]\[1\] sky130_fd_sc_hd__edfxtp_1
Xcpuregs\[4\]\[20\]$_DFFE_PP_ clknet_leaf_60_clk net610 net627
+ VSS VSS VDD VDD cpuregs\[4\]\[20\] sky130_fd_sc_hd__edfxtp_1
Xcpuregs\[4\]\[21\]$_DFFE_PP_ clknet_leaf_39_clk net607 net627
+ VSS VSS VDD VDD cpuregs\[4\]\[21\] sky130_fd_sc_hd__edfxtp_1
Xcpuregs\[4\]\[22\]$_DFFE_PP_ clknet_leaf_53_clk net608 net627
+ VSS VSS VDD VDD cpuregs\[4\]\[22\] sky130_fd_sc_hd__edfxtp_1
Xcpuregs\[4\]\[23\]$_DFFE_PP_ clknet_leaf_60_clk net603 net627
+ VSS VSS VDD VDD cpuregs\[4\]\[23\] sky130_fd_sc_hd__edfxtp_1
Xcpuregs\[4\]\[24\]$_DFFE_PP_ clknet_leaf_61_clk net600 net627
+ VSS VSS VDD VDD cpuregs\[4\]\[24\] sky130_fd_sc_hd__edfxtp_1
Xcpuregs\[4\]\[25\]$_DFFE_PP_ clknet_leaf_64_clk net604 net627
+ VSS VSS VDD VDD cpuregs\[4\]\[25\] sky130_fd_sc_hd__edfxtp_1
Xcpuregs\[4\]\[26\]$_DFFE_PP_ clknet_leaf_63_clk net605 net627
+ VSS VSS VDD VDD cpuregs\[4\]\[26\] sky130_fd_sc_hd__edfxtp_1
Xcpuregs\[4\]\[27\]$_DFFE_PP_ clknet_leaf_30_clk net601 net627
+ VSS VSS VDD VDD cpuregs\[4\]\[27\] sky130_fd_sc_hd__edfxtp_1
Xcpuregs\[4\]\[28\]$_DFFE_PP_ clknet_leaf_66_clk net602 net627
+ VSS VSS VDD VDD cpuregs\[4\]\[28\] sky130_fd_sc_hd__edfxtp_1
Xcpuregs\[4\]\[29\]$_DFFE_PP_ clknet_leaf_74_clk cpuregs_wrdata\[29\]
+ net627 VSS VSS VDD VDD cpuregs\[4\]\[29\] sky130_fd_sc_hd__edfxtp_1
Xcpuregs\[4\]\[2\]$_DFFE_PP_ clknet_leaf_159_clk net672 net627
+ VSS VSS VDD VDD cpuregs\[4\]\[2\] sky130_fd_sc_hd__edfxtp_1
Xcpuregs\[4\]\[30\]$_DFFE_PP_ clknet_leaf_151_clk cpuregs_wrdata\[30\]
+ net627 VSS VSS VDD VDD cpuregs\[4\]\[30\] sky130_fd_sc_hd__edfxtp_1
Xcpuregs\[4\]\[31\]$_DFFE_PP_ clknet_leaf_142_clk net598 net627
+ VSS VSS VDD VDD cpuregs\[4\]\[31\] sky130_fd_sc_hd__edfxtp_1
Xcpuregs\[4\]\[3\]$_DFFE_PP_ clknet_leaf_158_clk net673 net627
+ VSS VSS VDD VDD cpuregs\[4\]\[3\] sky130_fd_sc_hd__edfxtp_1
Xcpuregs\[4\]\[4\]$_DFFE_PP_ clknet_leaf_151_clk net659 net627
+ VSS VSS VDD VDD cpuregs\[4\]\[4\] sky130_fd_sc_hd__edfxtp_1
Xcpuregs\[4\]\[5\]$_DFFE_PP_ clknet_leaf_36_clk net674 net627
+ VSS VSS VDD VDD cpuregs\[4\]\[5\] sky130_fd_sc_hd__edfxtp_1
Xcpuregs\[4\]\[6\]$_DFFE_PP_ clknet_leaf_45_clk cpuregs_wrdata\[6\]
+ net627 VSS VSS VDD VDD cpuregs\[4\]\[6\] sky130_fd_sc_hd__edfxtp_1
Xcpuregs\[4\]\[7\]$_DFFE_PP_ clknet_leaf_52_clk cpuregs_wrdata\[7\]
+ net627 VSS VSS VDD VDD cpuregs\[4\]\[7\] sky130_fd_sc_hd__edfxtp_1
Xcpuregs\[4\]\[8\]$_DFFE_PP_ clknet_leaf_27_clk net660 net627
+ VSS VSS VDD VDD cpuregs\[4\]\[8\] sky130_fd_sc_hd__edfxtp_1
Xcpuregs\[4\]\[9\]$_DFFE_PP_ clknet_leaf_4_clk net613 net627
+ VSS VSS VDD VDD cpuregs\[4\]\[9\] sky130_fd_sc_hd__edfxtp_1
Xcpuregs\[5\]\[0\]$_DFFE_PP_ clknet_leaf_23_clk cpuregs_wrdata\[0\]
+ net628 VSS VSS VDD VDD cpuregs\[5\]\[0\] sky130_fd_sc_hd__edfxtp_1
Xcpuregs\[5\]\[10\]$_DFFE_PP_ clknet_leaf_18_clk net654 net628
+ VSS VSS VDD VDD cpuregs\[5\]\[10\] sky130_fd_sc_hd__edfxtp_1
Xcpuregs\[5\]\[11\]$_DFFE_PP_ clknet_leaf_11_clk net614 net628
+ VSS VSS VDD VDD cpuregs\[5\]\[11\] sky130_fd_sc_hd__edfxtp_1
Xcpuregs\[5\]\[12\]$_DFFE_PP_ clknet_leaf_157_clk net655 net628
+ VSS VSS VDD VDD cpuregs\[5\]\[12\] sky130_fd_sc_hd__edfxtp_1
Xcpuregs\[5\]\[13\]$_DFFE_PP_ clknet_leaf_8_clk net615 net628
+ VSS VSS VDD VDD cpuregs\[5\]\[13\] sky130_fd_sc_hd__edfxtp_1
Xcpuregs\[5\]\[14\]$_DFFE_PP_ clknet_leaf_32_clk net616 net628
+ VSS VSS VDD VDD cpuregs\[5\]\[14\] sky130_fd_sc_hd__edfxtp_1
Xcpuregs\[5\]\[15\]$_DFFE_PP_ clknet_leaf_72_clk cpuregs_wrdata\[15\]
+ net628 VSS VSS VDD VDD cpuregs\[5\]\[15\] sky130_fd_sc_hd__edfxtp_1
Xcpuregs\[5\]\[16\]$_DFFE_PP_ clknet_leaf_29_clk cpuregs_wrdata\[16\]
+ net628 VSS VSS VDD VDD cpuregs\[5\]\[16\] sky130_fd_sc_hd__edfxtp_1
Xcpuregs\[5\]\[17\]$_DFFE_PP_ clknet_leaf_77_clk cpuregs_wrdata\[17\]
+ net628 VSS VSS VDD VDD cpuregs\[5\]\[17\] sky130_fd_sc_hd__edfxtp_1
Xcpuregs\[5\]\[18\]$_DFFE_PP_ clknet_leaf_34_clk net617 net628
+ VSS VSS VDD VDD cpuregs\[5\]\[18\] sky130_fd_sc_hd__edfxtp_1
Xcpuregs\[5\]\[19\]$_DFFE_PP_ clknet_leaf_26_clk net606 net628
+ VSS VSS VDD VDD cpuregs\[5\]\[19\] sky130_fd_sc_hd__edfxtp_1
Xcpuregs\[5\]\[1\]$_DFFE_PP_ clknet_leaf_150_clk cpuregs_wrdata\[1\]
+ net628 VSS VSS VDD VDD cpuregs\[5\]\[1\] sky130_fd_sc_hd__edfxtp_1
Xcpuregs\[5\]\[20\]$_DFFE_PP_ clknet_leaf_60_clk net610 net628
+ VSS VSS VDD VDD cpuregs\[5\]\[20\] sky130_fd_sc_hd__edfxtp_1
Xcpuregs\[5\]\[21\]$_DFFE_PP_ clknet_leaf_42_clk net607 net628
+ VSS VSS VDD VDD cpuregs\[5\]\[21\] sky130_fd_sc_hd__edfxtp_1
Xcpuregs\[5\]\[22\]$_DFFE_PP_ clknet_leaf_52_clk net608 net628
+ VSS VSS VDD VDD cpuregs\[5\]\[22\] sky130_fd_sc_hd__edfxtp_1
Xcpuregs\[5\]\[23\]$_DFFE_PP_ clknet_leaf_54_clk net603 net628
+ VSS VSS VDD VDD cpuregs\[5\]\[23\] sky130_fd_sc_hd__edfxtp_1
Xcpuregs\[5\]\[24\]$_DFFE_PP_ clknet_leaf_61_clk net600 net628
+ VSS VSS VDD VDD cpuregs\[5\]\[24\] sky130_fd_sc_hd__edfxtp_1
Xcpuregs\[5\]\[25\]$_DFFE_PP_ clknet_leaf_64_clk net604 net628
+ VSS VSS VDD VDD cpuregs\[5\]\[25\] sky130_fd_sc_hd__edfxtp_1
Xcpuregs\[5\]\[26\]$_DFFE_PP_ clknet_leaf_63_clk net605 net628
+ VSS VSS VDD VDD cpuregs\[5\]\[26\] sky130_fd_sc_hd__edfxtp_1
Xcpuregs\[5\]\[27\]$_DFFE_PP_ clknet_leaf_30_clk net601 net628
+ VSS VSS VDD VDD cpuregs\[5\]\[27\] sky130_fd_sc_hd__edfxtp_1
Xcpuregs\[5\]\[28\]$_DFFE_PP_ clknet_leaf_67_clk net602 net628
+ VSS VSS VDD VDD cpuregs\[5\]\[28\] sky130_fd_sc_hd__edfxtp_1
Xcpuregs\[5\]\[29\]$_DFFE_PP_ clknet_leaf_73_clk cpuregs_wrdata\[29\]
+ net628 VSS VSS VDD VDD cpuregs\[5\]\[29\] sky130_fd_sc_hd__edfxtp_1
Xcpuregs\[5\]\[2\]$_DFFE_PP_ clknet_leaf_159_clk net672 net628
+ VSS VSS VDD VDD cpuregs\[5\]\[2\] sky130_fd_sc_hd__edfxtp_1
Xcpuregs\[5\]\[30\]$_DFFE_PP_ clknet_leaf_151_clk cpuregs_wrdata\[30\]
+ net628 VSS VSS VDD VDD cpuregs\[5\]\[30\] sky130_fd_sc_hd__edfxtp_1
Xcpuregs\[5\]\[31\]$_DFFE_PP_ clknet_leaf_142_clk net598 net628
+ VSS VSS VDD VDD cpuregs\[5\]\[31\] sky130_fd_sc_hd__edfxtp_1
Xcpuregs\[5\]\[3\]$_DFFE_PP_ clknet_leaf_158_clk net673 net628
+ VSS VSS VDD VDD cpuregs\[5\]\[3\] sky130_fd_sc_hd__edfxtp_1
Xcpuregs\[5\]\[4\]$_DFFE_PP_ clknet_leaf_152_clk net659 net628
+ VSS VSS VDD VDD cpuregs\[5\]\[4\] sky130_fd_sc_hd__edfxtp_1
Xcpuregs\[5\]\[5\]$_DFFE_PP_ clknet_leaf_36_clk net674 net628
+ VSS VSS VDD VDD cpuregs\[5\]\[5\] sky130_fd_sc_hd__edfxtp_1
Xcpuregs\[5\]\[6\]$_DFFE_PP_ clknet_leaf_44_clk cpuregs_wrdata\[6\]
+ net628 VSS VSS VDD VDD cpuregs\[5\]\[6\] sky130_fd_sc_hd__edfxtp_1
Xcpuregs\[5\]\[7\]$_DFFE_PP_ clknet_leaf_51_clk cpuregs_wrdata\[7\]
+ net628 VSS VSS VDD VDD cpuregs\[5\]\[7\] sky130_fd_sc_hd__edfxtp_1
Xcpuregs\[5\]\[8\]$_DFFE_PP_ clknet_leaf_33_clk net660 net628
+ VSS VSS VDD VDD cpuregs\[5\]\[8\] sky130_fd_sc_hd__edfxtp_1
Xcpuregs\[5\]\[9\]$_DFFE_PP_ clknet_leaf_4_clk net613 net628
+ VSS VSS VDD VDD cpuregs\[5\]\[9\] sky130_fd_sc_hd__edfxtp_1
Xcpuregs\[6\]\[0\]$_DFFE_PP_ clknet_leaf_22_clk cpuregs_wrdata\[0\]
+ net630 VSS VSS VDD VDD cpuregs\[6\]\[0\] sky130_fd_sc_hd__edfxtp_1
Xcpuregs\[6\]\[10\]$_DFFE_PP_ clknet_leaf_18_clk net654 net630
+ VSS VSS VDD VDD cpuregs\[6\]\[10\] sky130_fd_sc_hd__edfxtp_1
Xcpuregs\[6\]\[11\]$_DFFE_PP_ clknet_leaf_8_clk net614 net630
+ VSS VSS VDD VDD cpuregs\[6\]\[11\] sky130_fd_sc_hd__edfxtp_1
Xcpuregs\[6\]\[12\]$_DFFE_PP_ clknet_leaf_157_clk net655 net630
+ VSS VSS VDD VDD cpuregs\[6\]\[12\] sky130_fd_sc_hd__edfxtp_1
Xcpuregs\[6\]\[13\]$_DFFE_PP_ clknet_leaf_7_clk net615 net630
+ VSS VSS VDD VDD cpuregs\[6\]\[13\] sky130_fd_sc_hd__edfxtp_1
Xcpuregs\[6\]\[14\]$_DFFE_PP_ clknet_leaf_39_clk net616 net630
+ VSS VSS VDD VDD cpuregs\[6\]\[14\] sky130_fd_sc_hd__edfxtp_1
Xcpuregs\[6\]\[15\]$_DFFE_PP_ clknet_leaf_72_clk cpuregs_wrdata\[15\]
+ net630 VSS VSS VDD VDD cpuregs\[6\]\[15\] sky130_fd_sc_hd__edfxtp_1
Xcpuregs\[6\]\[16\]$_DFFE_PP_ clknet_leaf_29_clk cpuregs_wrdata\[16\]
+ net630 VSS VSS VDD VDD cpuregs\[6\]\[16\] sky130_fd_sc_hd__edfxtp_1
Xcpuregs\[6\]\[17\]$_DFFE_PP_ clknet_leaf_77_clk cpuregs_wrdata\[17\]
+ net630 VSS VSS VDD VDD cpuregs\[6\]\[17\] sky130_fd_sc_hd__edfxtp_1
Xcpuregs\[6\]\[18\]$_DFFE_PP_ clknet_leaf_13_clk net617 net630
+ VSS VSS VDD VDD cpuregs\[6\]\[18\] sky130_fd_sc_hd__edfxtp_1
Xcpuregs\[6\]\[19\]$_DFFE_PP_ clknet_leaf_26_clk net606 net630
+ VSS VSS VDD VDD cpuregs\[6\]\[19\] sky130_fd_sc_hd__edfxtp_1
Xcpuregs\[6\]\[1\]$_DFFE_PP_ clknet_leaf_150_clk cpuregs_wrdata\[1\]
+ net630 VSS VSS VDD VDD cpuregs\[6\]\[1\] sky130_fd_sc_hd__edfxtp_1
Xcpuregs\[6\]\[20\]$_DFFE_PP_ clknet_leaf_60_clk net610 net630
+ VSS VSS VDD VDD cpuregs\[6\]\[20\] sky130_fd_sc_hd__edfxtp_1
Xcpuregs\[6\]\[21\]$_DFFE_PP_ clknet_leaf_42_clk net607 net630
+ VSS VSS VDD VDD cpuregs\[6\]\[21\] sky130_fd_sc_hd__edfxtp_1
Xcpuregs\[6\]\[22\]$_DFFE_PP_ clknet_leaf_52_clk net608 net630
+ VSS VSS VDD VDD cpuregs\[6\]\[22\] sky130_fd_sc_hd__edfxtp_1
Xcpuregs\[6\]\[23\]$_DFFE_PP_ clknet_leaf_53_clk net603 net630
+ VSS VSS VDD VDD cpuregs\[6\]\[23\] sky130_fd_sc_hd__edfxtp_1
Xcpuregs\[6\]\[24\]$_DFFE_PP_ clknet_leaf_61_clk net600 net630
+ VSS VSS VDD VDD cpuregs\[6\]\[24\] sky130_fd_sc_hd__edfxtp_1
Xcpuregs\[6\]\[25\]$_DFFE_PP_ clknet_leaf_64_clk net604 net630
+ VSS VSS VDD VDD cpuregs\[6\]\[25\] sky130_fd_sc_hd__edfxtp_1
Xcpuregs\[6\]\[26\]$_DFFE_PP_ clknet_leaf_63_clk net605 net630
+ VSS VSS VDD VDD cpuregs\[6\]\[26\] sky130_fd_sc_hd__edfxtp_1
Xcpuregs\[6\]\[27\]$_DFFE_PP_ clknet_leaf_30_clk net601 net630
+ VSS VSS VDD VDD cpuregs\[6\]\[27\] sky130_fd_sc_hd__edfxtp_1
Xcpuregs\[6\]\[28\]$_DFFE_PP_ clknet_leaf_67_clk net602 net630
+ VSS VSS VDD VDD cpuregs\[6\]\[28\] sky130_fd_sc_hd__edfxtp_1
Xcpuregs\[6\]\[29\]$_DFFE_PP_ clknet_leaf_73_clk cpuregs_wrdata\[29\]
+ net630 VSS VSS VDD VDD cpuregs\[6\]\[29\] sky130_fd_sc_hd__edfxtp_1
Xcpuregs\[6\]\[2\]$_DFFE_PP_ clknet_leaf_159_clk net672 net630
+ VSS VSS VDD VDD cpuregs\[6\]\[2\] sky130_fd_sc_hd__edfxtp_1
Xcpuregs\[6\]\[30\]$_DFFE_PP_ clknet_leaf_151_clk cpuregs_wrdata\[30\]
+ net630 VSS VSS VDD VDD cpuregs\[6\]\[30\] sky130_fd_sc_hd__edfxtp_1
Xcpuregs\[6\]\[31\]$_DFFE_PP_ clknet_leaf_143_clk net598 net630
+ VSS VSS VDD VDD cpuregs\[6\]\[31\] sky130_fd_sc_hd__edfxtp_1
Xcpuregs\[6\]\[3\]$_DFFE_PP_ clknet_leaf_158_clk net673 net630
+ VSS VSS VDD VDD cpuregs\[6\]\[3\] sky130_fd_sc_hd__edfxtp_1
Xcpuregs\[6\]\[4\]$_DFFE_PP_ clknet_leaf_152_clk net659 net630
+ VSS VSS VDD VDD cpuregs\[6\]\[4\] sky130_fd_sc_hd__edfxtp_1
Xcpuregs\[6\]\[5\]$_DFFE_PP_ clknet_leaf_37_clk net674 net630
+ VSS VSS VDD VDD cpuregs\[6\]\[5\] sky130_fd_sc_hd__edfxtp_1
Xcpuregs\[6\]\[6\]$_DFFE_PP_ clknet_leaf_44_clk cpuregs_wrdata\[6\]
+ net630 VSS VSS VDD VDD cpuregs\[6\]\[6\] sky130_fd_sc_hd__edfxtp_1
Xcpuregs\[6\]\[7\]$_DFFE_PP_ clknet_leaf_51_clk cpuregs_wrdata\[7\]
+ net630 VSS VSS VDD VDD cpuregs\[6\]\[7\] sky130_fd_sc_hd__edfxtp_1
Xcpuregs\[6\]\[8\]$_DFFE_PP_ clknet_leaf_33_clk net660 net630
+ VSS VSS VDD VDD cpuregs\[6\]\[8\] sky130_fd_sc_hd__edfxtp_1
Xcpuregs\[6\]\[9\]$_DFFE_PP_ clknet_leaf_4_clk net613 net630
+ VSS VSS VDD VDD cpuregs\[6\]\[9\] sky130_fd_sc_hd__edfxtp_1
Xcpuregs\[7\]\[0\]$_DFFE_PP_ clknet_leaf_23_clk cpuregs_wrdata\[0\]
+ net631 VSS VSS VDD VDD cpuregs\[7\]\[0\] sky130_fd_sc_hd__edfxtp_1
Xcpuregs\[7\]\[10\]$_DFFE_PP_ clknet_leaf_18_clk net654 net631
+ VSS VSS VDD VDD cpuregs\[7\]\[10\] sky130_fd_sc_hd__edfxtp_1
Xcpuregs\[7\]\[11\]$_DFFE_PP_ clknet_leaf_10_clk net614 net631
+ VSS VSS VDD VDD cpuregs\[7\]\[11\] sky130_fd_sc_hd__edfxtp_1
Xcpuregs\[7\]\[12\]$_DFFE_PP_ clknet_leaf_157_clk net655 net631
+ VSS VSS VDD VDD cpuregs\[7\]\[12\] sky130_fd_sc_hd__edfxtp_1
Xcpuregs\[7\]\[13\]$_DFFE_PP_ clknet_leaf_7_clk net615 net631
+ VSS VSS VDD VDD cpuregs\[7\]\[13\] sky130_fd_sc_hd__edfxtp_1
Xcpuregs\[7\]\[14\]$_DFFE_PP_ clknet_leaf_43_clk net616 net631
+ VSS VSS VDD VDD cpuregs\[7\]\[14\] sky130_fd_sc_hd__edfxtp_1
Xcpuregs\[7\]\[15\]$_DFFE_PP_ clknet_leaf_75_clk cpuregs_wrdata\[15\]
+ net631 VSS VSS VDD VDD cpuregs\[7\]\[15\] sky130_fd_sc_hd__edfxtp_1
Xcpuregs\[7\]\[16\]$_DFFE_PP_ clknet_leaf_29_clk cpuregs_wrdata\[16\]
+ net631 VSS VSS VDD VDD cpuregs\[7\]\[16\] sky130_fd_sc_hd__edfxtp_1
Xcpuregs\[7\]\[17\]$_DFFE_PP_ clknet_leaf_77_clk cpuregs_wrdata\[17\]
+ net631 VSS VSS VDD VDD cpuregs\[7\]\[17\] sky130_fd_sc_hd__edfxtp_1
Xcpuregs\[7\]\[18\]$_DFFE_PP_ clknet_leaf_13_clk net617 net631
+ VSS VSS VDD VDD cpuregs\[7\]\[18\] sky130_fd_sc_hd__edfxtp_1
Xcpuregs\[7\]\[19\]$_DFFE_PP_ clknet_leaf_27_clk net606 net631
+ VSS VSS VDD VDD cpuregs\[7\]\[19\] sky130_fd_sc_hd__edfxtp_1
Xcpuregs\[7\]\[1\]$_DFFE_PP_ clknet_leaf_150_clk cpuregs_wrdata\[1\]
+ net631 VSS VSS VDD VDD cpuregs\[7\]\[1\] sky130_fd_sc_hd__edfxtp_1
Xcpuregs\[7\]\[20\]$_DFFE_PP_ clknet_leaf_60_clk net610 net631
+ VSS VSS VDD VDD cpuregs\[7\]\[20\] sky130_fd_sc_hd__edfxtp_1
Xcpuregs\[7\]\[21\]$_DFFE_PP_ clknet_leaf_39_clk net607 net631
+ VSS VSS VDD VDD cpuregs\[7\]\[21\] sky130_fd_sc_hd__edfxtp_1
Xcpuregs\[7\]\[22\]$_DFFE_PP_ clknet_leaf_52_clk net608 net631
+ VSS VSS VDD VDD cpuregs\[7\]\[22\] sky130_fd_sc_hd__edfxtp_1
Xcpuregs\[7\]\[23\]$_DFFE_PP_ clknet_leaf_53_clk net603 net631
+ VSS VSS VDD VDD cpuregs\[7\]\[23\] sky130_fd_sc_hd__edfxtp_1
Xcpuregs\[7\]\[24\]$_DFFE_PP_ clknet_leaf_60_clk net600 net631
+ VSS VSS VDD VDD cpuregs\[7\]\[24\] sky130_fd_sc_hd__edfxtp_1
Xcpuregs\[7\]\[25\]$_DFFE_PP_ clknet_leaf_64_clk net604 net631
+ VSS VSS VDD VDD cpuregs\[7\]\[25\] sky130_fd_sc_hd__edfxtp_1
Xcpuregs\[7\]\[26\]$_DFFE_PP_ clknet_leaf_62_clk net605 net631
+ VSS VSS VDD VDD cpuregs\[7\]\[26\] sky130_fd_sc_hd__edfxtp_1
Xcpuregs\[7\]\[27\]$_DFFE_PP_ clknet_leaf_30_clk net601 net631
+ VSS VSS VDD VDD cpuregs\[7\]\[27\] sky130_fd_sc_hd__edfxtp_1
Xcpuregs\[7\]\[28\]$_DFFE_PP_ clknet_leaf_67_clk net602 net631
+ VSS VSS VDD VDD cpuregs\[7\]\[28\] sky130_fd_sc_hd__edfxtp_1
Xcpuregs\[7\]\[29\]$_DFFE_PP_ clknet_leaf_73_clk cpuregs_wrdata\[29\]
+ net631 VSS VSS VDD VDD cpuregs\[7\]\[29\] sky130_fd_sc_hd__edfxtp_1
Xcpuregs\[7\]\[2\]$_DFFE_PP_ clknet_leaf_159_clk net672 net631
+ VSS VSS VDD VDD cpuregs\[7\]\[2\] sky130_fd_sc_hd__edfxtp_1
Xcpuregs\[7\]\[30\]$_DFFE_PP_ clknet_leaf_151_clk cpuregs_wrdata\[30\]
+ net631 VSS VSS VDD VDD cpuregs\[7\]\[30\] sky130_fd_sc_hd__edfxtp_1
Xcpuregs\[7\]\[31\]$_DFFE_PP_ clknet_leaf_142_clk net598 net631
+ VSS VSS VDD VDD cpuregs\[7\]\[31\] sky130_fd_sc_hd__edfxtp_1
Xcpuregs\[7\]\[3\]$_DFFE_PP_ clknet_leaf_158_clk net673 net631
+ VSS VSS VDD VDD cpuregs\[7\]\[3\] sky130_fd_sc_hd__edfxtp_1
Xcpuregs\[7\]\[4\]$_DFFE_PP_ clknet_leaf_152_clk net659 net631
+ VSS VSS VDD VDD cpuregs\[7\]\[4\] sky130_fd_sc_hd__edfxtp_1
Xcpuregs\[7\]\[5\]$_DFFE_PP_ clknet_leaf_36_clk net674 net631
+ VSS VSS VDD VDD cpuregs\[7\]\[5\] sky130_fd_sc_hd__edfxtp_1
Xcpuregs\[7\]\[6\]$_DFFE_PP_ clknet_leaf_44_clk cpuregs_wrdata\[6\]
+ net631 VSS VSS VDD VDD cpuregs\[7\]\[6\] sky130_fd_sc_hd__edfxtp_1
Xcpuregs\[7\]\[7\]$_DFFE_PP_ clknet_leaf_51_clk cpuregs_wrdata\[7\]
+ net631 VSS VSS VDD VDD cpuregs\[7\]\[7\] sky130_fd_sc_hd__edfxtp_1
Xcpuregs\[7\]\[8\]$_DFFE_PP_ clknet_leaf_33_clk net660 net631
+ VSS VSS VDD VDD cpuregs\[7\]\[8\] sky130_fd_sc_hd__edfxtp_1
Xcpuregs\[7\]\[9\]$_DFFE_PP_ clknet_leaf_4_clk net613 net631
+ VSS VSS VDD VDD cpuregs\[7\]\[9\] sky130_fd_sc_hd__edfxtp_1
Xcpuregs\[8\]\[0\]$_DFFE_PP_ clknet_leaf_141_clk cpuregs_wrdata\[0\]
+ net632 VSS VSS VDD VDD cpuregs\[8\]\[0\] sky130_fd_sc_hd__edfxtp_1
Xcpuregs\[8\]\[10\]$_DFFE_PP_ clknet_leaf_18_clk net654 net632
+ VSS VSS VDD VDD cpuregs\[8\]\[10\] sky130_fd_sc_hd__edfxtp_1
Xcpuregs\[8\]\[11\]$_DFFE_PP_ clknet_leaf_12_clk net614 net632
+ VSS VSS VDD VDD cpuregs\[8\]\[11\] sky130_fd_sc_hd__edfxtp_1
Xcpuregs\[8\]\[12\]$_DFFE_PP_ clknet_leaf_155_clk net655 _0862_
+ VSS VSS VDD VDD cpuregs\[8\]\[12\] sky130_fd_sc_hd__edfxtp_1
Xcpuregs\[8\]\[13\]$_DFFE_PP_ clknet_leaf_4_clk net615 net632
+ VSS VSS VDD VDD cpuregs\[8\]\[13\] sky130_fd_sc_hd__edfxtp_1
Xcpuregs\[8\]\[14\]$_DFFE_PP_ clknet_leaf_36_clk net616 net632
+ VSS VSS VDD VDD cpuregs\[8\]\[14\] sky130_fd_sc_hd__edfxtp_1
Xcpuregs\[8\]\[15\]$_DFFE_PP_ clknet_leaf_77_clk cpuregs_wrdata\[15\]
+ net632 VSS VSS VDD VDD cpuregs\[8\]\[15\] sky130_fd_sc_hd__edfxtp_1
Xcpuregs\[8\]\[16\]$_DFFE_PP_ clknet_leaf_33_clk cpuregs_wrdata\[16\]
+ net632 VSS VSS VDD VDD cpuregs\[8\]\[16\] sky130_fd_sc_hd__edfxtp_1
Xcpuregs\[8\]\[17\]$_DFFE_PP_ clknet_leaf_23_clk cpuregs_wrdata\[17\]
+ net632 VSS VSS VDD VDD cpuregs\[8\]\[17\] sky130_fd_sc_hd__edfxtp_1
Xcpuregs\[8\]\[18\]$_DFFE_PP_ clknet_leaf_14_clk net617 net632
+ VSS VSS VDD VDD cpuregs\[8\]\[18\] sky130_fd_sc_hd__edfxtp_1
Xcpuregs\[8\]\[19\]$_DFFE_PP_ clknet_leaf_21_clk net606 net632
+ VSS VSS VDD VDD cpuregs\[8\]\[19\] sky130_fd_sc_hd__edfxtp_1
Xcpuregs\[8\]\[1\]$_DFFE_PP_ clknet_leaf_149_clk cpuregs_wrdata\[1\]
+ _0862_ VSS VSS VDD VDD cpuregs\[8\]\[1\] sky130_fd_sc_hd__edfxtp_1
Xcpuregs\[8\]\[20\]$_DFFE_PP_ clknet_leaf_57_clk net610 net632
+ VSS VSS VDD VDD cpuregs\[8\]\[20\] sky130_fd_sc_hd__edfxtp_1
Xcpuregs\[8\]\[21\]$_DFFE_PP_ clknet_leaf_31_clk net607 net632
+ VSS VSS VDD VDD cpuregs\[8\]\[21\] sky130_fd_sc_hd__edfxtp_1
Xcpuregs\[8\]\[22\]$_DFFE_PP_ clknet_leaf_46_clk net608 net632
+ VSS VSS VDD VDD cpuregs\[8\]\[22\] sky130_fd_sc_hd__edfxtp_1
Xcpuregs\[8\]\[23\]$_DFFE_PP_ clknet_leaf_57_clk net603 net632
+ VSS VSS VDD VDD cpuregs\[8\]\[23\] sky130_fd_sc_hd__edfxtp_1
Xcpuregs\[8\]\[24\]$_DFFE_PP_ clknet_leaf_69_clk net600 net632
+ VSS VSS VDD VDD cpuregs\[8\]\[24\] sky130_fd_sc_hd__edfxtp_1
Xcpuregs\[8\]\[25\]$_DFFE_PP_ clknet_leaf_66_clk net604 net632
+ VSS VSS VDD VDD cpuregs\[8\]\[25\] sky130_fd_sc_hd__edfxtp_1
Xcpuregs\[8\]\[26\]$_DFFE_PP_ clknet_leaf_66_clk net605 net632
+ VSS VSS VDD VDD cpuregs\[8\]\[26\] sky130_fd_sc_hd__edfxtp_1
Xcpuregs\[8\]\[27\]$_DFFE_PP_ clknet_leaf_30_clk net601 net632
+ VSS VSS VDD VDD cpuregs\[8\]\[27\] sky130_fd_sc_hd__edfxtp_1
Xcpuregs\[8\]\[28\]$_DFFE_PP_ clknet_leaf_82_clk net602 net632
+ VSS VSS VDD VDD cpuregs\[8\]\[28\] sky130_fd_sc_hd__edfxtp_1
Xcpuregs\[8\]\[29\]$_DFFE_PP_ clknet_leaf_74_clk cpuregs_wrdata\[29\]
+ net632 VSS VSS VDD VDD cpuregs\[8\]\[29\] sky130_fd_sc_hd__edfxtp_1
Xcpuregs\[8\]\[2\]$_DFFE_PP_ clknet_leaf_155_clk net672 _0862_
+ VSS VSS VDD VDD cpuregs\[8\]\[2\] sky130_fd_sc_hd__edfxtp_1
Xcpuregs\[8\]\[30\]$_DFFE_PP_ clknet_leaf_147_clk cpuregs_wrdata\[30\]
+ _0862_ VSS VSS VDD VDD cpuregs\[8\]\[30\] sky130_fd_sc_hd__edfxtp_1
Xcpuregs\[8\]\[31\]$_DFFE_PP_ clknet_leaf_143_clk net598 _0862_
+ VSS VSS VDD VDD cpuregs\[8\]\[31\] sky130_fd_sc_hd__edfxtp_1
Xcpuregs\[8\]\[3\]$_DFFE_PP_ clknet_leaf_154_clk net673 _0862_
+ VSS VSS VDD VDD cpuregs\[8\]\[3\] sky130_fd_sc_hd__edfxtp_1
Xcpuregs\[8\]\[4\]$_DFFE_PP_ clknet_leaf_153_clk net659 _0862_
+ VSS VSS VDD VDD cpuregs\[8\]\[4\] sky130_fd_sc_hd__edfxtp_1
Xcpuregs\[8\]\[5\]$_DFFE_PP_ clknet_leaf_11_clk net674 net632
+ VSS VSS VDD VDD cpuregs\[8\]\[5\] sky130_fd_sc_hd__edfxtp_1
Xcpuregs\[8\]\[6\]$_DFFE_PP_ clknet_leaf_43_clk cpuregs_wrdata\[6\]
+ net632 VSS VSS VDD VDD cpuregs\[8\]\[6\] sky130_fd_sc_hd__edfxtp_1
Xcpuregs\[8\]\[7\]$_DFFE_PP_ clknet_leaf_46_clk cpuregs_wrdata\[7\]
+ net632 VSS VSS VDD VDD cpuregs\[8\]\[7\] sky130_fd_sc_hd__edfxtp_1
Xcpuregs\[8\]\[8\]$_DFFE_PP_ clknet_leaf_27_clk net660 net632
+ VSS VSS VDD VDD cpuregs\[8\]\[8\] sky130_fd_sc_hd__edfxtp_1
Xcpuregs\[8\]\[9\]$_DFFE_PP_ clknet_leaf_3_clk net613 net632
+ VSS VSS VDD VDD cpuregs\[8\]\[9\] sky130_fd_sc_hd__edfxtp_1
Xcpuregs\[9\]\[0\]$_DFFE_PP_ clknet_leaf_23_clk cpuregs_wrdata\[0\]
+ net633 VSS VSS VDD VDD cpuregs\[9\]\[0\] sky130_fd_sc_hd__edfxtp_1
Xcpuregs\[9\]\[10\]$_DFFE_PP_ clknet_leaf_17_clk net654 net633
+ VSS VSS VDD VDD cpuregs\[9\]\[10\] sky130_fd_sc_hd__edfxtp_1
Xcpuregs\[9\]\[11\]$_DFFE_PP_ clknet_leaf_11_clk net614 net633
+ VSS VSS VDD VDD cpuregs\[9\]\[11\] sky130_fd_sc_hd__edfxtp_1
Xcpuregs\[9\]\[12\]$_DFFE_PP_ clknet_leaf_156_clk net655 _0863_
+ VSS VSS VDD VDD cpuregs\[9\]\[12\] sky130_fd_sc_hd__edfxtp_1
Xcpuregs\[9\]\[13\]$_DFFE_PP_ clknet_leaf_4_clk net615 net633
+ VSS VSS VDD VDD cpuregs\[9\]\[13\] sky130_fd_sc_hd__edfxtp_1
Xcpuregs\[9\]\[14\]$_DFFE_PP_ clknet_leaf_36_clk net616 net633
+ VSS VSS VDD VDD cpuregs\[9\]\[14\] sky130_fd_sc_hd__edfxtp_1
Xcpuregs\[9\]\[15\]$_DFFE_PP_ clknet_leaf_75_clk cpuregs_wrdata\[15\]
+ net633 VSS VSS VDD VDD cpuregs\[9\]\[15\] sky130_fd_sc_hd__edfxtp_1
Xcpuregs\[9\]\[16\]$_DFFE_PP_ clknet_leaf_33_clk cpuregs_wrdata\[16\]
+ net633 VSS VSS VDD VDD cpuregs\[9\]\[16\] sky130_fd_sc_hd__edfxtp_1
Xcpuregs\[9\]\[17\]$_DFFE_PP_ clknet_leaf_24_clk cpuregs_wrdata\[17\]
+ net633 VSS VSS VDD VDD cpuregs\[9\]\[17\] sky130_fd_sc_hd__edfxtp_1
Xcpuregs\[9\]\[18\]$_DFFE_PP_ clknet_leaf_14_clk net617 net633
+ VSS VSS VDD VDD cpuregs\[9\]\[18\] sky130_fd_sc_hd__edfxtp_1
Xcpuregs\[9\]\[19\]$_DFFE_PP_ clknet_leaf_20_clk net606 net633
+ VSS VSS VDD VDD cpuregs\[9\]\[19\] sky130_fd_sc_hd__edfxtp_1
Xcpuregs\[9\]\[1\]$_DFFE_PP_ clknet_leaf_148_clk cpuregs_wrdata\[1\]
+ _0863_ VSS VSS VDD VDD cpuregs\[9\]\[1\] sky130_fd_sc_hd__edfxtp_1
Xcpuregs\[9\]\[20\]$_DFFE_PP_ clknet_leaf_57_clk net610 net633
+ VSS VSS VDD VDD cpuregs\[9\]\[20\] sky130_fd_sc_hd__edfxtp_1
Xcpuregs\[9\]\[21\]$_DFFE_PP_ clknet_leaf_43_clk net607 net633
+ VSS VSS VDD VDD cpuregs\[9\]\[21\] sky130_fd_sc_hd__edfxtp_1
Xcpuregs\[9\]\[22\]$_DFFE_PP_ clknet_leaf_46_clk net608 net633
+ VSS VSS VDD VDD cpuregs\[9\]\[22\] sky130_fd_sc_hd__edfxtp_1
Xcpuregs\[9\]\[23\]$_DFFE_PP_ clknet_leaf_56_clk net603 net633
+ VSS VSS VDD VDD cpuregs\[9\]\[23\] sky130_fd_sc_hd__edfxtp_1
Xcpuregs\[9\]\[24\]$_DFFE_PP_ clknet_leaf_57_clk net600 net633
+ VSS VSS VDD VDD cpuregs\[9\]\[24\] sky130_fd_sc_hd__edfxtp_1
Xcpuregs\[9\]\[25\]$_DFFE_PP_ clknet_leaf_66_clk net604 net633
+ VSS VSS VDD VDD cpuregs\[9\]\[25\] sky130_fd_sc_hd__edfxtp_1
Xcpuregs\[9\]\[26\]$_DFFE_PP_ clknet_leaf_66_clk net605 net633
+ VSS VSS VDD VDD cpuregs\[9\]\[26\] sky130_fd_sc_hd__edfxtp_1
Xcpuregs\[9\]\[27\]$_DFFE_PP_ clknet_leaf_30_clk net601 net633
+ VSS VSS VDD VDD cpuregs\[9\]\[27\] sky130_fd_sc_hd__edfxtp_1
Xcpuregs\[9\]\[28\]$_DFFE_PP_ clknet_leaf_74_clk net602 net633
+ VSS VSS VDD VDD cpuregs\[9\]\[28\] sky130_fd_sc_hd__edfxtp_1
Xcpuregs\[9\]\[29\]$_DFFE_PP_ clknet_leaf_74_clk cpuregs_wrdata\[29\]
+ net633 VSS VSS VDD VDD cpuregs\[9\]\[29\] sky130_fd_sc_hd__edfxtp_1
Xcpuregs\[9\]\[2\]$_DFFE_PP_ clknet_leaf_1_clk net672 _0863_
+ VSS VSS VDD VDD cpuregs\[9\]\[2\] sky130_fd_sc_hd__edfxtp_1
Xcpuregs\[9\]\[30\]$_DFFE_PP_ clknet_leaf_147_clk cpuregs_wrdata\[30\]
+ _0863_ VSS VSS VDD VDD cpuregs\[9\]\[30\] sky130_fd_sc_hd__edfxtp_1
Xcpuregs\[9\]\[31\]$_DFFE_PP_ clknet_leaf_142_clk net598 net633
+ VSS VSS VDD VDD cpuregs\[9\]\[31\] sky130_fd_sc_hd__edfxtp_1
Xcpuregs\[9\]\[3\]$_DFFE_PP_ clknet_leaf_154_clk net673 _0863_
+ VSS VSS VDD VDD cpuregs\[9\]\[3\] sky130_fd_sc_hd__edfxtp_1
Xcpuregs\[9\]\[4\]$_DFFE_PP_ clknet_leaf_153_clk net659 _0863_
+ VSS VSS VDD VDD cpuregs\[9\]\[4\] sky130_fd_sc_hd__edfxtp_1
Xcpuregs\[9\]\[5\]$_DFFE_PP_ clknet_leaf_11_clk net674 net633
+ VSS VSS VDD VDD cpuregs\[9\]\[5\] sky130_fd_sc_hd__edfxtp_1
Xcpuregs\[9\]\[6\]$_DFFE_PP_ clknet_leaf_42_clk cpuregs_wrdata\[6\]
+ net633 VSS VSS VDD VDD cpuregs\[9\]\[6\] sky130_fd_sc_hd__edfxtp_1
Xcpuregs\[9\]\[7\]$_DFFE_PP_ clknet_leaf_46_clk cpuregs_wrdata\[7\]
+ net633 VSS VSS VDD VDD cpuregs\[9\]\[7\] sky130_fd_sc_hd__edfxtp_1
Xcpuregs\[9\]\[8\]$_DFFE_PP_ clknet_leaf_27_clk net660 net633
+ VSS VSS VDD VDD cpuregs\[9\]\[8\] sky130_fd_sc_hd__edfxtp_1
Xcpuregs\[9\]\[9\]$_DFFE_PP_ clknet_leaf_3_clk net613 _0863_
+ VSS VSS VDD VDD cpuregs\[9\]\[9\] sky130_fd_sc_hd__edfxtp_1
Xdecoded_imm\[0\]$_DFFE_PP_ clknet_leaf_117_clk _4628_ _0812_
+ VSS VSS VDD VDD decoded_imm\[0\] sky130_fd_sc_hd__edfxtp_1
Xdecoded_imm\[10\]$_SDFFCE_PN0P_ clknet_leaf_103_clk _0559_
+ net680 VSS VSS VDD VDD decoded_imm\[10\] sky130_fd_sc_hd__edfxtp_1
Xdecoded_imm\[11\]$_SDFFCE_PN0P_ clknet_leaf_135_clk _0558_
+ _0812_ VSS VSS VDD VDD decoded_imm\[11\] sky130_fd_sc_hd__edfxtp_1
Xdecoded_imm\[12\]$_SDFFCE_PN0P_ clknet_leaf_102_clk _0557_
+ net680 VSS VSS VDD VDD decoded_imm\[12\] sky130_fd_sc_hd__edfxtp_1
Xdecoded_imm\[13\]$_SDFFCE_PN0P_ clknet_leaf_102_clk _0556_
+ net680 VSS VSS VDD VDD decoded_imm\[13\] sky130_fd_sc_hd__edfxtp_1
Xdecoded_imm\[14\]$_SDFFCE_PN0P_ clknet_leaf_102_clk _0555_
+ net680 VSS VSS VDD VDD decoded_imm\[14\] sky130_fd_sc_hd__edfxtp_1
Xdecoded_imm\[15\]$_SDFFCE_PN0P_ clknet_leaf_102_clk _0554_
+ net680 VSS VSS VDD VDD decoded_imm\[15\] sky130_fd_sc_hd__edfxtp_1
Xdecoded_imm\[16\]$_SDFFCE_PN0P_ clknet_leaf_101_clk _0553_
+ net680 VSS VSS VDD VDD decoded_imm\[16\] sky130_fd_sc_hd__edfxtp_1
Xdecoded_imm\[17\]$_SDFFCE_PN0P_ clknet_leaf_101_clk _0552_
+ net680 VSS VSS VDD VDD decoded_imm\[17\] sky130_fd_sc_hd__edfxtp_1
Xdecoded_imm\[18\]$_SDFFCE_PN0P_ clknet_leaf_101_clk _0551_
+ net680 VSS VSS VDD VDD decoded_imm\[18\] sky130_fd_sc_hd__edfxtp_1
Xdecoded_imm\[19\]$_SDFFCE_PN0P_ clknet_leaf_105_clk _0550_
+ net680 VSS VSS VDD VDD decoded_imm\[19\] sky130_fd_sc_hd__edfxtp_1
Xdecoded_imm\[1\]$_SDFFCE_PN0P_ clknet_leaf_135_clk _0568_
+ _0812_ VSS VSS VDD VDD decoded_imm\[1\] sky130_fd_sc_hd__edfxtp_1
Xdecoded_imm\[20\]$_SDFFCE_PN0P_ clknet_leaf_98_clk _0549_
+ net680 VSS VSS VDD VDD decoded_imm\[20\] sky130_fd_sc_hd__edfxtp_1
Xdecoded_imm\[21\]$_SDFFCE_PN0P_ clknet_leaf_109_clk _0548_
+ net680 VSS VSS VDD VDD decoded_imm\[21\] sky130_fd_sc_hd__edfxtp_1
Xdecoded_imm\[22\]$_SDFFCE_PN0P_ clknet_leaf_109_clk _0547_
+ net680 VSS VSS VDD VDD decoded_imm\[22\] sky130_fd_sc_hd__edfxtp_1
Xdecoded_imm\[23\]$_SDFFCE_PN0P_ clknet_leaf_109_clk _0546_
+ net680 VSS VSS VDD VDD decoded_imm\[23\] sky130_fd_sc_hd__edfxtp_1
Xdecoded_imm\[24\]$_SDFFCE_PN0P_ clknet_leaf_105_clk _0545_
+ net680 VSS VSS VDD VDD decoded_imm\[24\] sky130_fd_sc_hd__edfxtp_1
Xdecoded_imm\[25\]$_SDFFCE_PN0P_ clknet_leaf_109_clk _0544_
+ net680 VSS VSS VDD VDD decoded_imm\[25\] sky130_fd_sc_hd__edfxtp_1
Xdecoded_imm\[26\]$_SDFFCE_PN0P_ clknet_leaf_98_clk _0543_
+ net680 VSS VSS VDD VDD decoded_imm\[26\] sky130_fd_sc_hd__edfxtp_1
Xdecoded_imm\[27\]$_SDFFCE_PN0P_ clknet_leaf_97_clk _0542_
+ net680 VSS VSS VDD VDD decoded_imm\[27\] sky130_fd_sc_hd__edfxtp_1
Xdecoded_imm\[28\]$_SDFFCE_PN0P_ clknet_leaf_98_clk _0541_
+ net680 VSS VSS VDD VDD decoded_imm\[28\] sky130_fd_sc_hd__edfxtp_1
Xdecoded_imm\[29\]$_SDFFCE_PN0P_ clknet_leaf_98_clk _0540_
+ net680 VSS VSS VDD VDD decoded_imm\[29\] sky130_fd_sc_hd__edfxtp_1
Xdecoded_imm\[2\]$_SDFFCE_PN0P_ clknet_leaf_137_clk _0567_
+ _0812_ VSS VSS VDD VDD decoded_imm\[2\] sky130_fd_sc_hd__edfxtp_1
Xdecoded_imm\[30\]$_SDFFCE_PN0P_ clknet_leaf_109_clk _0539_
+ net680 VSS VSS VDD VDD decoded_imm\[30\] sky130_fd_sc_hd__edfxtp_1
Xdecoded_imm\[31\]$_SDFFCE_PN0P_ clknet_leaf_109_clk _0801_
+ net680 VSS VSS VDD VDD decoded_imm\[31\] sky130_fd_sc_hd__edfxtp_1
Xdecoded_imm\[3\]$_SDFFCE_PN0P_ clknet_leaf_135_clk _0566_
+ _0812_ VSS VSS VDD VDD decoded_imm\[3\] sky130_fd_sc_hd__edfxtp_1
Xdecoded_imm\[4\]$_SDFFCE_PN0P_ clknet_leaf_136_clk _0565_
+ _0812_ VSS VSS VDD VDD decoded_imm\[4\] sky130_fd_sc_hd__edfxtp_1
Xdecoded_imm\[5\]$_SDFFCE_PN0P_ clknet_leaf_138_clk _0564_
+ net680 VSS VSS VDD VDD decoded_imm\[5\] sky130_fd_sc_hd__edfxtp_1
Xdecoded_imm\[6\]$_SDFFCE_PN0P_ clknet_leaf_140_clk _0563_
+ net680 VSS VSS VDD VDD decoded_imm\[6\] sky130_fd_sc_hd__edfxtp_1
Xdecoded_imm\[7\]$_SDFFCE_PN0P_ clknet_leaf_140_clk _0562_
+ net680 VSS VSS VDD VDD decoded_imm\[7\] sky130_fd_sc_hd__edfxtp_1
Xdecoded_imm\[8\]$_SDFFCE_PN0P_ clknet_leaf_104_clk _0561_
+ net680 VSS VSS VDD VDD decoded_imm\[8\] sky130_fd_sc_hd__edfxtp_1
Xdecoded_imm\[9\]$_SDFFCE_PN0P_ clknet_leaf_103_clk _0560_
+ net680 VSS VSS VDD VDD decoded_imm\[9\] sky130_fd_sc_hd__edfxtp_1
Xdecoded_imm_j\[10\]$_DFFE_PP_ clknet_leaf_110_clk mem_rdata_latched\[30\]
+ net611 VSS VSS VDD VDD decoded_imm_j\[10\] sky130_fd_sc_hd__edfxtp_1
Xdecoded_imm_j\[12\]$_DFFE_PP_ clknet_leaf_110_clk mem_rdata_latched\[12\]
+ net611 VSS VSS VDD VDD decoded_imm_j\[12\] sky130_fd_sc_hd__edfxtp_1
Xdecoded_imm_j\[13\]$_DFFE_PP_ clknet_leaf_97_clk mem_rdata_latched\[13\]
+ net611 VSS VSS VDD VDD decoded_imm_j\[13\] sky130_fd_sc_hd__edfxtp_1
Xdecoded_imm_j\[14\]$_DFFE_PP_ clknet_leaf_97_clk mem_rdata_latched\[14\]
+ net611 VSS VSS VDD VDD decoded_imm_j\[14\] sky130_fd_sc_hd__edfxtp_1
Xdecoded_imm_j\[19\]$_DFFE_PP_ clknet_leaf_107_clk mem_rdata_latched\[19\]
+ net611 VSS VSS VDD VDD decoded_imm_j\[19\] sky130_fd_sc_hd__edfxtp_1
Xdecoded_imm_j\[20\]$_DFFE_PP_ clknet_leaf_97_clk mem_rdata_latched\[31\]
+ net611 VSS VSS VDD VDD decoded_imm_j\[20\] sky130_fd_sc_hd__edfxtp_1
Xdecoded_imm_j\[4\]$_DFFE_PP_ clknet_leaf_137_clk mem_rdata_latched\[24\]
+ net611 VSS VSS VDD VDD decoded_imm_j\[4\] sky130_fd_sc_hd__edfxtp_1
Xdecoded_imm_j\[5\]$_DFFE_PP_ clknet_leaf_107_clk mem_rdata_latched\[25\]
+ net611 VSS VSS VDD VDD decoded_imm_j\[5\] sky130_fd_sc_hd__edfxtp_1
Xdecoded_imm_j\[6\]$_DFFE_PP_ clknet_leaf_108_clk mem_rdata_latched\[26\]
+ net611 VSS VSS VDD VDD decoded_imm_j\[6\] sky130_fd_sc_hd__edfxtp_1
Xdecoded_imm_j\[7\]$_DFFE_PP_ clknet_leaf_108_clk mem_rdata_latched\[27\]
+ net611 VSS VSS VDD VDD decoded_imm_j\[7\] sky130_fd_sc_hd__edfxtp_1
Xdecoded_imm_j\[8\]$_DFFE_PP_ clknet_leaf_108_clk mem_rdata_latched\[28\]
+ net611 VSS VSS VDD VDD decoded_imm_j\[8\] sky130_fd_sc_hd__edfxtp_1
Xdecoded_imm_j\[9\]$_DFFE_PP_ clknet_leaf_109_clk mem_rdata_latched\[29\]
+ net611 VSS VSS VDD VDD decoded_imm_j\[9\] sky130_fd_sc_hd__edfxtp_1
Xdecoded_rd\[0\]$_DFFE_PP_ clknet_leaf_135_clk mem_rdata_latched\[7\]
+ net611 VSS VSS VDD VDD decoded_rd\[0\] sky130_fd_sc_hd__edfxtp_1
Xdecoded_rd\[1\]$_DFFE_PP_ clknet_leaf_127_clk mem_rdata_latched\[8\]
+ net611 VSS VSS VDD VDD decoded_rd\[1\] sky130_fd_sc_hd__edfxtp_1
Xdecoded_rd\[2\]$_DFFE_PP_ clknet_leaf_135_clk mem_rdata_latched\[9\]
+ net611 VSS VSS VDD VDD decoded_rd\[2\] sky130_fd_sc_hd__edfxtp_1
Xdecoded_rd\[3\]$_DFFE_PP_ clknet_leaf_134_clk mem_rdata_latched\[10\]
+ net611 VSS VSS VDD VDD decoded_rd\[3\] sky130_fd_sc_hd__edfxtp_1
Xdecoded_rd\[4\]$_DFFE_PP_ clknet_leaf_134_clk mem_rdata_latched\[11\]
+ net611 VSS VSS VDD VDD decoded_rd\[4\] sky130_fd_sc_hd__edfxtp_1
Xdecoded_rs1\[0\]$_DFFE_PP_ clknet_leaf_107_clk mem_rdata_latched\[15\]
+ net611 VSS VSS VDD VDD decoded_imm_j\[15\] sky130_fd_sc_hd__edfxtp_1
Xdecoded_rs1\[1\]$_DFFE_PP_ clknet_leaf_107_clk mem_rdata_latched\[16\]
+ net611 VSS VSS VDD VDD decoded_imm_j\[16\] sky130_fd_sc_hd__edfxtp_1
Xdecoded_rs1\[2\]$_DFFE_PP_ clknet_leaf_106_clk mem_rdata_latched\[17\]
+ net611 VSS VSS VDD VDD decoded_imm_j\[17\] sky130_fd_sc_hd__edfxtp_1
Xdecoded_rs1\[3\]$_DFFE_PP_ clknet_leaf_107_clk mem_rdata_latched\[18\]
+ net611 VSS VSS VDD VDD decoded_imm_j\[18\] sky130_fd_sc_hd__edfxtp_1
Xdecoded_rs2\[0\]$_DFFE_PP_ clknet_leaf_127_clk mem_rdata_latched\[20\]
+ net611 VSS VSS VDD VDD decoded_imm_j\[11\] sky130_fd_sc_hd__edfxtp_1
Xdecoded_rs2\[1\]$_DFFE_PP_ clknet_leaf_127_clk mem_rdata_latched\[21\]
+ net611 VSS VSS VDD VDD decoded_imm_j\[1\] sky130_fd_sc_hd__edfxtp_1
Xdecoded_rs2\[2\]$_DFFE_PP_ clknet_leaf_127_clk mem_rdata_latched\[22\]
+ net611 VSS VSS VDD VDD decoded_imm_j\[2\] sky130_fd_sc_hd__edfxtp_1
Xdecoded_rs2\[3\]$_DFFE_PP_ clknet_leaf_127_clk mem_rdata_latched\[23\]
+ net611 VSS VSS VDD VDD decoded_imm_j\[3\] sky130_fd_sc_hd__edfxtp_1
Xdecoder_pseudo_trigger$_SDFF_PN0_ clknet_leaf_116_clk _0784_
+ VSS VSS VDD VDD decoder_pseudo_trigger sky130_fd_sc_hd__dfxtp_1
Xdecoder_trigger$_DFF_P_ clknet_leaf_116_clk _0000_ VSS VSS
+ VDD VDD decoder_trigger sky130_fd_sc_hd__dfxtp_2
Xinstr_add$_SDFFE_PN0P_ clknet_leaf_111_clk _0763_ VSS VSS
+ VDD VDD instr_add sky130_fd_sc_hd__dfxtp_1
Xinstr_addi$_SDFFE_PN0P_ clknet_leaf_112_clk _0770_ VSS VSS
+ VDD VDD instr_addi sky130_fd_sc_hd__dfxtp_1
Xinstr_and$_SDFFE_PN0P_ clknet_leaf_96_clk _0799_ VSS VSS
+ VDD VDD instr_and sky130_fd_sc_hd__dfxtp_1
Xinstr_andi$_SDFFE_PN0P_ clknet_leaf_95_clk _0765_ VSS VSS
+ VDD VDD instr_andi sky130_fd_sc_hd__dfxtp_1
Xinstr_auipc$_DFFE_PP_ clknet_leaf_119_clk _0806_ net611 VSS
+ VSS VDD VDD instr_auipc sky130_fd_sc_hd__edfxtp_1
Xinstr_beq$_SDFFE_PN0P_ clknet_leaf_96_clk _0789_ VSS VSS
+ VDD VDD instr_beq sky130_fd_sc_hd__dfxtp_1
Xinstr_bge$_SDFFE_PN0P_ clknet_leaf_96_clk _0773_ VSS VSS
+ VDD VDD instr_bge sky130_fd_sc_hd__dfxtp_1
Xinstr_bgeu$_SDFFE_PN0P_ clknet_leaf_96_clk _0771_ VSS VSS
+ VDD VDD instr_bgeu sky130_fd_sc_hd__dfxtp_1
Xinstr_blt$_SDFFE_PN0P_ clknet_leaf_111_clk _0774_ VSS VSS
+ VDD VDD instr_blt sky130_fd_sc_hd__dfxtp_1
Xinstr_bltu$_SDFFE_PN0P_ clknet_leaf_96_clk _0772_ VSS VSS
+ VDD VDD instr_bltu sky130_fd_sc_hd__dfxtp_1
Xinstr_bne$_SDFFE_PN0P_ clknet_leaf_96_clk _0775_ VSS VSS
+ VDD VDD instr_bne sky130_fd_sc_hd__dfxtp_1
Xinstr_fence$_SDFFE_PN0P_ clknet_leaf_119_clk _0792_ VSS VSS
+ VDD VDD instr_fence sky130_fd_sc_hd__dfxtp_1
Xinstr_jal$_DFFE_PP_ clknet_leaf_119_clk _0807_ net611 VSS
+ VSS VDD VDD instr_jal sky130_fd_sc_hd__edfxtp_1
Xinstr_jalr$_DFFE_PP_ clknet_leaf_119_clk _0831_ net611 VSS
+ VSS VDD VDD instr_jalr sky130_fd_sc_hd__edfxtp_1
Xinstr_lb$_DFFE_PP_ clknet_leaf_113_clk _0813_ net680 VSS
+ VSS VDD VDD instr_lb sky130_fd_sc_hd__edfxtp_1
Xinstr_lbu$_DFFE_PP_ clknet_leaf_113_clk _0816_ net680 VSS
+ VSS VDD VDD instr_lbu sky130_fd_sc_hd__edfxtp_1
Xinstr_lh$_DFFE_PP_ clknet_leaf_113_clk _0814_ net680 VSS
+ VSS VDD VDD instr_lh sky130_fd_sc_hd__edfxtp_1
Xinstr_lhu$_DFFE_PP_ clknet_leaf_111_clk _0817_ net680 VSS
+ VSS VDD VDD instr_lhu sky130_fd_sc_hd__edfxtp_1
Xinstr_lui$_DFFE_PP_ clknet_leaf_119_clk _0805_ net611 VSS
+ VSS VDD VDD instr_lui sky130_fd_sc_hd__edfxtp_1
Xinstr_lw$_DFFE_PP_ clknet_leaf_113_clk _0815_ net680 VSS
+ VSS VDD VDD instr_lw sky130_fd_sc_hd__edfxtp_1
Xinstr_or$_SDFFE_PN0P_ clknet_leaf_95_clk _0802_ VSS VSS VDD
+ VDD instr_or sky130_fd_sc_hd__dfxtp_1
Xinstr_ori$_SDFFE_PN0P_ clknet_leaf_94_clk _0766_ VSS VSS
+ VDD VDD instr_ori sky130_fd_sc_hd__dfxtp_1
Xinstr_rdcycle$_DFFE_PP_ clknet_leaf_117_clk _0824_ _0812_
+ VSS VSS VDD VDD instr_rdcycle sky130_fd_sc_hd__edfxtp_1
Xinstr_rdcycleh$_DFFE_PP_ clknet_leaf_118_clk _0825_ _0812_
+ VSS VSS VDD VDD instr_rdcycleh sky130_fd_sc_hd__edfxtp_1
Xinstr_rdinstr$_DFFE_PP_ clknet_leaf_118_clk _0826_ _0812_
+ VSS VSS VDD VDD instr_rdinstr sky130_fd_sc_hd__edfxtp_1
Xinstr_rdinstrh$_DFFE_PP_ clknet_leaf_126_clk _0827_ _0812_
+ VSS VSS VDD VDD instr_rdinstrh sky130_fd_sc_hd__edfxtp_1
Xinstr_sb$_DFFE_PP_ clknet_leaf_114_clk _0818_ _0812_ VSS
+ VSS VDD VDD instr_sb sky130_fd_sc_hd__edfxtp_1
Xinstr_sh$_DFFE_PP_ clknet_leaf_113_clk _0819_ _0812_ VSS
+ VSS VDD VDD instr_sh sky130_fd_sc_hd__edfxtp_1
Xinstr_sll$_SDFFE_PN0P_ clknet_leaf_110_clk _0761_ VSS VSS
+ VDD VDD instr_sll sky130_fd_sc_hd__dfxtp_1
Xinstr_slli$_DFFE_PP_ clknet_leaf_110_clk _0821_ net680 VSS
+ VSS VDD VDD instr_slli sky130_fd_sc_hd__edfxtp_1
Xinstr_slt$_SDFFE_PN0P_ clknet_leaf_111_clk _0760_ VSS VSS
+ VDD VDD instr_slt sky130_fd_sc_hd__dfxtp_1
Xinstr_slti$_SDFFE_PN0P_ clknet_leaf_112_clk _0769_ VSS VSS
+ VDD VDD instr_slti sky130_fd_sc_hd__dfxtp_1
Xinstr_sltiu$_SDFFE_PN0P_ clknet_leaf_112_clk _0768_ VSS VSS
+ VDD VDD instr_sltiu sky130_fd_sc_hd__dfxtp_1
Xinstr_sltu$_SDFFE_PN0P_ clknet_leaf_112_clk _0800_ VSS VSS
+ VDD VDD instr_sltu sky130_fd_sc_hd__dfxtp_1
Xinstr_sra$_SDFFE_PN0P_ clknet_leaf_111_clk _0803_ VSS VSS
+ VDD VDD instr_sra sky130_fd_sc_hd__dfxtp_1
Xinstr_srai$_DFFE_PP_ clknet_leaf_111_clk _0823_ net680 VSS
+ VSS VDD VDD instr_srai sky130_fd_sc_hd__edfxtp_1
Xinstr_srl$_SDFFE_PN0P_ clknet_leaf_111_clk _0804_ VSS VSS
+ VDD VDD instr_srl sky130_fd_sc_hd__dfxtp_1
Xinstr_srli$_DFFE_PP_ clknet_leaf_111_clk _0822_ net680 VSS
+ VSS VDD VDD instr_srli sky130_fd_sc_hd__edfxtp_1
Xinstr_sub$_SDFFE_PN0P_ clknet_leaf_111_clk _0762_ VSS VSS
+ VDD VDD instr_sub sky130_fd_sc_hd__dfxtp_2
Xinstr_sw$_DFFE_PP_ clknet_leaf_113_clk _0820_ net680 VSS
+ VSS VDD VDD instr_sw sky130_fd_sc_hd__edfxtp_1
Xinstr_xor$_SDFFE_PN0P_ clknet_leaf_96_clk _0793_ VSS VSS
+ VDD VDD instr_xor sky130_fd_sc_hd__dfxtp_1
Xinstr_xori$_SDFFE_PN0P_ clknet_leaf_95_clk _0767_ VSS VSS
+ VDD VDD instr_xori sky130_fd_sc_hd__dfxtp_1
Xis_alu_reg_imm$_DFFE_PP_ clknet_leaf_119_clk _0810_ net611
+ VSS VSS VDD VDD is_alu_reg_imm sky130_fd_sc_hd__edfxtp_1
Xis_alu_reg_reg$_DFFE_PP_ clknet_leaf_118_clk _0811_ net611
+ VSS VSS VDD VDD is_alu_reg_reg sky130_fd_sc_hd__edfxtp_1
Xis_beq_bne_blt_bge_bltu_bgeu$_SDFFE_PN0P_ clknet_leaf_118_clk
+ _0796_ VSS VSS VDD VDD is_beq_bne_blt_bge_bltu_bgeu sky130_fd_sc_hd__dfxtp_1
Xis_compare$_SDFF_PP0_ clknet_leaf_94_clk _0798_ VSS VSS VDD
+ VDD is_compare sky130_fd_sc_hd__dfxtp_1
Xis_jalr_addi_slti_sltiu_xori_ori_andi$_DFFE_PP_ clknet_leaf_116_clk
+ _0832_ _0812_ VSS VSS VDD VDD is_jalr_addi_slti_sltiu_xori_ori_andi
+ sky130_fd_sc_hd__edfxtp_1
Xis_lb_lh_lw_lbu_lhu$_DFFE_PP_ clknet_leaf_121_clk _0808_
+ net611 VSS VSS VDD VDD is_lb_lh_lw_lbu_lhu sky130_fd_sc_hd__edfxtp_1
Xis_lui_auipc_jal$_DFF_P_ clknet_leaf_108_clk _0001_ VSS VSS
+ VDD VDD is_lui_auipc_jal sky130_fd_sc_hd__dfxtp_1
Xis_sb_sh_sw$_DFFE_PP_ clknet_leaf_120_clk _0809_ net611 VSS
+ VSS VDD VDD is_sb_sh_sw sky130_fd_sc_hd__edfxtp_1
Xis_sll_srl_sra$_DFFE_PP_ clknet_leaf_118_clk _0829_ _0812_
+ VSS VSS VDD VDD is_sll_srl_sra sky130_fd_sc_hd__edfxtp_1
Xis_slli_srli_srai$_DFFE_PP_ clknet_leaf_118_clk _0828_ _0812_
+ VSS VSS VDD VDD is_slli_srli_srai sky130_fd_sc_hd__edfxtp_1
Xis_slti_blt_slt$_DFF_P_ clknet_leaf_96_clk _0002_ VSS VSS
+ VDD VDD is_slti_blt_slt sky130_fd_sc_hd__dfxtp_1
Xis_sltiu_bltu_sltu$_DFF_P_ clknet_leaf_96_clk _0003_ VSS
+ VSS VDD VDD is_sltiu_bltu_sltu sky130_fd_sc_hd__dfxtp_1
Xlatched_branch$_SDFFE_PN0P_ clknet_leaf_107_clk _0781_ VSS
+ VSS VDD VDD latched_branch sky130_fd_sc_hd__dfxtp_1
Xlatched_is_lb$_SDFFE_PN0P_ clknet_leaf_110_clk _0778_ VSS
+ VSS VDD VDD latched_is_lb sky130_fd_sc_hd__dfxtp_1
Xlatched_is_lh$_SDFFE_PN0P_ clknet_leaf_110_clk _0779_ VSS
+ VSS VDD VDD latched_is_lh sky130_fd_sc_hd__dfxtp_1
Xlatched_rd\[0\]$_SDFFCE_PN0P_ clknet_leaf_135_clk _0759_
+ net662 VSS VSS VDD VDD latched_rd\[0\] sky130_fd_sc_hd__edfxtp_1
Xlatched_rd\[1\]$_SDFFCE_PN0P_ clknet_leaf_134_clk _0758_
+ net662 VSS VSS VDD VDD latched_rd\[1\] sky130_fd_sc_hd__edfxtp_1
Xlatched_rd\[2\]$_SDFFCE_PN0P_ clknet_leaf_134_clk _0757_
+ net662 VSS VSS VDD VDD latched_rd\[2\] sky130_fd_sc_hd__edfxtp_1
Xlatched_rd\[3\]$_SDFFCE_PN0P_ clknet_leaf_134_clk _0756_
+ net662 VSS VSS VDD VDD latched_rd\[3\] sky130_fd_sc_hd__edfxtp_1
Xlatched_rd\[4\]$_SDFFCE_PN0P_ clknet_leaf_134_clk _0777_
+ net662 VSS VSS VDD VDD latched_rd\[4\] sky130_fd_sc_hd__edfxtp_1
Xlatched_stalu$_SDFFE_PN0P_ clknet_leaf_108_clk _0782_ VSS
+ VSS VDD VDD latched_stalu sky130_fd_sc_hd__dfxtp_2
Xlatched_store$_SDFFE_PN0P_ clknet_leaf_107_clk _0783_ VSS
+ VSS VDD VDD latched_store sky130_fd_sc_hd__dfxtp_1
Xmem_addr\[10\]$_DFFE_PP_ clknet_leaf_114_clk net203 net619
+ VSS VSS VDD VDD net172 sky130_fd_sc_hd__edfxtp_1
Xmem_addr\[11\]$_DFFE_PP_ clknet_leaf_120_clk net665 net619
+ VSS VSS VDD VDD net173 sky130_fd_sc_hd__edfxtp_1
Xmem_addr\[12\]$_DFFE_PP_ clknet_leaf_120_clk net666 net619
+ VSS VSS VDD VDD net174 sky130_fd_sc_hd__edfxtp_1
Xmem_addr\[13\]$_DFFE_PP_ clknet_leaf_120_clk net667 net619
+ VSS VSS VDD VDD net175 sky130_fd_sc_hd__edfxtp_1
Xmem_addr\[14\]$_DFFE_PP_ clknet_leaf_89_clk net207 net619
+ VSS VSS VDD VDD net176 sky130_fd_sc_hd__edfxtp_1
Xmem_addr\[15\]$_DFFE_PP_ clknet_leaf_89_clk net208 net619
+ VSS VSS VDD VDD net177 sky130_fd_sc_hd__edfxtp_1
Xmem_addr\[16\]$_DFFE_PP_ clknet_leaf_95_clk net209 net619
+ VSS VSS VDD VDD net178 sky130_fd_sc_hd__edfxtp_1
Xmem_addr\[17\]$_DFFE_PP_ clknet_leaf_95_clk net210 net619
+ VSS VSS VDD VDD net179 sky130_fd_sc_hd__edfxtp_1
Xmem_addr\[18\]$_DFFE_PP_ clknet_leaf_93_clk net211 net619
+ VSS VSS VDD VDD net180 sky130_fd_sc_hd__edfxtp_1
Xmem_addr\[19\]$_DFFE_PP_ clknet_leaf_120_clk net212 net619
+ VSS VSS VDD VDD net181 sky130_fd_sc_hd__edfxtp_1
Xmem_addr\[20\]$_DFFE_PP_ clknet_leaf_93_clk net213 net619
+ VSS VSS VDD VDD net182 sky130_fd_sc_hd__edfxtp_1
Xmem_addr\[21\]$_DFFE_PP_ clknet_leaf_93_clk net214 net619
+ VSS VSS VDD VDD net183 sky130_fd_sc_hd__edfxtp_1
Xmem_addr\[22\]$_DFFE_PP_ clknet_leaf_94_clk net215 net619
+ VSS VSS VDD VDD net184 sky130_fd_sc_hd__edfxtp_1
Xmem_addr\[23\]$_DFFE_PP_ clknet_leaf_93_clk net216 net619
+ VSS VSS VDD VDD net185 sky130_fd_sc_hd__edfxtp_1
Xmem_addr\[24\]$_DFFE_PP_ clknet_leaf_95_clk net217 net619
+ VSS VSS VDD VDD net186 sky130_fd_sc_hd__edfxtp_1
Xmem_addr\[25\]$_DFFE_PP_ clknet_leaf_95_clk net218 net619
+ VSS VSS VDD VDD net187 sky130_fd_sc_hd__edfxtp_1
Xmem_addr\[26\]$_DFFE_PP_ clknet_leaf_95_clk net219 net619
+ VSS VSS VDD VDD net188 sky130_fd_sc_hd__edfxtp_1
Xmem_addr\[27\]$_DFFE_PP_ clknet_leaf_94_clk net220 net619
+ VSS VSS VDD VDD net189 sky130_fd_sc_hd__edfxtp_1
Xmem_addr\[28\]$_DFFE_PP_ clknet_leaf_94_clk net221 net619
+ VSS VSS VDD VDD net190 sky130_fd_sc_hd__edfxtp_1
Xmem_addr\[29\]$_DFFE_PP_ clknet_leaf_95_clk net222 net619
+ VSS VSS VDD VDD net191 sky130_fd_sc_hd__edfxtp_1
Xmem_addr\[2\]$_DFFE_PP_ clknet_leaf_114_clk net223 net619
+ VSS VSS VDD VDD net192 sky130_fd_sc_hd__edfxtp_1
Xmem_addr\[30\]$_DFFE_PP_ clknet_leaf_93_clk net224 net619
+ VSS VSS VDD VDD net193 sky130_fd_sc_hd__edfxtp_1
Xmem_addr\[31\]$_DFFE_PP_ clknet_leaf_95_clk net225 net619
+ VSS VSS VDD VDD net194 sky130_fd_sc_hd__edfxtp_1
Xmem_addr\[3\]$_DFFE_PP_ clknet_leaf_112_clk net226 net619
+ VSS VSS VDD VDD net195 sky130_fd_sc_hd__edfxtp_1
Xmem_addr\[4\]$_DFFE_PP_ clknet_leaf_113_clk net227 net619
+ VSS VSS VDD VDD net196 sky130_fd_sc_hd__edfxtp_1
Xmem_addr\[5\]$_DFFE_PP_ clknet_leaf_112_clk net228 net619
+ VSS VSS VDD VDD net197 sky130_fd_sc_hd__edfxtp_1
Xmem_addr\[6\]$_DFFE_PP_ clknet_leaf_113_clk net229 net619
+ VSS VSS VDD VDD net198 sky130_fd_sc_hd__edfxtp_1
Xmem_addr\[7\]$_DFFE_PP_ clknet_leaf_95_clk net664 net619
+ VSS VSS VDD VDD net199 sky130_fd_sc_hd__edfxtp_1
Xmem_addr\[8\]$_DFFE_PP_ clknet_leaf_112_clk net231 net619
+ VSS VSS VDD VDD net200 sky130_fd_sc_hd__edfxtp_1
Xmem_addr\[9\]$_DFFE_PP_ clknet_leaf_114_clk net232 net619
+ VSS VSS VDD VDD net201 sky130_fd_sc_hd__edfxtp_1
Xmem_do_prefetch$_SDFFE_PP0P_ clknet_leaf_115_clk _0788_ VSS
+ VSS VDD VDD mem_do_prefetch sky130_fd_sc_hd__dfxtp_1
Xmem_do_rdata$_SDFFE_PP1P_ clknet_leaf_115_clk _0786_ VSS
+ VSS VDD VDD mem_do_rdata sky130_fd_sc_hd__dfxtp_1
Xmem_do_rinst$_SDFFE_PP1P_ clknet_leaf_115_clk _0787_ VSS
+ VSS VDD VDD mem_do_rinst sky130_fd_sc_hd__dfxtp_1
Xmem_do_wdata$_SDFFE_PP1P_ clknet_leaf_114_clk _0785_ VSS
+ VSS VDD VDD mem_do_wdata sky130_fd_sc_hd__dfxtp_1
Xmem_instr$_SDFFCE_PP0P_ clknet_leaf_114_clk _0764_ _0524_
+ VSS VSS VDD VDD net202 sky130_fd_sc_hd__edfxtp_1
Xmem_rdata_q\[0\]$_DFFE_PP_ clknet_leaf_119_clk net138 _3278_
+ VSS VSS VDD VDD mem_rdata_q\[0\] sky130_fd_sc_hd__edfxtp_1
Xmem_rdata_q\[10\]$_DFFE_PP_ clknet_leaf_137_clk net139 net677
+ VSS VSS VDD VDD mem_rdata_q\[10\] sky130_fd_sc_hd__edfxtp_1
Xmem_rdata_q\[11\]$_DFFE_PP_ clknet_leaf_117_clk net140 net677
+ VSS VSS VDD VDD mem_rdata_q\[11\] sky130_fd_sc_hd__edfxtp_1
Xmem_rdata_q\[12\]$_DFFE_PP_ clknet_leaf_110_clk net141 _3278_
+ VSS VSS VDD VDD mem_rdata_q\[12\] sky130_fd_sc_hd__edfxtp_1
Xmem_rdata_q\[13\]$_DFFE_PP_ clknet_leaf_111_clk net142 _3278_
+ VSS VSS VDD VDD mem_rdata_q\[13\] sky130_fd_sc_hd__edfxtp_1
Xmem_rdata_q\[14\]$_DFFE_PP_ clknet_leaf_111_clk net143 _3278_
+ VSS VSS VDD VDD mem_rdata_q\[14\] sky130_fd_sc_hd__edfxtp_1
Xmem_rdata_q\[15\]$_DFFE_PP_ clknet_leaf_109_clk net144 net677
+ VSS VSS VDD VDD mem_rdata_q\[15\] sky130_fd_sc_hd__edfxtp_1
Xmem_rdata_q\[16\]$_DFFE_PP_ clknet_leaf_117_clk net145 net677
+ VSS VSS VDD VDD mem_rdata_q\[16\] sky130_fd_sc_hd__edfxtp_1
Xmem_rdata_q\[17\]$_DFFE_PP_ clknet_leaf_105_clk net146 net677
+ VSS VSS VDD VDD mem_rdata_q\[17\] sky130_fd_sc_hd__edfxtp_1
Xmem_rdata_q\[18\]$_DFFE_PP_ clknet_leaf_109_clk net147 net677
+ VSS VSS VDD VDD mem_rdata_q\[18\] sky130_fd_sc_hd__edfxtp_1
Xmem_rdata_q\[19\]$_DFFE_PP_ clknet_leaf_109_clk net148 net677
+ VSS VSS VDD VDD mem_rdata_q\[19\] sky130_fd_sc_hd__edfxtp_1
Xmem_rdata_q\[1\]$_DFFE_PP_ clknet_leaf_119_clk net149 _3278_
+ VSS VSS VDD VDD mem_rdata_q\[1\] sky130_fd_sc_hd__edfxtp_1
Xmem_rdata_q\[20\]$_DFFE_PP_ clknet_leaf_126_clk net150 net677
+ VSS VSS VDD VDD mem_rdata_q\[20\] sky130_fd_sc_hd__edfxtp_1
Xmem_rdata_q\[21\]$_DFFE_PP_ clknet_leaf_127_clk net151 net677
+ VSS VSS VDD VDD mem_rdata_q\[21\] sky130_fd_sc_hd__edfxtp_1
Xmem_rdata_q\[22\]$_DFFE_PP_ clknet_leaf_117_clk net152 net677
+ VSS VSS VDD VDD mem_rdata_q\[22\] sky130_fd_sc_hd__edfxtp_1
Xmem_rdata_q\[23\]$_DFFE_PP_ clknet_leaf_117_clk net153 net677
+ VSS VSS VDD VDD mem_rdata_q\[23\] sky130_fd_sc_hd__edfxtp_1
Xmem_rdata_q\[24\]$_DFFE_PP_ clknet_leaf_117_clk net154 net677
+ VSS VSS VDD VDD mem_rdata_q\[24\] sky130_fd_sc_hd__edfxtp_1
Xmem_rdata_q\[25\]$_DFFE_PP_ clknet_leaf_107_clk net155 net677
+ VSS VSS VDD VDD mem_rdata_q\[25\] sky130_fd_sc_hd__edfxtp_1
Xmem_rdata_q\[26\]$_DFFE_PP_ clknet_leaf_108_clk net156 net677
+ VSS VSS VDD VDD mem_rdata_q\[26\] sky130_fd_sc_hd__edfxtp_1
Xmem_rdata_q\[27\]$_DFFE_PP_ clknet_leaf_118_clk net157 net677
+ VSS VSS VDD VDD mem_rdata_q\[27\] sky130_fd_sc_hd__edfxtp_1
Xmem_rdata_q\[28\]$_DFFE_PP_ clknet_leaf_108_clk net158 net677
+ VSS VSS VDD VDD mem_rdata_q\[28\] sky130_fd_sc_hd__edfxtp_1
Xmem_rdata_q\[29\]$_DFFE_PP_ clknet_leaf_110_clk net159 net677
+ VSS VSS VDD VDD mem_rdata_q\[29\] sky130_fd_sc_hd__edfxtp_1
Xmem_rdata_q\[2\]$_DFFE_PP_ clknet_leaf_120_clk net160 _3278_
+ VSS VSS VDD VDD mem_rdata_q\[2\] sky130_fd_sc_hd__edfxtp_1
Xmem_rdata_q\[30\]$_DFFE_PP_ clknet_leaf_110_clk net161 _3278_
+ VSS VSS VDD VDD mem_rdata_q\[30\] sky130_fd_sc_hd__edfxtp_1
Xmem_rdata_q\[31\]$_DFFE_PP_ clknet_leaf_118_clk net162 net677
+ VSS VSS VDD VDD mem_rdata_q\[31\] sky130_fd_sc_hd__edfxtp_1
Xmem_rdata_q\[3\]$_DFFE_PP_ clknet_leaf_120_clk net163 _3278_
+ VSS VSS VDD VDD mem_rdata_q\[3\] sky130_fd_sc_hd__edfxtp_1
Xmem_rdata_q\[4\]$_DFFE_PP_ clknet_leaf_119_clk net164 _3278_
+ VSS VSS VDD VDD mem_rdata_q\[4\] sky130_fd_sc_hd__edfxtp_1
Xmem_rdata_q\[5\]$_DFFE_PP_ clknet_leaf_120_clk net165 _3278_
+ VSS VSS VDD VDD mem_rdata_q\[5\] sky130_fd_sc_hd__edfxtp_1
Xmem_rdata_q\[6\]$_DFFE_PP_ clknet_leaf_120_clk net166 _3278_
+ VSS VSS VDD VDD mem_rdata_q\[6\] sky130_fd_sc_hd__edfxtp_1
Xmem_rdata_q\[7\]$_DFFE_PP_ clknet_leaf_117_clk net167 net677
+ VSS VSS VDD VDD mem_rdata_q\[7\] sky130_fd_sc_hd__edfxtp_1
Xmem_rdata_q\[8\]$_DFFE_PP_ clknet_leaf_127_clk net168 net677
+ VSS VSS VDD VDD mem_rdata_q\[8\] sky130_fd_sc_hd__edfxtp_1
Xmem_rdata_q\[9\]$_DFFE_PP_ clknet_leaf_137_clk net169 net677
+ VSS VSS VDD VDD mem_rdata_q\[9\] sky130_fd_sc_hd__edfxtp_1
Xmem_state\[0\]$_SDFFCE_PP0P_ clknet_leaf_115_clk _0755_ _0519_
+ VSS VSS VDD VDD mem_state\[0\] sky130_fd_sc_hd__edfxtp_1
Xmem_state\[1\]$_SDFFCE_PP0P_ clknet_leaf_115_clk _0794_ _0519_
+ VSS VSS VDD VDD mem_state\[1\] sky130_fd_sc_hd__edfxtp_1
Xmem_valid$_SDFFCE_PP0P_ clknet_leaf_115_clk _0795_ _0522_
+ VSS VSS VDD VDD net271 sky130_fd_sc_hd__edfxtp_1
Xmem_wdata\[0\]$_DFFE_PP_ clknet_leaf_87_clk net234 net656
+ VSS VSS VDD VDD net272 sky130_fd_sc_hd__edfxtp_1
Xmem_wdata\[10\]$_DFFE_PP_ clknet_leaf_88_clk net235 net656
+ VSS VSS VDD VDD net273 sky130_fd_sc_hd__edfxtp_1
Xmem_wdata\[11\]$_DFFE_PP_ clknet_leaf_88_clk net236 net656
+ VSS VSS VDD VDD net274 sky130_fd_sc_hd__edfxtp_1
Xmem_wdata\[12\]$_DFFE_PP_ clknet_leaf_87_clk net237 net656
+ VSS VSS VDD VDD net275 sky130_fd_sc_hd__edfxtp_1
Xmem_wdata\[13\]$_DFFE_PP_ clknet_leaf_88_clk net238 net656
+ VSS VSS VDD VDD net276 sky130_fd_sc_hd__edfxtp_1
Xmem_wdata\[14\]$_DFFE_PP_ clknet_leaf_88_clk net239 net656
+ VSS VSS VDD VDD net277 sky130_fd_sc_hd__edfxtp_1
Xmem_wdata\[15\]$_DFFE_PP_ clknet_leaf_89_clk net240 net656
+ VSS VSS VDD VDD net278 sky130_fd_sc_hd__edfxtp_1
Xmem_wdata\[16\]$_DFFE_PP_ clknet_leaf_93_clk net241 net656
+ VSS VSS VDD VDD net279 sky130_fd_sc_hd__edfxtp_1
Xmem_wdata\[17\]$_DFFE_PP_ clknet_leaf_89_clk net242 net656
+ VSS VSS VDD VDD net280 sky130_fd_sc_hd__edfxtp_1
Xmem_wdata\[18\]$_DFFE_PP_ clknet_leaf_93_clk net243 net656
+ VSS VSS VDD VDD net281 sky130_fd_sc_hd__edfxtp_1
Xmem_wdata\[19\]$_DFFE_PP_ clknet_leaf_93_clk net244 net656
+ VSS VSS VDD VDD net282 sky130_fd_sc_hd__edfxtp_1
Xmem_wdata\[1\]$_DFFE_PP_ clknet_leaf_87_clk net245 net656
+ VSS VSS VDD VDD net283 sky130_fd_sc_hd__edfxtp_1
Xmem_wdata\[20\]$_DFFE_PP_ clknet_leaf_89_clk net246 net656
+ VSS VSS VDD VDD net284 sky130_fd_sc_hd__edfxtp_1
Xmem_wdata\[21\]$_DFFE_PP_ clknet_leaf_84_clk net247 net656
+ VSS VSS VDD VDD net285 sky130_fd_sc_hd__edfxtp_1
Xmem_wdata\[22\]$_DFFE_PP_ clknet_leaf_63_clk net248 net656
+ VSS VSS VDD VDD net286 sky130_fd_sc_hd__edfxtp_1
Xmem_wdata\[23\]$_DFFE_PP_ clknet_leaf_84_clk net249 net656
+ VSS VSS VDD VDD net287 sky130_fd_sc_hd__edfxtp_1
Xmem_wdata\[24\]$_DFFE_PP_ clknet_leaf_88_clk net250 net656
+ VSS VSS VDD VDD net288 sky130_fd_sc_hd__edfxtp_1
Xmem_wdata\[25\]$_DFFE_PP_ clknet_leaf_87_clk net251 net656
+ VSS VSS VDD VDD net289 sky130_fd_sc_hd__edfxtp_1
Xmem_wdata\[26\]$_DFFE_PP_ clknet_leaf_88_clk net252 net656
+ VSS VSS VDD VDD net290 sky130_fd_sc_hd__edfxtp_1
Xmem_wdata\[27\]$_DFFE_PP_ clknet_leaf_88_clk net253 net656
+ VSS VSS VDD VDD net291 sky130_fd_sc_hd__edfxtp_1
Xmem_wdata\[28\]$_DFFE_PP_ clknet_leaf_87_clk net254 net656
+ VSS VSS VDD VDD net292 sky130_fd_sc_hd__edfxtp_1
Xmem_wdata\[29\]$_DFFE_PP_ clknet_leaf_89_clk net255 net656
+ VSS VSS VDD VDD net293 sky130_fd_sc_hd__edfxtp_1
Xmem_wdata\[2\]$_DFFE_PP_ clknet_leaf_88_clk net256 net656
+ VSS VSS VDD VDD net294 sky130_fd_sc_hd__edfxtp_1
Xmem_wdata\[30\]$_DFFE_PP_ clknet_leaf_88_clk net257 net656
+ VSS VSS VDD VDD net295 sky130_fd_sc_hd__edfxtp_1
Xmem_wdata\[31\]$_DFFE_PP_ clknet_leaf_89_clk net258 net656
+ VSS VSS VDD VDD net296 sky130_fd_sc_hd__edfxtp_1
Xmem_wdata\[3\]$_DFFE_PP_ clknet_leaf_87_clk net259 net656
+ VSS VSS VDD VDD net297 sky130_fd_sc_hd__edfxtp_1
Xmem_wdata\[4\]$_DFFE_PP_ clknet_leaf_87_clk net260 net656
+ VSS VSS VDD VDD net298 sky130_fd_sc_hd__edfxtp_1
Xmem_wdata\[5\]$_DFFE_PP_ clknet_leaf_63_clk net261 net656
+ VSS VSS VDD VDD net299 sky130_fd_sc_hd__edfxtp_1
Xmem_wdata\[6\]$_DFFE_PP_ clknet_leaf_84_clk net262 net656
+ VSS VSS VDD VDD net300 sky130_fd_sc_hd__edfxtp_1
Xmem_wdata\[7\]$_DFFE_PP_ clknet_leaf_63_clk net263 net656
+ VSS VSS VDD VDD net301 sky130_fd_sc_hd__edfxtp_1
Xmem_wdata\[8\]$_DFFE_PP_ clknet_leaf_87_clk net264 net656
+ VSS VSS VDD VDD net302 sky130_fd_sc_hd__edfxtp_1
Xmem_wdata\[9\]$_DFFE_PP_ clknet_leaf_87_clk net265 net656
+ VSS VSS VDD VDD net303 sky130_fd_sc_hd__edfxtp_1
Xmem_wordsize\[0\]$_DFF_P_ clknet_leaf_114_clk _0508_ VSS
+ VSS VDD VDD mem_wordsize\[0\] sky130_fd_sc_hd__dfxtp_1
Xmem_wordsize\[1\]$_DFF_P_ clknet_leaf_113_clk _0509_ VSS
+ VSS VDD VDD mem_wordsize\[1\] sky130_fd_sc_hd__dfxtp_1
Xmem_wordsize\[2\]$_DFF_P_ clknet_leaf_114_clk _0510_ VSS
+ VSS VDD VDD mem_wordsize\[2\] sky130_fd_sc_hd__dfxtp_1
Xmem_wstrb\[0\]$_DFFE_PN_ clknet_leaf_114_clk _4629_ _0528_
+ VSS VSS VDD VDD net304 sky130_fd_sc_hd__edfxtp_1
Xmem_wstrb\[1\]$_DFFE_PN_ clknet_leaf_112_clk _4630_ _0528_
+ VSS VSS VDD VDD net305 sky130_fd_sc_hd__edfxtp_1
Xmem_wstrb\[2\]$_DFFE_PN_ clknet_leaf_112_clk _4631_ _0528_
+ VSS VSS VDD VDD net306 sky130_fd_sc_hd__edfxtp_1
Xmem_wstrb\[3\]$_DFFE_PN_ clknet_leaf_112_clk _4632_ _0528_
+ VSS VSS VDD VDD net307 sky130_fd_sc_hd__edfxtp_1
Xreg_next_pc\[10\]$_SDFFE_PN0P_ clknet_leaf_105_clk _0652_
+ VSS VSS VDD VDD reg_next_pc\[10\] sky130_fd_sc_hd__dfxtp_1
Xreg_next_pc\[11\]$_SDFFE_PN0P_ clknet_leaf_105_clk _0651_
+ VSS VSS VDD VDD reg_next_pc\[11\] sky130_fd_sc_hd__dfxtp_1
Xreg_next_pc\[12\]$_SDFFE_PN0P_ clknet_leaf_101_clk _0650_
+ VSS VSS VDD VDD reg_next_pc\[12\] sky130_fd_sc_hd__dfxtp_1
Xreg_next_pc\[13\]$_SDFFE_PN0P_ clknet_leaf_101_clk _0649_
+ VSS VSS VDD VDD reg_next_pc\[13\] sky130_fd_sc_hd__dfxtp_1
Xreg_next_pc\[14\]$_SDFFE_PN0P_ clknet_leaf_101_clk _0648_
+ VSS VSS VDD VDD reg_next_pc\[14\] sky130_fd_sc_hd__dfxtp_1
Xreg_next_pc\[15\]$_SDFFE_PN0P_ clknet_leaf_100_clk _0647_
+ VSS VSS VDD VDD reg_next_pc\[15\] sky130_fd_sc_hd__dfxtp_1
Xreg_next_pc\[16\]$_SDFFE_PN0P_ clknet_leaf_100_clk _0646_
+ VSS VSS VDD VDD reg_next_pc\[16\] sky130_fd_sc_hd__dfxtp_1
Xreg_next_pc\[17\]$_SDFFE_PN0P_ clknet_leaf_100_clk _0645_
+ VSS VSS VDD VDD reg_next_pc\[17\] sky130_fd_sc_hd__dfxtp_1
Xreg_next_pc\[18\]$_SDFFE_PN0P_ clknet_leaf_99_clk _0644_
+ VSS VSS VDD VDD reg_next_pc\[18\] sky130_fd_sc_hd__dfxtp_1
Xreg_next_pc\[19\]$_SDFFE_PN0P_ clknet_leaf_98_clk _0643_
+ VSS VSS VDD VDD reg_next_pc\[19\] sky130_fd_sc_hd__dfxtp_1
Xreg_next_pc\[1\]$_SDFFE_PN0P_ clknet_leaf_107_clk _0661_
+ VSS VSS VDD VDD reg_next_pc\[1\] sky130_fd_sc_hd__dfxtp_1
Xreg_next_pc\[20\]$_SDFFE_PN0P_ clknet_leaf_98_clk _0642_
+ VSS VSS VDD VDD reg_next_pc\[20\] sky130_fd_sc_hd__dfxtp_1
Xreg_next_pc\[21\]$_SDFFE_PN0P_ clknet_leaf_99_clk _0641_
+ VSS VSS VDD VDD reg_next_pc\[21\] sky130_fd_sc_hd__dfxtp_1
Xreg_next_pc\[22\]$_SDFFE_PN0P_ clknet_leaf_99_clk _0640_
+ VSS VSS VDD VDD reg_next_pc\[22\] sky130_fd_sc_hd__dfxtp_1
Xreg_next_pc\[23\]$_SDFFE_PN0P_ clknet_leaf_91_clk _0639_
+ VSS VSS VDD VDD reg_next_pc\[23\] sky130_fd_sc_hd__dfxtp_1
Xreg_next_pc\[24\]$_SDFFE_PN0P_ clknet_leaf_92_clk _0638_
+ VSS VSS VDD VDD reg_next_pc\[24\] sky130_fd_sc_hd__dfxtp_1
Xreg_next_pc\[25\]$_SDFFE_PN0P_ clknet_leaf_92_clk _0637_
+ VSS VSS VDD VDD reg_next_pc\[25\] sky130_fd_sc_hd__dfxtp_1
Xreg_next_pc\[26\]$_SDFFE_PN0P_ clknet_leaf_92_clk _0636_
+ VSS VSS VDD VDD reg_next_pc\[26\] sky130_fd_sc_hd__dfxtp_1
Xreg_next_pc\[27\]$_SDFFE_PN0P_ clknet_leaf_92_clk _0635_
+ VSS VSS VDD VDD reg_next_pc\[27\] sky130_fd_sc_hd__dfxtp_1
Xreg_next_pc\[28\]$_SDFFE_PN0P_ clknet_leaf_92_clk _0634_
+ VSS VSS VDD VDD reg_next_pc\[28\] sky130_fd_sc_hd__dfxtp_1
Xreg_next_pc\[29\]$_SDFFE_PN0P_ clknet_leaf_93_clk _0633_
+ VSS VSS VDD VDD reg_next_pc\[29\] sky130_fd_sc_hd__dfxtp_1
Xreg_next_pc\[2\]$_SDFFE_PN0P_ clknet_leaf_137_clk _0660_
+ VSS VSS VDD VDD reg_next_pc\[2\] sky130_fd_sc_hd__dfxtp_1
Xreg_next_pc\[30\]$_SDFFE_PN0P_ clknet_leaf_93_clk _0632_
+ VSS VSS VDD VDD reg_next_pc\[30\] sky130_fd_sc_hd__dfxtp_1
Xreg_next_pc\[31\]$_SDFFE_PN0P_ clknet_leaf_94_clk _0797_
+ VSS VSS VDD VDD reg_next_pc\[31\] sky130_fd_sc_hd__dfxtp_1
Xreg_next_pc\[3\]$_SDFFE_PN0P_ clknet_leaf_137_clk _0659_
+ VSS VSS VDD VDD reg_next_pc\[3\] sky130_fd_sc_hd__dfxtp_1
Xreg_next_pc\[4\]$_SDFFE_PN0P_ clknet_leaf_106_clk _0658_
+ VSS VSS VDD VDD reg_next_pc\[4\] sky130_fd_sc_hd__dfxtp_1
Xreg_next_pc\[5\]$_SDFFE_PN0P_ clknet_leaf_106_clk _0657_
+ VSS VSS VDD VDD reg_next_pc\[5\] sky130_fd_sc_hd__dfxtp_1
Xreg_next_pc\[6\]$_SDFFE_PN0P_ clknet_leaf_106_clk _0656_
+ VSS VSS VDD VDD reg_next_pc\[6\] sky130_fd_sc_hd__dfxtp_1
Xreg_next_pc\[7\]$_SDFFE_PN0P_ clknet_leaf_106_clk _0655_
+ VSS VSS VDD VDD reg_next_pc\[7\] sky130_fd_sc_hd__dfxtp_1
Xreg_next_pc\[8\]$_SDFFE_PN0P_ clknet_leaf_104_clk _0654_
+ VSS VSS VDD VDD reg_next_pc\[8\] sky130_fd_sc_hd__dfxtp_1
Xreg_next_pc\[9\]$_SDFFE_PN0P_ clknet_leaf_106_clk _0653_
+ VSS VSS VDD VDD reg_next_pc\[9\] sky130_fd_sc_hd__dfxtp_1
Xreg_op1\[0\]$_DFFE_PP_ clknet_leaf_104_clk _4596_ _0527_
+ VSS VSS VDD VDD net308 sky130_fd_sc_hd__edfxtp_1
Xreg_op1\[10\]$_DFFE_PP_ clknet_leaf_140_clk _4597_ _0527_
+ VSS VSS VDD VDD net309 sky130_fd_sc_hd__edfxtp_1
Xreg_op1\[11\]$_DFFE_PP_ clknet_leaf_103_clk _4598_ _0527_
+ VSS VSS VDD VDD net310 sky130_fd_sc_hd__edfxtp_1
Xreg_op1\[12\]$_DFFE_PP_ clknet_leaf_103_clk _4599_ _0527_
+ VSS VSS VDD VDD net311 sky130_fd_sc_hd__edfxtp_1
Xreg_op1\[13\]$_DFFE_PP_ clknet_leaf_103_clk _4600_ _0527_
+ VSS VSS VDD VDD net312 sky130_fd_sc_hd__edfxtp_1
Xreg_op1\[14\]$_DFFE_PP_ clknet_leaf_78_clk _4601_ net599
+ VSS VSS VDD VDD net313 sky130_fd_sc_hd__edfxtp_1
Xreg_op1\[15\]$_DFFE_PP_ clknet_leaf_78_clk _4602_ net599
+ VSS VSS VDD VDD net314 sky130_fd_sc_hd__edfxtp_1
Xreg_op1\[16\]$_DFFE_PP_ clknet_leaf_78_clk _4603_ net599
+ VSS VSS VDD VDD net315 sky130_fd_sc_hd__edfxtp_1
Xreg_op1\[17\]$_DFFE_PP_ clknet_leaf_78_clk _4604_ net599
+ VSS VSS VDD VDD net316 sky130_fd_sc_hd__edfxtp_1
Xreg_op1\[18\]$_DFFE_PP_ clknet_leaf_79_clk _4605_ net599
+ VSS VSS VDD VDD net317 sky130_fd_sc_hd__edfxtp_1
Xreg_op1\[19\]$_DFFE_PP_ clknet_leaf_80_clk _4606_ net599
+ VSS VSS VDD VDD net318 sky130_fd_sc_hd__edfxtp_1
Xreg_op1\[1\]$_DFFE_PP_ clknet_leaf_139_clk _4607_ _0527_
+ VSS VSS VDD VDD net319 sky130_fd_sc_hd__edfxtp_1
Xreg_op1\[20\]$_DFFE_PP_ clknet_leaf_79_clk _4608_ net599
+ VSS VSS VDD VDD net320 sky130_fd_sc_hd__edfxtp_1
Xreg_op1\[21\]$_DFFE_PP_ clknet_leaf_79_clk _4609_ net599
+ VSS VSS VDD VDD net321 sky130_fd_sc_hd__edfxtp_1
Xreg_op1\[22\]$_DFFE_PP_ clknet_leaf_80_clk _4610_ net599
+ VSS VSS VDD VDD net322 sky130_fd_sc_hd__edfxtp_1
Xreg_op1\[23\]$_DFFE_PP_ clknet_leaf_80_clk _4611_ net599
+ VSS VSS VDD VDD net323 sky130_fd_sc_hd__edfxtp_1
Xreg_op1\[24\]$_DFFE_PP_ clknet_leaf_85_clk _4612_ net599
+ VSS VSS VDD VDD net324 sky130_fd_sc_hd__edfxtp_1
Xreg_op1\[25\]$_DFFE_PP_ clknet_leaf_86_clk _4613_ net599
+ VSS VSS VDD VDD net325 sky130_fd_sc_hd__edfxtp_1
Xreg_op1\[26\]$_DFFE_PP_ clknet_leaf_91_clk _4614_ net599
+ VSS VSS VDD VDD net326 sky130_fd_sc_hd__edfxtp_1
Xreg_op1\[27\]$_DFFE_PP_ clknet_leaf_90_clk _4615_ net599
+ VSS VSS VDD VDD net327 sky130_fd_sc_hd__edfxtp_1
Xreg_op1\[28\]$_DFFE_PP_ clknet_leaf_90_clk _4616_ net599
+ VSS VSS VDD VDD net328 sky130_fd_sc_hd__edfxtp_1
Xreg_op1\[29\]$_DFFE_PP_ clknet_leaf_90_clk _4617_ net599
+ VSS VSS VDD VDD net329 sky130_fd_sc_hd__edfxtp_1
Xreg_op1\[2\]$_DFFE_PP_ clknet_leaf_138_clk _4618_ _0527_
+ VSS VSS VDD VDD net330 sky130_fd_sc_hd__edfxtp_1
Xreg_op1\[30\]$_DFFE_PP_ clknet_leaf_90_clk _4619_ net599
+ VSS VSS VDD VDD net331 sky130_fd_sc_hd__edfxtp_1
Xreg_op1\[31\]$_DFFE_PP_ clknet_leaf_97_clk _4620_ _0526_
+ VSS VSS VDD VDD net332 sky130_fd_sc_hd__edfxtp_1
Xreg_op1\[3\]$_DFFE_PP_ clknet_leaf_139_clk _4621_ _0527_
+ VSS VSS VDD VDD net333 sky130_fd_sc_hd__edfxtp_1
Xreg_op1\[4\]$_DFFE_PP_ clknet_leaf_139_clk _4622_ _0527_
+ VSS VSS VDD VDD net334 sky130_fd_sc_hd__edfxtp_1
Xreg_op1\[5\]$_DFFE_PP_ clknet_leaf_139_clk _4623_ _0527_
+ VSS VSS VDD VDD net335 sky130_fd_sc_hd__edfxtp_1
Xreg_op1\[6\]$_DFFE_PP_ clknet_leaf_139_clk _4624_ _0527_
+ VSS VSS VDD VDD net336 sky130_fd_sc_hd__edfxtp_1
Xreg_op1\[7\]$_DFFE_PP_ clknet_leaf_140_clk _4625_ _0527_
+ VSS VSS VDD VDD net337 sky130_fd_sc_hd__edfxtp_1
Xreg_op1\[8\]$_DFFE_PP_ clknet_leaf_141_clk _4626_ _0527_
+ VSS VSS VDD VDD net338 sky130_fd_sc_hd__edfxtp_1
Xreg_op1\[9\]$_DFFE_PP_ clknet_leaf_140_clk _4627_ _0527_
+ VSS VSS VDD VDD net339 sky130_fd_sc_hd__edfxtp_1
Xreg_op2\[0\]$_DFFE_PP_ clknet_leaf_80_clk _4564_ _0523_ VSS
+ VSS VDD VDD net234 sky130_fd_sc_hd__edfxtp_1
Xreg_op2\[10\]$_DFFE_PP_ clknet_leaf_83_clk _4565_ _0523_
+ VSS VSS VDD VDD net340 sky130_fd_sc_hd__edfxtp_1
Xreg_op2\[11\]$_DFFE_PP_ clknet_leaf_83_clk _4566_ _0523_
+ VSS VSS VDD VDD net341 sky130_fd_sc_hd__edfxtp_1
Xreg_op2\[12\]$_DFFE_PP_ clknet_leaf_83_clk _4567_ _0523_
+ VSS VSS VDD VDD net342 sky130_fd_sc_hd__edfxtp_1
Xreg_op2\[13\]$_DFFE_PP_ clknet_leaf_82_clk _4568_ _0523_
+ VSS VSS VDD VDD net343 sky130_fd_sc_hd__edfxtp_1
Xreg_op2\[14\]$_DFFE_PP_ clknet_leaf_83_clk _4569_ _0523_
+ VSS VSS VDD VDD net344 sky130_fd_sc_hd__edfxtp_1
Xreg_op2\[15\]$_DFFE_PP_ clknet_leaf_82_clk _4570_ _0523_
+ VSS VSS VDD VDD net345 sky130_fd_sc_hd__edfxtp_1
Xreg_op2\[16\]$_DFFE_PP_ clknet_leaf_82_clk _4571_ _0523_
+ VSS VSS VDD VDD net346 sky130_fd_sc_hd__edfxtp_1
Xreg_op2\[17\]$_DFFE_PP_ clknet_leaf_81_clk _4572_ _0523_
+ VSS VSS VDD VDD net347 sky130_fd_sc_hd__edfxtp_1
Xreg_op2\[18\]$_DFFE_PP_ clknet_leaf_81_clk _4573_ _0523_
+ VSS VSS VDD VDD net348 sky130_fd_sc_hd__edfxtp_1
Xreg_op2\[19\]$_DFFE_PP_ clknet_leaf_79_clk _4574_ _0523_
+ VSS VSS VDD VDD net349 sky130_fd_sc_hd__edfxtp_1
Xreg_op2\[1\]$_DFFE_PP_ clknet_leaf_80_clk net652 _0523_ VSS
+ VSS VDD VDD net245 sky130_fd_sc_hd__edfxtp_1
Xreg_op2\[20\]$_DFFE_PP_ clknet_leaf_85_clk _4576_ _0523_
+ VSS VSS VDD VDD net350 sky130_fd_sc_hd__edfxtp_1
Xreg_op2\[21\]$_DFFE_PP_ clknet_leaf_83_clk _4577_ _0523_
+ VSS VSS VDD VDD net351 sky130_fd_sc_hd__edfxtp_1
Xreg_op2\[22\]$_DFFE_PP_ clknet_leaf_84_clk _4578_ _0523_
+ VSS VSS VDD VDD net352 sky130_fd_sc_hd__edfxtp_1
Xreg_op2\[23\]$_DFFE_PP_ clknet_leaf_85_clk _4579_ _0523_
+ VSS VSS VDD VDD net353 sky130_fd_sc_hd__edfxtp_1
Xreg_op2\[24\]$_DFFE_PP_ clknet_leaf_85_clk _4580_ _0523_
+ VSS VSS VDD VDD net354 sky130_fd_sc_hd__edfxtp_1
Xreg_op2\[25\]$_DFFE_PP_ clknet_leaf_86_clk _4581_ _0523_
+ VSS VSS VDD VDD net355 sky130_fd_sc_hd__edfxtp_1
Xreg_op2\[26\]$_DFFE_PP_ clknet_leaf_86_clk _4582_ _0523_
+ VSS VSS VDD VDD net356 sky130_fd_sc_hd__edfxtp_1
Xreg_op2\[27\]$_DFFE_PP_ clknet_leaf_81_clk _4583_ _0523_
+ VSS VSS VDD VDD net357 sky130_fd_sc_hd__edfxtp_1
Xreg_op2\[28\]$_DFFE_PP_ clknet_leaf_86_clk _4584_ _0523_
+ VSS VSS VDD VDD net358 sky130_fd_sc_hd__edfxtp_1
Xreg_op2\[29\]$_DFFE_PP_ clknet_leaf_86_clk _4585_ _0523_
+ VSS VSS VDD VDD net359 sky130_fd_sc_hd__edfxtp_1
Xreg_op2\[2\]$_DFFE_PP_ clknet_leaf_80_clk net653 _0523_ VSS
+ VSS VDD VDD net256 sky130_fd_sc_hd__edfxtp_1
Xreg_op2\[30\]$_DFFE_PP_ clknet_leaf_108_clk _4587_ _0523_
+ VSS VSS VDD VDD net360 sky130_fd_sc_hd__edfxtp_1
Xreg_op2\[31\]$_DFFE_PP_ clknet_leaf_108_clk _4588_ _0523_
+ VSS VSS VDD VDD net361 sky130_fd_sc_hd__edfxtp_1
Xreg_op2\[3\]$_DFFE_PP_ clknet_leaf_81_clk _4589_ _0523_ VSS
+ VSS VDD VDD net259 sky130_fd_sc_hd__edfxtp_1
Xreg_op2\[4\]$_DFFE_PP_ clknet_leaf_80_clk _4590_ _0523_ VSS
+ VSS VDD VDD net260 sky130_fd_sc_hd__edfxtp_1
Xreg_op2\[5\]$_DFFE_PP_ clknet_leaf_82_clk _4591_ _0523_ VSS
+ VSS VDD VDD net261 sky130_fd_sc_hd__edfxtp_1
Xreg_op2\[6\]$_DFFE_PP_ clknet_leaf_82_clk _4592_ _0523_ VSS
+ VSS VDD VDD net262 sky130_fd_sc_hd__edfxtp_1
Xreg_op2\[7\]$_DFFE_PP_ clknet_leaf_82_clk _4593_ _0523_ VSS
+ VSS VDD VDD net263 sky130_fd_sc_hd__edfxtp_1
Xreg_op2\[8\]$_DFFE_PP_ clknet_leaf_83_clk _4594_ _0523_ VSS
+ VSS VDD VDD net362 sky130_fd_sc_hd__edfxtp_1
Xreg_op2\[9\]$_DFFE_PP_ clknet_leaf_83_clk _4595_ _0523_ VSS
+ VSS VDD VDD net363 sky130_fd_sc_hd__edfxtp_1
Xreg_out\[0\]$_DFF_P_ clknet_leaf_116_clk _0004_ VSS VSS VDD
+ VDD reg_out\[0\] sky130_fd_sc_hd__dfxtp_1
Xreg_out\[10\]$_DFF_P_ clknet_leaf_104_clk _0005_ VSS VSS
+ VDD VDD reg_out\[10\] sky130_fd_sc_hd__dfxtp_1
Xreg_out\[11\]$_DFF_P_ clknet_leaf_103_clk _0006_ VSS VSS
+ VDD VDD reg_out\[11\] sky130_fd_sc_hd__dfxtp_1
Xreg_out\[12\]$_DFF_P_ clknet_leaf_105_clk _0007_ VSS VSS
+ VDD VDD reg_out\[12\] sky130_fd_sc_hd__dfxtp_1
Xreg_out\[13\]$_DFF_P_ clknet_leaf_101_clk _0008_ VSS VSS
+ VDD VDD reg_out\[13\] sky130_fd_sc_hd__dfxtp_1
Xreg_out\[14\]$_DFF_P_ clknet_leaf_101_clk _0009_ VSS VSS
+ VDD VDD reg_out\[14\] sky130_fd_sc_hd__dfxtp_1
Xreg_out\[15\]$_DFF_P_ clknet_leaf_101_clk _0010_ VSS VSS
+ VDD VDD reg_out\[15\] sky130_fd_sc_hd__dfxtp_1
Xreg_out\[16\]$_DFF_P_ clknet_leaf_100_clk _0011_ VSS VSS
+ VDD VDD reg_out\[16\] sky130_fd_sc_hd__dfxtp_1
Xreg_out\[17\]$_DFF_P_ clknet_leaf_100_clk _0012_ VSS VSS
+ VDD VDD reg_out\[17\] sky130_fd_sc_hd__dfxtp_1
Xreg_out\[18\]$_DFF_P_ clknet_leaf_100_clk _0013_ VSS VSS
+ VDD VDD reg_out\[18\] sky130_fd_sc_hd__dfxtp_1
Xreg_out\[19\]$_DFF_P_ clknet_leaf_100_clk _0014_ VSS VSS
+ VDD VDD reg_out\[19\] sky130_fd_sc_hd__dfxtp_1
Xreg_out\[1\]$_DFF_P_ clknet_leaf_107_clk _0015_ VSS VSS VDD
+ VDD reg_out\[1\] sky130_fd_sc_hd__dfxtp_1
Xreg_out\[20\]$_DFF_P_ clknet_leaf_99_clk _0016_ VSS VSS VDD
+ VDD reg_out\[20\] sky130_fd_sc_hd__dfxtp_1
Xreg_out\[21\]$_DFF_P_ clknet_leaf_99_clk _0017_ VSS VSS VDD
+ VDD reg_out\[21\] sky130_fd_sc_hd__dfxtp_1
Xreg_out\[22\]$_DFF_P_ clknet_leaf_99_clk _0018_ VSS VSS VDD
+ VDD reg_out\[22\] sky130_fd_sc_hd__dfxtp_1
Xreg_out\[23\]$_DFF_P_ clknet_leaf_91_clk _0019_ VSS VSS VDD
+ VDD reg_out\[23\] sky130_fd_sc_hd__dfxtp_1
Xreg_out\[24\]$_DFF_P_ clknet_leaf_91_clk _0020_ VSS VSS VDD
+ VDD reg_out\[24\] sky130_fd_sc_hd__dfxtp_1
Xreg_out\[25\]$_DFF_P_ clknet_leaf_97_clk _0021_ VSS VSS VDD
+ VDD reg_out\[25\] sky130_fd_sc_hd__dfxtp_1
Xreg_out\[26\]$_DFF_P_ clknet_leaf_94_clk _0022_ VSS VSS VDD
+ VDD reg_out\[26\] sky130_fd_sc_hd__dfxtp_1
Xreg_out\[27\]$_DFF_P_ clknet_leaf_94_clk _0023_ VSS VSS VDD
+ VDD reg_out\[27\] sky130_fd_sc_hd__dfxtp_1
Xreg_out\[28\]$_DFF_P_ clknet_leaf_94_clk _0024_ VSS VSS VDD
+ VDD reg_out\[28\] sky130_fd_sc_hd__dfxtp_1
Xreg_out\[29\]$_DFF_P_ clknet_leaf_94_clk _0025_ VSS VSS VDD
+ VDD reg_out\[29\] sky130_fd_sc_hd__dfxtp_1
Xreg_out\[2\]$_DFF_P_ clknet_leaf_138_clk _0026_ VSS VSS VDD
+ VDD reg_out\[2\] sky130_fd_sc_hd__dfxtp_1
Xreg_out\[30\]$_DFF_P_ clknet_leaf_97_clk _0027_ VSS VSS VDD
+ VDD reg_out\[30\] sky130_fd_sc_hd__dfxtp_1
Xreg_out\[31\]$_DFF_P_ clknet_leaf_97_clk _0028_ VSS VSS VDD
+ VDD reg_out\[31\] sky130_fd_sc_hd__dfxtp_1
Xreg_out\[3\]$_DFF_P_ clknet_leaf_137_clk _0029_ VSS VSS VDD
+ VDD reg_out\[3\] sky130_fd_sc_hd__dfxtp_1
Xreg_out\[4\]$_DFF_P_ clknet_leaf_138_clk _0030_ VSS VSS VDD
+ VDD reg_out\[4\] sky130_fd_sc_hd__dfxtp_1
Xreg_out\[5\]$_DFF_P_ clknet_leaf_138_clk _0031_ VSS VSS VDD
+ VDD reg_out\[5\] sky130_fd_sc_hd__dfxtp_1
Xreg_out\[6\]$_DFF_P_ clknet_leaf_138_clk _0032_ VSS VSS VDD
+ VDD reg_out\[6\] sky130_fd_sc_hd__dfxtp_1
Xreg_out\[7\]$_DFF_P_ clknet_leaf_104_clk _0033_ VSS VSS VDD
+ VDD reg_out\[7\] sky130_fd_sc_hd__dfxtp_1
Xreg_out\[8\]$_DFF_P_ clknet_leaf_104_clk _0034_ VSS VSS VDD
+ VDD reg_out\[8\] sky130_fd_sc_hd__dfxtp_1
Xreg_out\[9\]$_DFF_P_ clknet_leaf_104_clk _0035_ VSS VSS VDD
+ VDD reg_out\[9\] sky130_fd_sc_hd__dfxtp_1
Xreg_pc\[10\]$_SDFFE_PN0P_ clknet_leaf_103_clk _0745_ VSS
+ VSS VDD VDD reg_pc\[10\] sky130_fd_sc_hd__dfxtp_1
Xreg_pc\[11\]$_SDFFE_PN0P_ clknet_leaf_103_clk _0744_ VSS
+ VSS VDD VDD reg_pc\[11\] sky130_fd_sc_hd__dfxtp_1
Xreg_pc\[12\]$_SDFFE_PN0P_ clknet_leaf_102_clk _0743_ VSS
+ VSS VDD VDD reg_pc\[12\] sky130_fd_sc_hd__dfxtp_1
Xreg_pc\[13\]$_SDFFE_PN0P_ clknet_leaf_102_clk _0742_ VSS
+ VSS VDD VDD reg_pc\[13\] sky130_fd_sc_hd__dfxtp_1
Xreg_pc\[14\]$_SDFFE_PN0P_ clknet_leaf_102_clk _0741_ VSS
+ VSS VDD VDD reg_pc\[14\] sky130_fd_sc_hd__dfxtp_1
Xreg_pc\[15\]$_SDFFE_PN0P_ clknet_leaf_102_clk _0740_ VSS
+ VSS VDD VDD reg_pc\[15\] sky130_fd_sc_hd__dfxtp_1
Xreg_pc\[16\]$_SDFFE_PN0P_ clknet_leaf_78_clk _0739_ VSS VSS
+ VDD VDD reg_pc\[16\] sky130_fd_sc_hd__dfxtp_1
Xreg_pc\[17\]$_SDFFE_PN0P_ clknet_leaf_102_clk _0738_ VSS
+ VSS VDD VDD reg_pc\[17\] sky130_fd_sc_hd__dfxtp_1
Xreg_pc\[18\]$_SDFFE_PN0P_ clknet_leaf_100_clk _0737_ VSS
+ VSS VDD VDD reg_pc\[18\] sky130_fd_sc_hd__dfxtp_1
Xreg_pc\[19\]$_SDFFE_PN0P_ clknet_leaf_99_clk _0736_ VSS VSS
+ VDD VDD reg_pc\[19\] sky130_fd_sc_hd__dfxtp_1
Xreg_pc\[1\]$_SDFFE_PN0P_ clknet_leaf_107_clk _0754_ VSS VSS
+ VDD VDD reg_pc\[1\] sky130_fd_sc_hd__dfxtp_1
Xreg_pc\[20\]$_SDFFE_PN0P_ clknet_leaf_79_clk _0735_ VSS VSS
+ VDD VDD reg_pc\[20\] sky130_fd_sc_hd__dfxtp_1
Xreg_pc\[21\]$_SDFFE_PN0P_ clknet_leaf_99_clk _0734_ VSS VSS
+ VDD VDD reg_pc\[21\] sky130_fd_sc_hd__dfxtp_1
Xreg_pc\[22\]$_SDFFE_PN0P_ clknet_leaf_91_clk _0733_ VSS VSS
+ VDD VDD reg_pc\[22\] sky130_fd_sc_hd__dfxtp_1
Xreg_pc\[23\]$_SDFFE_PN0P_ clknet_leaf_91_clk _0732_ VSS VSS
+ VDD VDD reg_pc\[23\] sky130_fd_sc_hd__dfxtp_1
Xreg_pc\[24\]$_SDFFE_PN0P_ clknet_leaf_99_clk _0731_ VSS VSS
+ VDD VDD reg_pc\[24\] sky130_fd_sc_hd__dfxtp_1
Xreg_pc\[25\]$_SDFFE_PN0P_ clknet_leaf_92_clk _0730_ VSS VSS
+ VDD VDD reg_pc\[25\] sky130_fd_sc_hd__dfxtp_1
Xreg_pc\[26\]$_SDFFE_PN0P_ clknet_leaf_91_clk _0729_ VSS VSS
+ VDD VDD reg_pc\[26\] sky130_fd_sc_hd__dfxtp_1
Xreg_pc\[27\]$_SDFFE_PN0P_ clknet_leaf_92_clk _0728_ VSS VSS
+ VDD VDD reg_pc\[27\] sky130_fd_sc_hd__dfxtp_1
Xreg_pc\[28\]$_SDFFE_PN0P_ clknet_leaf_92_clk _0727_ VSS VSS
+ VDD VDD reg_pc\[28\] sky130_fd_sc_hd__dfxtp_1
Xreg_pc\[29\]$_SDFFE_PN0P_ clknet_leaf_92_clk _0726_ VSS VSS
+ VDD VDD reg_pc\[29\] sky130_fd_sc_hd__dfxtp_1
Xreg_pc\[2\]$_SDFFE_PN0P_ clknet_leaf_135_clk _0753_ VSS VSS
+ VDD VDD reg_pc\[2\] sky130_fd_sc_hd__dfxtp_1
Xreg_pc\[30\]$_SDFFE_PN0P_ clknet_leaf_94_clk _0725_ VSS VSS
+ VDD VDD reg_pc\[30\] sky130_fd_sc_hd__dfxtp_1
Xreg_pc\[31\]$_SDFFE_PN0P_ clknet_leaf_97_clk _0776_ VSS VSS
+ VDD VDD reg_pc\[31\] sky130_fd_sc_hd__dfxtp_1
Xreg_pc\[3\]$_SDFFE_PN0P_ clknet_leaf_138_clk _0752_ VSS VSS
+ VDD VDD reg_pc\[3\] sky130_fd_sc_hd__dfxtp_1
Xreg_pc\[4\]$_SDFFE_PN0P_ clknet_leaf_138_clk _0751_ VSS VSS
+ VDD VDD reg_pc\[4\] sky130_fd_sc_hd__dfxtp_1
Xreg_pc\[5\]$_SDFFE_PN0P_ clknet_leaf_106_clk _0750_ VSS VSS
+ VDD VDD reg_pc\[5\] sky130_fd_sc_hd__dfxtp_1
Xreg_pc\[6\]$_SDFFE_PN0P_ clknet_leaf_138_clk _0749_ VSS VSS
+ VDD VDD reg_pc\[6\] sky130_fd_sc_hd__dfxtp_1
Xreg_pc\[7\]$_SDFFE_PN0P_ clknet_leaf_104_clk _0748_ VSS VSS
+ VDD VDD reg_pc\[7\] sky130_fd_sc_hd__dfxtp_1
Xreg_pc\[8\]$_SDFFE_PN0P_ clknet_leaf_140_clk _0747_ VSS VSS
+ VDD VDD reg_pc\[8\] sky130_fd_sc_hd__dfxtp_1
Xreg_pc\[9\]$_SDFFE_PN0P_ clknet_leaf_103_clk _0746_ VSS VSS
+ VDD VDD reg_pc\[9\] sky130_fd_sc_hd__dfxtp_1
Xreg_sh\[0\]$_DFFE_PP_ clknet_leaf_135_clk _0036_ _0518_ VSS
+ VSS VDD VDD reg_sh\[0\] sky130_fd_sc_hd__edfxtp_1
Xreg_sh\[1\]$_DFFE_PP_ clknet_leaf_135_clk _0037_ _0518_ VSS
+ VSS VDD VDD reg_sh\[1\] sky130_fd_sc_hd__edfxtp_1
Xreg_sh\[2\]$_DFF_P_ clknet_leaf_137_clk _0038_ VSS VSS VDD
+ VDD reg_sh\[2\] sky130_fd_sc_hd__dfxtp_1
Xreg_sh\[3\]$_DFF_P_ clknet_leaf_136_clk _0039_ VSS VSS VDD
+ VDD reg_sh\[3\] sky130_fd_sc_hd__dfxtp_1
Xreg_sh\[4\]$_DFF_P_ clknet_leaf_137_clk _0040_ VSS VSS VDD
+ VDD reg_sh\[4\] sky130_fd_sc_hd__dfxtp_1
Xtrap$_SDFF_PN0_ clknet_leaf_116_clk _0790_ VSS VSS VDD VDD
+ net364 sky130_fd_sc_hd__dfxtp_1
X_9355__35 VSS VSS VDD VDD _unconnected_34 mem_la_addr[0]
+ sky130_fd_sc_hd__conb_1
X_9356__36 VSS VSS VDD VDD _unconnected_35 mem_la_addr[1]
+ sky130_fd_sc_hd__conb_1
X_9408__80 VSS VSS VDD VDD _unconnected_79 trace_data[10]
+ sky130_fd_sc_hd__conb_1
X_9409__81 VSS VSS VDD VDD _unconnected_80 trace_data[11]
+ sky130_fd_sc_hd__conb_1
X_9410__82 VSS VSS VDD VDD _unconnected_81 trace_data[12]
+ sky130_fd_sc_hd__conb_1
X_9411__83 VSS VSS VDD VDD _unconnected_82 trace_data[13]
+ sky130_fd_sc_hd__conb_1
X_9412__84 VSS VSS VDD VDD _unconnected_83 trace_data[14]
+ sky130_fd_sc_hd__conb_1
X_9413__85 VSS VSS VDD VDD _unconnected_84 trace_data[15]
+ sky130_fd_sc_hd__conb_1
X_9414__86 VSS VSS VDD VDD _unconnected_85 trace_data[16]
+ sky130_fd_sc_hd__conb_1
X_9415__87 VSS VSS VDD VDD _unconnected_86 trace_data[17]
+ sky130_fd_sc_hd__conb_1
X_9416__88 VSS VSS VDD VDD _unconnected_87 trace_data[18]
+ sky130_fd_sc_hd__conb_1
X_9417__89 VSS VSS VDD VDD _unconnected_88 trace_data[19]
+ sky130_fd_sc_hd__conb_1
X_9418__90 VSS VSS VDD VDD _unconnected_89 trace_data[20]
+ sky130_fd_sc_hd__conb_1
X_9419__91 VSS VSS VDD VDD _unconnected_90 trace_data[21]
+ sky130_fd_sc_hd__conb_1
X_9420__92 VSS VSS VDD VDD _unconnected_91 trace_data[22]
+ sky130_fd_sc_hd__conb_1
X_9421__93 VSS VSS VDD VDD _unconnected_92 trace_data[23]
+ sky130_fd_sc_hd__conb_1
X_9422__94 VSS VSS VDD VDD _unconnected_93 trace_data[24]
+ sky130_fd_sc_hd__conb_1
X_9423__95 VSS VSS VDD VDD _unconnected_94 trace_data[25]
+ sky130_fd_sc_hd__conb_1
X_9424__96 VSS VSS VDD VDD _unconnected_95 trace_data[26]
+ sky130_fd_sc_hd__conb_1
X_9425__97 VSS VSS VDD VDD _unconnected_96 trace_data[27]
+ sky130_fd_sc_hd__conb_1
X_9426__98 VSS VSS VDD VDD _unconnected_97 trace_data[28]
+ sky130_fd_sc_hd__conb_1
X_9427__99 VSS VSS VDD VDD _unconnected_98 trace_data[29]
+ sky130_fd_sc_hd__conb_1
X_9428__100 VSS VSS VDD VDD _unconnected_99 trace_data[30]
+ sky130_fd_sc_hd__conb_1
X_9429__101 VSS VSS VDD VDD _unconnected_100 trace_data[31]
+ sky130_fd_sc_hd__conb_1
X_9430__102 VSS VSS VDD VDD _unconnected_101 trace_data[32]
+ sky130_fd_sc_hd__conb_1
X_9431__103 VSS VSS VDD VDD _unconnected_102 trace_data[33]
+ sky130_fd_sc_hd__conb_1
X_9432__104 VSS VSS VDD VDD _unconnected_103 trace_data[34]
+ sky130_fd_sc_hd__conb_1
X_9433__105 VSS VSS VDD VDD _unconnected_104 trace_data[35]
+ sky130_fd_sc_hd__conb_1
Xcpuregs\[0\]\[0\]$_DFFE_PP__107 VSS VSS VDD VDD _unconnected_106
+ net106 sky130_fd_sc_hd__conb_1
Xcpuregs\[0\]\[10\]$_DFFE_PP__108 VSS VSS VDD VDD _unconnected_107
+ net107 sky130_fd_sc_hd__conb_1
Xcpuregs\[0\]\[11\]$_DFFE_PP__109 VSS VSS VDD VDD _unconnected_108
+ net108 sky130_fd_sc_hd__conb_1
Xcpuregs\[0\]\[12\]$_DFFE_PP__110 VSS VSS VDD VDD _unconnected_109
+ net109 sky130_fd_sc_hd__conb_1
Xcpuregs\[0\]\[13\]$_DFFE_PP__111 VSS VSS VDD VDD _unconnected_110
+ net110 sky130_fd_sc_hd__conb_1
Xcpuregs\[0\]\[14\]$_DFFE_PP__112 VSS VSS VDD VDD _unconnected_111
+ net111 sky130_fd_sc_hd__conb_1
Xcpuregs\[0\]\[15\]$_DFFE_PP__113 VSS VSS VDD VDD _unconnected_112
+ net112 sky130_fd_sc_hd__conb_1
Xcpuregs\[0\]\[16\]$_DFFE_PP__114 VSS VSS VDD VDD _unconnected_113
+ net113 sky130_fd_sc_hd__conb_1
Xcpuregs\[0\]\[17\]$_DFFE_PP__115 VSS VSS VDD VDD _unconnected_114
+ net114 sky130_fd_sc_hd__conb_1
Xcpuregs\[0\]\[18\]$_DFFE_PP__116 VSS VSS VDD VDD _unconnected_115
+ net115 sky130_fd_sc_hd__conb_1
Xcpuregs\[0\]\[19\]$_DFFE_PP__117 VSS VSS VDD VDD _unconnected_116
+ net116 sky130_fd_sc_hd__conb_1
Xcpuregs\[0\]\[1\]$_DFFE_PP__118 VSS VSS VDD VDD _unconnected_117
+ net117 sky130_fd_sc_hd__conb_1
Xcpuregs\[0\]\[20\]$_DFFE_PP__119 VSS VSS VDD VDD _unconnected_118
+ net118 sky130_fd_sc_hd__conb_1
Xcpuregs\[0\]\[21\]$_DFFE_PP__120 VSS VSS VDD VDD _unconnected_119
+ net119 sky130_fd_sc_hd__conb_1
Xcpuregs\[0\]\[22\]$_DFFE_PP__121 VSS VSS VDD VDD _unconnected_120
+ net120 sky130_fd_sc_hd__conb_1
Xcpuregs\[0\]\[23\]$_DFFE_PP__122 VSS VSS VDD VDD _unconnected_121
+ net121 sky130_fd_sc_hd__conb_1
Xcpuregs\[0\]\[24\]$_DFFE_PP__123 VSS VSS VDD VDD _unconnected_122
+ net122 sky130_fd_sc_hd__conb_1
Xcpuregs\[0\]\[25\]$_DFFE_PP__124 VSS VSS VDD VDD _unconnected_123
+ net123 sky130_fd_sc_hd__conb_1
Xcpuregs\[0\]\[26\]$_DFFE_PP__125 VSS VSS VDD VDD _unconnected_124
+ net124 sky130_fd_sc_hd__conb_1
Xcpuregs\[0\]\[27\]$_DFFE_PP__126 VSS VSS VDD VDD _unconnected_125
+ net125 sky130_fd_sc_hd__conb_1
Xcpuregs\[0\]\[28\]$_DFFE_PP__127 VSS VSS VDD VDD _unconnected_126
+ net126 sky130_fd_sc_hd__conb_1
Xcpuregs\[0\]\[29\]$_DFFE_PP__128 VSS VSS VDD VDD _unconnected_127
+ net127 sky130_fd_sc_hd__conb_1
Xcpuregs\[0\]\[2\]$_DFFE_PP__129 VSS VSS VDD VDD _unconnected_128
+ net128 sky130_fd_sc_hd__conb_1
Xcpuregs\[0\]\[30\]$_DFFE_PP__130 VSS VSS VDD VDD _unconnected_129
+ net129 sky130_fd_sc_hd__conb_1
Xcpuregs\[0\]\[31\]$_DFFE_PP__131 VSS VSS VDD VDD _unconnected_130
+ net130 sky130_fd_sc_hd__conb_1
Xcpuregs\[0\]\[3\]$_DFFE_PP__132 VSS VSS VDD VDD _unconnected_131
+ net131 sky130_fd_sc_hd__conb_1
Xcpuregs\[0\]\[4\]$_DFFE_PP__133 VSS VSS VDD VDD _unconnected_132
+ net132 sky130_fd_sc_hd__conb_1
Xcpuregs\[0\]\[5\]$_DFFE_PP__134 VSS VSS VDD VDD _unconnected_133
+ net133 sky130_fd_sc_hd__conb_1
Xcpuregs\[0\]\[6\]$_DFFE_PP__135 VSS VSS VDD VDD _unconnected_134
+ net134 sky130_fd_sc_hd__conb_1
Xcpuregs\[0\]\[7\]$_DFFE_PP__136 VSS VSS VDD VDD _unconnected_135
+ net135 sky130_fd_sc_hd__conb_1
Xcpuregs\[0\]\[8\]$_DFFE_PP__137 VSS VSS VDD VDD _unconnected_136
+ net136 sky130_fd_sc_hd__conb_1
Xcpuregs\[0\]\[9\]$_DFFE_PP__138 VSS VSS VDD VDD _unconnected_137
+ net137 sky130_fd_sc_hd__conb_1
XTAP_TAPCELL_ROW_0_1 VSS VDD sky130_fd_sc_hd__tapvpwrvgnd_1
XTAP_TAPCELL_ROW_0_2 VSS VDD sky130_fd_sc_hd__tapvpwrvgnd_1
XTAP_TAPCELL_ROW_0_3 VSS VDD sky130_fd_sc_hd__tapvpwrvgnd_1
XTAP_TAPCELL_ROW_0_4 VSS VDD sky130_fd_sc_hd__tapvpwrvgnd_1
XTAP_TAPCELL_ROW_0_5 VSS VDD sky130_fd_sc_hd__tapvpwrvgnd_1
XTAP_TAPCELL_ROW_0_6 VSS VDD sky130_fd_sc_hd__tapvpwrvgnd_1
XTAP_TAPCELL_ROW_0_7 VSS VDD sky130_fd_sc_hd__tapvpwrvgnd_1
XTAP_TAPCELL_ROW_0_8 VSS VDD sky130_fd_sc_hd__tapvpwrvgnd_1
XTAP_TAPCELL_ROW_0_9 VSS VDD sky130_fd_sc_hd__tapvpwrvgnd_1
XTAP_TAPCELL_ROW_0_10 VSS VDD sky130_fd_sc_hd__tapvpwrvgnd_1
XTAP_TAPCELL_ROW_0_11 VSS VDD sky130_fd_sc_hd__tapvpwrvgnd_1
XTAP_TAPCELL_ROW_0_12 VSS VDD sky130_fd_sc_hd__tapvpwrvgnd_1
XTAP_TAPCELL_ROW_0_13 VSS VDD sky130_fd_sc_hd__tapvpwrvgnd_1
XTAP_TAPCELL_ROW_0_14 VSS VDD sky130_fd_sc_hd__tapvpwrvgnd_1
XTAP_TAPCELL_ROW_0_15 VSS VDD sky130_fd_sc_hd__tapvpwrvgnd_1
XTAP_TAPCELL_ROW_0_16 VSS VDD sky130_fd_sc_hd__tapvpwrvgnd_1
XTAP_TAPCELL_ROW_0_17 VSS VDD sky130_fd_sc_hd__tapvpwrvgnd_1
XTAP_TAPCELL_ROW_0_18 VSS VDD sky130_fd_sc_hd__tapvpwrvgnd_1
XTAP_TAPCELL_ROW_0_19 VSS VDD sky130_fd_sc_hd__tapvpwrvgnd_1
XTAP_TAPCELL_ROW_0_20 VSS VDD sky130_fd_sc_hd__tapvpwrvgnd_1
XTAP_TAPCELL_ROW_0_21 VSS VDD sky130_fd_sc_hd__tapvpwrvgnd_1
XTAP_TAPCELL_ROW_0_22 VSS VDD sky130_fd_sc_hd__tapvpwrvgnd_1
XTAP_TAPCELL_ROW_0_23 VSS VDD sky130_fd_sc_hd__tapvpwrvgnd_1
XTAP_TAPCELL_ROW_0_24 VSS VDD sky130_fd_sc_hd__tapvpwrvgnd_1
XTAP_TAPCELL_ROW_0_25 VSS VDD sky130_fd_sc_hd__tapvpwrvgnd_1
XTAP_TAPCELL_ROW_0_26 VSS VDD sky130_fd_sc_hd__tapvpwrvgnd_1
XTAP_TAPCELL_ROW_0_27 VSS VDD sky130_fd_sc_hd__tapvpwrvgnd_1
XTAP_TAPCELL_ROW_0_28 VSS VDD sky130_fd_sc_hd__tapvpwrvgnd_1
XTAP_TAPCELL_ROW_0_29 VSS VDD sky130_fd_sc_hd__tapvpwrvgnd_1
XTAP_TAPCELL_ROW_0_30 VSS VDD sky130_fd_sc_hd__tapvpwrvgnd_1
XTAP_TAPCELL_ROW_1_31 VSS VDD sky130_fd_sc_hd__tapvpwrvgnd_1
XTAP_TAPCELL_ROW_1_32 VSS VDD sky130_fd_sc_hd__tapvpwrvgnd_1
XTAP_TAPCELL_ROW_1_33 VSS VDD sky130_fd_sc_hd__tapvpwrvgnd_1
XTAP_TAPCELL_ROW_1_34 VSS VDD sky130_fd_sc_hd__tapvpwrvgnd_1
XTAP_TAPCELL_ROW_1_35 VSS VDD sky130_fd_sc_hd__tapvpwrvgnd_1
XTAP_TAPCELL_ROW_1_36 VSS VDD sky130_fd_sc_hd__tapvpwrvgnd_1
XTAP_TAPCELL_ROW_1_37 VSS VDD sky130_fd_sc_hd__tapvpwrvgnd_1
XTAP_TAPCELL_ROW_1_38 VSS VDD sky130_fd_sc_hd__tapvpwrvgnd_1
XTAP_TAPCELL_ROW_1_39 VSS VDD sky130_fd_sc_hd__tapvpwrvgnd_1
XTAP_TAPCELL_ROW_1_40 VSS VDD sky130_fd_sc_hd__tapvpwrvgnd_1
XTAP_TAPCELL_ROW_1_41 VSS VDD sky130_fd_sc_hd__tapvpwrvgnd_1
XTAP_TAPCELL_ROW_1_42 VSS VDD sky130_fd_sc_hd__tapvpwrvgnd_1
XTAP_TAPCELL_ROW_1_43 VSS VDD sky130_fd_sc_hd__tapvpwrvgnd_1
XTAP_TAPCELL_ROW_1_44 VSS VDD sky130_fd_sc_hd__tapvpwrvgnd_1
XTAP_TAPCELL_ROW_1_45 VSS VDD sky130_fd_sc_hd__tapvpwrvgnd_1
XTAP_TAPCELL_ROW_2_46 VSS VDD sky130_fd_sc_hd__tapvpwrvgnd_1
XTAP_TAPCELL_ROW_2_47 VSS VDD sky130_fd_sc_hd__tapvpwrvgnd_1
XTAP_TAPCELL_ROW_2_48 VSS VDD sky130_fd_sc_hd__tapvpwrvgnd_1
XTAP_TAPCELL_ROW_2_49 VSS VDD sky130_fd_sc_hd__tapvpwrvgnd_1
XTAP_TAPCELL_ROW_2_50 VSS VDD sky130_fd_sc_hd__tapvpwrvgnd_1
XTAP_TAPCELL_ROW_2_51 VSS VDD sky130_fd_sc_hd__tapvpwrvgnd_1
XTAP_TAPCELL_ROW_2_52 VSS VDD sky130_fd_sc_hd__tapvpwrvgnd_1
XTAP_TAPCELL_ROW_2_53 VSS VDD sky130_fd_sc_hd__tapvpwrvgnd_1
XTAP_TAPCELL_ROW_2_54 VSS VDD sky130_fd_sc_hd__tapvpwrvgnd_1
XTAP_TAPCELL_ROW_2_55 VSS VDD sky130_fd_sc_hd__tapvpwrvgnd_1
XTAP_TAPCELL_ROW_2_56 VSS VDD sky130_fd_sc_hd__tapvpwrvgnd_1
XTAP_TAPCELL_ROW_2_57 VSS VDD sky130_fd_sc_hd__tapvpwrvgnd_1
XTAP_TAPCELL_ROW_2_58 VSS VDD sky130_fd_sc_hd__tapvpwrvgnd_1
XTAP_TAPCELL_ROW_2_59 VSS VDD sky130_fd_sc_hd__tapvpwrvgnd_1
XTAP_TAPCELL_ROW_2_60 VSS VDD sky130_fd_sc_hd__tapvpwrvgnd_1
XTAP_TAPCELL_ROW_2_61 VSS VDD sky130_fd_sc_hd__tapvpwrvgnd_1
XTAP_TAPCELL_ROW_3_62 VSS VDD sky130_fd_sc_hd__tapvpwrvgnd_1
XTAP_TAPCELL_ROW_3_63 VSS VDD sky130_fd_sc_hd__tapvpwrvgnd_1
XTAP_TAPCELL_ROW_3_64 VSS VDD sky130_fd_sc_hd__tapvpwrvgnd_1
XTAP_TAPCELL_ROW_3_65 VSS VDD sky130_fd_sc_hd__tapvpwrvgnd_1
XTAP_TAPCELL_ROW_3_66 VSS VDD sky130_fd_sc_hd__tapvpwrvgnd_1
XTAP_TAPCELL_ROW_3_67 VSS VDD sky130_fd_sc_hd__tapvpwrvgnd_1
XTAP_TAPCELL_ROW_3_68 VSS VDD sky130_fd_sc_hd__tapvpwrvgnd_1
XTAP_TAPCELL_ROW_3_69 VSS VDD sky130_fd_sc_hd__tapvpwrvgnd_1
XTAP_TAPCELL_ROW_3_70 VSS VDD sky130_fd_sc_hd__tapvpwrvgnd_1
XTAP_TAPCELL_ROW_3_71 VSS VDD sky130_fd_sc_hd__tapvpwrvgnd_1
XTAP_TAPCELL_ROW_3_72 VSS VDD sky130_fd_sc_hd__tapvpwrvgnd_1
XTAP_TAPCELL_ROW_3_73 VSS VDD sky130_fd_sc_hd__tapvpwrvgnd_1
XTAP_TAPCELL_ROW_3_74 VSS VDD sky130_fd_sc_hd__tapvpwrvgnd_1
XTAP_TAPCELL_ROW_3_75 VSS VDD sky130_fd_sc_hd__tapvpwrvgnd_1
XTAP_TAPCELL_ROW_3_76 VSS VDD sky130_fd_sc_hd__tapvpwrvgnd_1
XTAP_TAPCELL_ROW_4_77 VSS VDD sky130_fd_sc_hd__tapvpwrvgnd_1
XTAP_TAPCELL_ROW_4_78 VSS VDD sky130_fd_sc_hd__tapvpwrvgnd_1
XTAP_TAPCELL_ROW_4_79 VSS VDD sky130_fd_sc_hd__tapvpwrvgnd_1
XTAP_TAPCELL_ROW_4_80 VSS VDD sky130_fd_sc_hd__tapvpwrvgnd_1
XTAP_TAPCELL_ROW_4_81 VSS VDD sky130_fd_sc_hd__tapvpwrvgnd_1
XTAP_TAPCELL_ROW_4_82 VSS VDD sky130_fd_sc_hd__tapvpwrvgnd_1
XTAP_TAPCELL_ROW_4_83 VSS VDD sky130_fd_sc_hd__tapvpwrvgnd_1
XTAP_TAPCELL_ROW_4_84 VSS VDD sky130_fd_sc_hd__tapvpwrvgnd_1
XTAP_TAPCELL_ROW_4_85 VSS VDD sky130_fd_sc_hd__tapvpwrvgnd_1
XTAP_TAPCELL_ROW_4_86 VSS VDD sky130_fd_sc_hd__tapvpwrvgnd_1
XTAP_TAPCELL_ROW_4_87 VSS VDD sky130_fd_sc_hd__tapvpwrvgnd_1
XTAP_TAPCELL_ROW_4_88 VSS VDD sky130_fd_sc_hd__tapvpwrvgnd_1
XTAP_TAPCELL_ROW_4_89 VSS VDD sky130_fd_sc_hd__tapvpwrvgnd_1
XTAP_TAPCELL_ROW_4_90 VSS VDD sky130_fd_sc_hd__tapvpwrvgnd_1
XTAP_TAPCELL_ROW_4_91 VSS VDD sky130_fd_sc_hd__tapvpwrvgnd_1
XTAP_TAPCELL_ROW_4_92 VSS VDD sky130_fd_sc_hd__tapvpwrvgnd_1
XTAP_TAPCELL_ROW_5_93 VSS VDD sky130_fd_sc_hd__tapvpwrvgnd_1
XTAP_TAPCELL_ROW_5_94 VSS VDD sky130_fd_sc_hd__tapvpwrvgnd_1
XTAP_TAPCELL_ROW_5_95 VSS VDD sky130_fd_sc_hd__tapvpwrvgnd_1
XTAP_TAPCELL_ROW_5_96 VSS VDD sky130_fd_sc_hd__tapvpwrvgnd_1
XTAP_TAPCELL_ROW_5_97 VSS VDD sky130_fd_sc_hd__tapvpwrvgnd_1
XTAP_TAPCELL_ROW_5_98 VSS VDD sky130_fd_sc_hd__tapvpwrvgnd_1
XTAP_TAPCELL_ROW_5_99 VSS VDD sky130_fd_sc_hd__tapvpwrvgnd_1
XTAP_TAPCELL_ROW_5_100 VSS VDD sky130_fd_sc_hd__tapvpwrvgnd_1
XTAP_TAPCELL_ROW_5_101 VSS VDD sky130_fd_sc_hd__tapvpwrvgnd_1
XTAP_TAPCELL_ROW_5_102 VSS VDD sky130_fd_sc_hd__tapvpwrvgnd_1
XTAP_TAPCELL_ROW_5_103 VSS VDD sky130_fd_sc_hd__tapvpwrvgnd_1
XTAP_TAPCELL_ROW_5_104 VSS VDD sky130_fd_sc_hd__tapvpwrvgnd_1
XTAP_TAPCELL_ROW_5_105 VSS VDD sky130_fd_sc_hd__tapvpwrvgnd_1
XTAP_TAPCELL_ROW_5_106 VSS VDD sky130_fd_sc_hd__tapvpwrvgnd_1
XTAP_TAPCELL_ROW_5_107 VSS VDD sky130_fd_sc_hd__tapvpwrvgnd_1
XTAP_TAPCELL_ROW_6_108 VSS VDD sky130_fd_sc_hd__tapvpwrvgnd_1
XTAP_TAPCELL_ROW_6_109 VSS VDD sky130_fd_sc_hd__tapvpwrvgnd_1
XTAP_TAPCELL_ROW_6_110 VSS VDD sky130_fd_sc_hd__tapvpwrvgnd_1
XTAP_TAPCELL_ROW_6_111 VSS VDD sky130_fd_sc_hd__tapvpwrvgnd_1
XTAP_TAPCELL_ROW_6_112 VSS VDD sky130_fd_sc_hd__tapvpwrvgnd_1
XTAP_TAPCELL_ROW_6_113 VSS VDD sky130_fd_sc_hd__tapvpwrvgnd_1
XTAP_TAPCELL_ROW_6_114 VSS VDD sky130_fd_sc_hd__tapvpwrvgnd_1
XTAP_TAPCELL_ROW_6_115 VSS VDD sky130_fd_sc_hd__tapvpwrvgnd_1
XTAP_TAPCELL_ROW_6_116 VSS VDD sky130_fd_sc_hd__tapvpwrvgnd_1
XTAP_TAPCELL_ROW_6_117 VSS VDD sky130_fd_sc_hd__tapvpwrvgnd_1
XTAP_TAPCELL_ROW_6_118 VSS VDD sky130_fd_sc_hd__tapvpwrvgnd_1
XTAP_TAPCELL_ROW_6_119 VSS VDD sky130_fd_sc_hd__tapvpwrvgnd_1
XTAP_TAPCELL_ROW_6_120 VSS VDD sky130_fd_sc_hd__tapvpwrvgnd_1
XTAP_TAPCELL_ROW_6_121 VSS VDD sky130_fd_sc_hd__tapvpwrvgnd_1
XTAP_TAPCELL_ROW_6_122 VSS VDD sky130_fd_sc_hd__tapvpwrvgnd_1
XTAP_TAPCELL_ROW_6_123 VSS VDD sky130_fd_sc_hd__tapvpwrvgnd_1
XTAP_TAPCELL_ROW_7_124 VSS VDD sky130_fd_sc_hd__tapvpwrvgnd_1
XTAP_TAPCELL_ROW_7_125 VSS VDD sky130_fd_sc_hd__tapvpwrvgnd_1
XTAP_TAPCELL_ROW_7_126 VSS VDD sky130_fd_sc_hd__tapvpwrvgnd_1
XTAP_TAPCELL_ROW_7_127 VSS VDD sky130_fd_sc_hd__tapvpwrvgnd_1
XTAP_TAPCELL_ROW_7_128 VSS VDD sky130_fd_sc_hd__tapvpwrvgnd_1
XTAP_TAPCELL_ROW_7_129 VSS VDD sky130_fd_sc_hd__tapvpwrvgnd_1
XTAP_TAPCELL_ROW_7_130 VSS VDD sky130_fd_sc_hd__tapvpwrvgnd_1
XTAP_TAPCELL_ROW_7_131 VSS VDD sky130_fd_sc_hd__tapvpwrvgnd_1
XTAP_TAPCELL_ROW_7_132 VSS VDD sky130_fd_sc_hd__tapvpwrvgnd_1
XTAP_TAPCELL_ROW_7_133 VSS VDD sky130_fd_sc_hd__tapvpwrvgnd_1
XTAP_TAPCELL_ROW_7_134 VSS VDD sky130_fd_sc_hd__tapvpwrvgnd_1
XTAP_TAPCELL_ROW_7_135 VSS VDD sky130_fd_sc_hd__tapvpwrvgnd_1
XTAP_TAPCELL_ROW_7_136 VSS VDD sky130_fd_sc_hd__tapvpwrvgnd_1
XTAP_TAPCELL_ROW_7_137 VSS VDD sky130_fd_sc_hd__tapvpwrvgnd_1
XTAP_TAPCELL_ROW_7_138 VSS VDD sky130_fd_sc_hd__tapvpwrvgnd_1
XTAP_TAPCELL_ROW_8_139 VSS VDD sky130_fd_sc_hd__tapvpwrvgnd_1
XTAP_TAPCELL_ROW_8_140 VSS VDD sky130_fd_sc_hd__tapvpwrvgnd_1
XTAP_TAPCELL_ROW_8_141 VSS VDD sky130_fd_sc_hd__tapvpwrvgnd_1
XTAP_TAPCELL_ROW_8_142 VSS VDD sky130_fd_sc_hd__tapvpwrvgnd_1
XTAP_TAPCELL_ROW_8_143 VSS VDD sky130_fd_sc_hd__tapvpwrvgnd_1
XTAP_TAPCELL_ROW_8_144 VSS VDD sky130_fd_sc_hd__tapvpwrvgnd_1
XTAP_TAPCELL_ROW_8_145 VSS VDD sky130_fd_sc_hd__tapvpwrvgnd_1
XTAP_TAPCELL_ROW_8_146 VSS VDD sky130_fd_sc_hd__tapvpwrvgnd_1
XTAP_TAPCELL_ROW_8_147 VSS VDD sky130_fd_sc_hd__tapvpwrvgnd_1
XTAP_TAPCELL_ROW_8_148 VSS VDD sky130_fd_sc_hd__tapvpwrvgnd_1
XTAP_TAPCELL_ROW_8_149 VSS VDD sky130_fd_sc_hd__tapvpwrvgnd_1
XTAP_TAPCELL_ROW_8_150 VSS VDD sky130_fd_sc_hd__tapvpwrvgnd_1
XTAP_TAPCELL_ROW_8_151 VSS VDD sky130_fd_sc_hd__tapvpwrvgnd_1
XTAP_TAPCELL_ROW_8_152 VSS VDD sky130_fd_sc_hd__tapvpwrvgnd_1
XTAP_TAPCELL_ROW_8_153 VSS VDD sky130_fd_sc_hd__tapvpwrvgnd_1
XTAP_TAPCELL_ROW_8_154 VSS VDD sky130_fd_sc_hd__tapvpwrvgnd_1
XTAP_TAPCELL_ROW_9_155 VSS VDD sky130_fd_sc_hd__tapvpwrvgnd_1
XTAP_TAPCELL_ROW_9_156 VSS VDD sky130_fd_sc_hd__tapvpwrvgnd_1
XTAP_TAPCELL_ROW_9_157 VSS VDD sky130_fd_sc_hd__tapvpwrvgnd_1
XTAP_TAPCELL_ROW_9_158 VSS VDD sky130_fd_sc_hd__tapvpwrvgnd_1
XTAP_TAPCELL_ROW_9_159 VSS VDD sky130_fd_sc_hd__tapvpwrvgnd_1
XTAP_TAPCELL_ROW_9_160 VSS VDD sky130_fd_sc_hd__tapvpwrvgnd_1
XTAP_TAPCELL_ROW_9_161 VSS VDD sky130_fd_sc_hd__tapvpwrvgnd_1
XTAP_TAPCELL_ROW_9_162 VSS VDD sky130_fd_sc_hd__tapvpwrvgnd_1
XTAP_TAPCELL_ROW_9_163 VSS VDD sky130_fd_sc_hd__tapvpwrvgnd_1
XTAP_TAPCELL_ROW_9_164 VSS VDD sky130_fd_sc_hd__tapvpwrvgnd_1
XTAP_TAPCELL_ROW_9_165 VSS VDD sky130_fd_sc_hd__tapvpwrvgnd_1
XTAP_TAPCELL_ROW_9_166 VSS VDD sky130_fd_sc_hd__tapvpwrvgnd_1
XTAP_TAPCELL_ROW_9_167 VSS VDD sky130_fd_sc_hd__tapvpwrvgnd_1
XTAP_TAPCELL_ROW_9_168 VSS VDD sky130_fd_sc_hd__tapvpwrvgnd_1
XTAP_TAPCELL_ROW_9_169 VSS VDD sky130_fd_sc_hd__tapvpwrvgnd_1
XTAP_TAPCELL_ROW_10_170 VSS VDD sky130_fd_sc_hd__tapvpwrvgnd_1
XTAP_TAPCELL_ROW_10_171 VSS VDD sky130_fd_sc_hd__tapvpwrvgnd_1
XTAP_TAPCELL_ROW_10_172 VSS VDD sky130_fd_sc_hd__tapvpwrvgnd_1
XTAP_TAPCELL_ROW_10_173 VSS VDD sky130_fd_sc_hd__tapvpwrvgnd_1
XTAP_TAPCELL_ROW_10_174 VSS VDD sky130_fd_sc_hd__tapvpwrvgnd_1
XTAP_TAPCELL_ROW_10_175 VSS VDD sky130_fd_sc_hd__tapvpwrvgnd_1
XTAP_TAPCELL_ROW_10_176 VSS VDD sky130_fd_sc_hd__tapvpwrvgnd_1
XTAP_TAPCELL_ROW_10_177 VSS VDD sky130_fd_sc_hd__tapvpwrvgnd_1
XTAP_TAPCELL_ROW_10_178 VSS VDD sky130_fd_sc_hd__tapvpwrvgnd_1
XTAP_TAPCELL_ROW_10_179 VSS VDD sky130_fd_sc_hd__tapvpwrvgnd_1
XTAP_TAPCELL_ROW_10_180 VSS VDD sky130_fd_sc_hd__tapvpwrvgnd_1
XTAP_TAPCELL_ROW_10_181 VSS VDD sky130_fd_sc_hd__tapvpwrvgnd_1
XTAP_TAPCELL_ROW_10_182 VSS VDD sky130_fd_sc_hd__tapvpwrvgnd_1
XTAP_TAPCELL_ROW_10_183 VSS VDD sky130_fd_sc_hd__tapvpwrvgnd_1
XTAP_TAPCELL_ROW_10_184 VSS VDD sky130_fd_sc_hd__tapvpwrvgnd_1
XTAP_TAPCELL_ROW_10_185 VSS VDD sky130_fd_sc_hd__tapvpwrvgnd_1
XTAP_TAPCELL_ROW_11_186 VSS VDD sky130_fd_sc_hd__tapvpwrvgnd_1
XTAP_TAPCELL_ROW_11_187 VSS VDD sky130_fd_sc_hd__tapvpwrvgnd_1
XTAP_TAPCELL_ROW_11_188 VSS VDD sky130_fd_sc_hd__tapvpwrvgnd_1
XTAP_TAPCELL_ROW_11_189 VSS VDD sky130_fd_sc_hd__tapvpwrvgnd_1
XTAP_TAPCELL_ROW_11_190 VSS VDD sky130_fd_sc_hd__tapvpwrvgnd_1
XTAP_TAPCELL_ROW_11_191 VSS VDD sky130_fd_sc_hd__tapvpwrvgnd_1
XTAP_TAPCELL_ROW_11_192 VSS VDD sky130_fd_sc_hd__tapvpwrvgnd_1
XTAP_TAPCELL_ROW_11_193 VSS VDD sky130_fd_sc_hd__tapvpwrvgnd_1
XTAP_TAPCELL_ROW_11_194 VSS VDD sky130_fd_sc_hd__tapvpwrvgnd_1
XTAP_TAPCELL_ROW_11_195 VSS VDD sky130_fd_sc_hd__tapvpwrvgnd_1
XTAP_TAPCELL_ROW_11_196 VSS VDD sky130_fd_sc_hd__tapvpwrvgnd_1
XTAP_TAPCELL_ROW_11_197 VSS VDD sky130_fd_sc_hd__tapvpwrvgnd_1
XTAP_TAPCELL_ROW_11_198 VSS VDD sky130_fd_sc_hd__tapvpwrvgnd_1
XTAP_TAPCELL_ROW_11_199 VSS VDD sky130_fd_sc_hd__tapvpwrvgnd_1
XTAP_TAPCELL_ROW_11_200 VSS VDD sky130_fd_sc_hd__tapvpwrvgnd_1
XTAP_TAPCELL_ROW_12_201 VSS VDD sky130_fd_sc_hd__tapvpwrvgnd_1
XTAP_TAPCELL_ROW_12_202 VSS VDD sky130_fd_sc_hd__tapvpwrvgnd_1
XTAP_TAPCELL_ROW_12_203 VSS VDD sky130_fd_sc_hd__tapvpwrvgnd_1
XTAP_TAPCELL_ROW_12_204 VSS VDD sky130_fd_sc_hd__tapvpwrvgnd_1
XTAP_TAPCELL_ROW_12_205 VSS VDD sky130_fd_sc_hd__tapvpwrvgnd_1
XTAP_TAPCELL_ROW_12_206 VSS VDD sky130_fd_sc_hd__tapvpwrvgnd_1
XTAP_TAPCELL_ROW_12_207 VSS VDD sky130_fd_sc_hd__tapvpwrvgnd_1
XTAP_TAPCELL_ROW_12_208 VSS VDD sky130_fd_sc_hd__tapvpwrvgnd_1
XTAP_TAPCELL_ROW_12_209 VSS VDD sky130_fd_sc_hd__tapvpwrvgnd_1
XTAP_TAPCELL_ROW_12_210 VSS VDD sky130_fd_sc_hd__tapvpwrvgnd_1
XTAP_TAPCELL_ROW_12_211 VSS VDD sky130_fd_sc_hd__tapvpwrvgnd_1
XTAP_TAPCELL_ROW_12_212 VSS VDD sky130_fd_sc_hd__tapvpwrvgnd_1
XTAP_TAPCELL_ROW_12_213 VSS VDD sky130_fd_sc_hd__tapvpwrvgnd_1
XTAP_TAPCELL_ROW_12_214 VSS VDD sky130_fd_sc_hd__tapvpwrvgnd_1
XTAP_TAPCELL_ROW_12_215 VSS VDD sky130_fd_sc_hd__tapvpwrvgnd_1
XTAP_TAPCELL_ROW_12_216 VSS VDD sky130_fd_sc_hd__tapvpwrvgnd_1
XTAP_TAPCELL_ROW_13_217 VSS VDD sky130_fd_sc_hd__tapvpwrvgnd_1
XTAP_TAPCELL_ROW_13_218 VSS VDD sky130_fd_sc_hd__tapvpwrvgnd_1
XTAP_TAPCELL_ROW_13_219 VSS VDD sky130_fd_sc_hd__tapvpwrvgnd_1
XTAP_TAPCELL_ROW_13_220 VSS VDD sky130_fd_sc_hd__tapvpwrvgnd_1
XTAP_TAPCELL_ROW_13_221 VSS VDD sky130_fd_sc_hd__tapvpwrvgnd_1
XTAP_TAPCELL_ROW_13_222 VSS VDD sky130_fd_sc_hd__tapvpwrvgnd_1
XTAP_TAPCELL_ROW_13_223 VSS VDD sky130_fd_sc_hd__tapvpwrvgnd_1
XTAP_TAPCELL_ROW_13_224 VSS VDD sky130_fd_sc_hd__tapvpwrvgnd_1
XTAP_TAPCELL_ROW_13_225 VSS VDD sky130_fd_sc_hd__tapvpwrvgnd_1
XTAP_TAPCELL_ROW_13_226 VSS VDD sky130_fd_sc_hd__tapvpwrvgnd_1
XTAP_TAPCELL_ROW_13_227 VSS VDD sky130_fd_sc_hd__tapvpwrvgnd_1
XTAP_TAPCELL_ROW_13_228 VSS VDD sky130_fd_sc_hd__tapvpwrvgnd_1
XTAP_TAPCELL_ROW_13_229 VSS VDD sky130_fd_sc_hd__tapvpwrvgnd_1
XTAP_TAPCELL_ROW_13_230 VSS VDD sky130_fd_sc_hd__tapvpwrvgnd_1
XTAP_TAPCELL_ROW_13_231 VSS VDD sky130_fd_sc_hd__tapvpwrvgnd_1
XTAP_TAPCELL_ROW_14_232 VSS VDD sky130_fd_sc_hd__tapvpwrvgnd_1
XTAP_TAPCELL_ROW_14_233 VSS VDD sky130_fd_sc_hd__tapvpwrvgnd_1
XTAP_TAPCELL_ROW_14_234 VSS VDD sky130_fd_sc_hd__tapvpwrvgnd_1
XTAP_TAPCELL_ROW_14_235 VSS VDD sky130_fd_sc_hd__tapvpwrvgnd_1
XTAP_TAPCELL_ROW_14_236 VSS VDD sky130_fd_sc_hd__tapvpwrvgnd_1
XTAP_TAPCELL_ROW_14_237 VSS VDD sky130_fd_sc_hd__tapvpwrvgnd_1
XTAP_TAPCELL_ROW_14_238 VSS VDD sky130_fd_sc_hd__tapvpwrvgnd_1
XTAP_TAPCELL_ROW_14_239 VSS VDD sky130_fd_sc_hd__tapvpwrvgnd_1
XTAP_TAPCELL_ROW_14_240 VSS VDD sky130_fd_sc_hd__tapvpwrvgnd_1
XTAP_TAPCELL_ROW_14_241 VSS VDD sky130_fd_sc_hd__tapvpwrvgnd_1
XTAP_TAPCELL_ROW_14_242 VSS VDD sky130_fd_sc_hd__tapvpwrvgnd_1
XTAP_TAPCELL_ROW_14_243 VSS VDD sky130_fd_sc_hd__tapvpwrvgnd_1
XTAP_TAPCELL_ROW_14_244 VSS VDD sky130_fd_sc_hd__tapvpwrvgnd_1
XTAP_TAPCELL_ROW_14_245 VSS VDD sky130_fd_sc_hd__tapvpwrvgnd_1
XTAP_TAPCELL_ROW_14_246 VSS VDD sky130_fd_sc_hd__tapvpwrvgnd_1
XTAP_TAPCELL_ROW_14_247 VSS VDD sky130_fd_sc_hd__tapvpwrvgnd_1
XTAP_TAPCELL_ROW_15_248 VSS VDD sky130_fd_sc_hd__tapvpwrvgnd_1
XTAP_TAPCELL_ROW_15_249 VSS VDD sky130_fd_sc_hd__tapvpwrvgnd_1
XTAP_TAPCELL_ROW_15_250 VSS VDD sky130_fd_sc_hd__tapvpwrvgnd_1
XTAP_TAPCELL_ROW_15_251 VSS VDD sky130_fd_sc_hd__tapvpwrvgnd_1
XTAP_TAPCELL_ROW_15_252 VSS VDD sky130_fd_sc_hd__tapvpwrvgnd_1
XTAP_TAPCELL_ROW_15_253 VSS VDD sky130_fd_sc_hd__tapvpwrvgnd_1
XTAP_TAPCELL_ROW_15_254 VSS VDD sky130_fd_sc_hd__tapvpwrvgnd_1
XTAP_TAPCELL_ROW_15_255 VSS VDD sky130_fd_sc_hd__tapvpwrvgnd_1
XTAP_TAPCELL_ROW_15_256 VSS VDD sky130_fd_sc_hd__tapvpwrvgnd_1
XTAP_TAPCELL_ROW_15_257 VSS VDD sky130_fd_sc_hd__tapvpwrvgnd_1
XTAP_TAPCELL_ROW_15_258 VSS VDD sky130_fd_sc_hd__tapvpwrvgnd_1
XTAP_TAPCELL_ROW_15_259 VSS VDD sky130_fd_sc_hd__tapvpwrvgnd_1
XTAP_TAPCELL_ROW_15_260 VSS VDD sky130_fd_sc_hd__tapvpwrvgnd_1
XTAP_TAPCELL_ROW_15_261 VSS VDD sky130_fd_sc_hd__tapvpwrvgnd_1
XTAP_TAPCELL_ROW_15_262 VSS VDD sky130_fd_sc_hd__tapvpwrvgnd_1
XTAP_TAPCELL_ROW_16_263 VSS VDD sky130_fd_sc_hd__tapvpwrvgnd_1
XTAP_TAPCELL_ROW_16_264 VSS VDD sky130_fd_sc_hd__tapvpwrvgnd_1
XTAP_TAPCELL_ROW_16_265 VSS VDD sky130_fd_sc_hd__tapvpwrvgnd_1
XTAP_TAPCELL_ROW_16_266 VSS VDD sky130_fd_sc_hd__tapvpwrvgnd_1
XTAP_TAPCELL_ROW_16_267 VSS VDD sky130_fd_sc_hd__tapvpwrvgnd_1
XTAP_TAPCELL_ROW_16_268 VSS VDD sky130_fd_sc_hd__tapvpwrvgnd_1
XTAP_TAPCELL_ROW_16_269 VSS VDD sky130_fd_sc_hd__tapvpwrvgnd_1
XTAP_TAPCELL_ROW_16_270 VSS VDD sky130_fd_sc_hd__tapvpwrvgnd_1
XTAP_TAPCELL_ROW_16_271 VSS VDD sky130_fd_sc_hd__tapvpwrvgnd_1
XTAP_TAPCELL_ROW_16_272 VSS VDD sky130_fd_sc_hd__tapvpwrvgnd_1
XTAP_TAPCELL_ROW_16_273 VSS VDD sky130_fd_sc_hd__tapvpwrvgnd_1
XTAP_TAPCELL_ROW_16_274 VSS VDD sky130_fd_sc_hd__tapvpwrvgnd_1
XTAP_TAPCELL_ROW_16_275 VSS VDD sky130_fd_sc_hd__tapvpwrvgnd_1
XTAP_TAPCELL_ROW_16_276 VSS VDD sky130_fd_sc_hd__tapvpwrvgnd_1
XTAP_TAPCELL_ROW_16_277 VSS VDD sky130_fd_sc_hd__tapvpwrvgnd_1
XTAP_TAPCELL_ROW_16_278 VSS VDD sky130_fd_sc_hd__tapvpwrvgnd_1
XTAP_TAPCELL_ROW_17_279 VSS VDD sky130_fd_sc_hd__tapvpwrvgnd_1
XTAP_TAPCELL_ROW_17_280 VSS VDD sky130_fd_sc_hd__tapvpwrvgnd_1
XTAP_TAPCELL_ROW_17_281 VSS VDD sky130_fd_sc_hd__tapvpwrvgnd_1
XTAP_TAPCELL_ROW_17_282 VSS VDD sky130_fd_sc_hd__tapvpwrvgnd_1
XTAP_TAPCELL_ROW_17_283 VSS VDD sky130_fd_sc_hd__tapvpwrvgnd_1
XTAP_TAPCELL_ROW_17_284 VSS VDD sky130_fd_sc_hd__tapvpwrvgnd_1
XTAP_TAPCELL_ROW_17_285 VSS VDD sky130_fd_sc_hd__tapvpwrvgnd_1
XTAP_TAPCELL_ROW_17_286 VSS VDD sky130_fd_sc_hd__tapvpwrvgnd_1
XTAP_TAPCELL_ROW_17_287 VSS VDD sky130_fd_sc_hd__tapvpwrvgnd_1
XTAP_TAPCELL_ROW_17_288 VSS VDD sky130_fd_sc_hd__tapvpwrvgnd_1
XTAP_TAPCELL_ROW_17_289 VSS VDD sky130_fd_sc_hd__tapvpwrvgnd_1
XTAP_TAPCELL_ROW_17_290 VSS VDD sky130_fd_sc_hd__tapvpwrvgnd_1
XTAP_TAPCELL_ROW_17_291 VSS VDD sky130_fd_sc_hd__tapvpwrvgnd_1
XTAP_TAPCELL_ROW_17_292 VSS VDD sky130_fd_sc_hd__tapvpwrvgnd_1
XTAP_TAPCELL_ROW_17_293 VSS VDD sky130_fd_sc_hd__tapvpwrvgnd_1
XTAP_TAPCELL_ROW_18_294 VSS VDD sky130_fd_sc_hd__tapvpwrvgnd_1
XTAP_TAPCELL_ROW_18_295 VSS VDD sky130_fd_sc_hd__tapvpwrvgnd_1
XTAP_TAPCELL_ROW_18_296 VSS VDD sky130_fd_sc_hd__tapvpwrvgnd_1
XTAP_TAPCELL_ROW_18_297 VSS VDD sky130_fd_sc_hd__tapvpwrvgnd_1
XTAP_TAPCELL_ROW_18_298 VSS VDD sky130_fd_sc_hd__tapvpwrvgnd_1
XTAP_TAPCELL_ROW_18_299 VSS VDD sky130_fd_sc_hd__tapvpwrvgnd_1
XTAP_TAPCELL_ROW_18_300 VSS VDD sky130_fd_sc_hd__tapvpwrvgnd_1
XTAP_TAPCELL_ROW_18_301 VSS VDD sky130_fd_sc_hd__tapvpwrvgnd_1
XTAP_TAPCELL_ROW_18_302 VSS VDD sky130_fd_sc_hd__tapvpwrvgnd_1
XTAP_TAPCELL_ROW_18_303 VSS VDD sky130_fd_sc_hd__tapvpwrvgnd_1
XTAP_TAPCELL_ROW_18_304 VSS VDD sky130_fd_sc_hd__tapvpwrvgnd_1
XTAP_TAPCELL_ROW_18_305 VSS VDD sky130_fd_sc_hd__tapvpwrvgnd_1
XTAP_TAPCELL_ROW_18_306 VSS VDD sky130_fd_sc_hd__tapvpwrvgnd_1
XTAP_TAPCELL_ROW_18_307 VSS VDD sky130_fd_sc_hd__tapvpwrvgnd_1
XTAP_TAPCELL_ROW_18_308 VSS VDD sky130_fd_sc_hd__tapvpwrvgnd_1
XTAP_TAPCELL_ROW_18_309 VSS VDD sky130_fd_sc_hd__tapvpwrvgnd_1
XTAP_TAPCELL_ROW_19_310 VSS VDD sky130_fd_sc_hd__tapvpwrvgnd_1
XTAP_TAPCELL_ROW_19_311 VSS VDD sky130_fd_sc_hd__tapvpwrvgnd_1
XTAP_TAPCELL_ROW_19_312 VSS VDD sky130_fd_sc_hd__tapvpwrvgnd_1
XTAP_TAPCELL_ROW_19_313 VSS VDD sky130_fd_sc_hd__tapvpwrvgnd_1
XTAP_TAPCELL_ROW_19_314 VSS VDD sky130_fd_sc_hd__tapvpwrvgnd_1
XTAP_TAPCELL_ROW_19_315 VSS VDD sky130_fd_sc_hd__tapvpwrvgnd_1
XTAP_TAPCELL_ROW_19_316 VSS VDD sky130_fd_sc_hd__tapvpwrvgnd_1
XTAP_TAPCELL_ROW_19_317 VSS VDD sky130_fd_sc_hd__tapvpwrvgnd_1
XTAP_TAPCELL_ROW_19_318 VSS VDD sky130_fd_sc_hd__tapvpwrvgnd_1
XTAP_TAPCELL_ROW_19_319 VSS VDD sky130_fd_sc_hd__tapvpwrvgnd_1
XTAP_TAPCELL_ROW_19_320 VSS VDD sky130_fd_sc_hd__tapvpwrvgnd_1
XTAP_TAPCELL_ROW_19_321 VSS VDD sky130_fd_sc_hd__tapvpwrvgnd_1
XTAP_TAPCELL_ROW_19_322 VSS VDD sky130_fd_sc_hd__tapvpwrvgnd_1
XTAP_TAPCELL_ROW_19_323 VSS VDD sky130_fd_sc_hd__tapvpwrvgnd_1
XTAP_TAPCELL_ROW_19_324 VSS VDD sky130_fd_sc_hd__tapvpwrvgnd_1
XTAP_TAPCELL_ROW_20_325 VSS VDD sky130_fd_sc_hd__tapvpwrvgnd_1
XTAP_TAPCELL_ROW_20_326 VSS VDD sky130_fd_sc_hd__tapvpwrvgnd_1
XTAP_TAPCELL_ROW_20_327 VSS VDD sky130_fd_sc_hd__tapvpwrvgnd_1
XTAP_TAPCELL_ROW_20_328 VSS VDD sky130_fd_sc_hd__tapvpwrvgnd_1
XTAP_TAPCELL_ROW_20_329 VSS VDD sky130_fd_sc_hd__tapvpwrvgnd_1
XTAP_TAPCELL_ROW_20_330 VSS VDD sky130_fd_sc_hd__tapvpwrvgnd_1
XTAP_TAPCELL_ROW_20_331 VSS VDD sky130_fd_sc_hd__tapvpwrvgnd_1
XTAP_TAPCELL_ROW_20_332 VSS VDD sky130_fd_sc_hd__tapvpwrvgnd_1
XTAP_TAPCELL_ROW_20_333 VSS VDD sky130_fd_sc_hd__tapvpwrvgnd_1
XTAP_TAPCELL_ROW_20_334 VSS VDD sky130_fd_sc_hd__tapvpwrvgnd_1
XTAP_TAPCELL_ROW_20_335 VSS VDD sky130_fd_sc_hd__tapvpwrvgnd_1
XTAP_TAPCELL_ROW_20_336 VSS VDD sky130_fd_sc_hd__tapvpwrvgnd_1
XTAP_TAPCELL_ROW_20_337 VSS VDD sky130_fd_sc_hd__tapvpwrvgnd_1
XTAP_TAPCELL_ROW_20_338 VSS VDD sky130_fd_sc_hd__tapvpwrvgnd_1
XTAP_TAPCELL_ROW_20_339 VSS VDD sky130_fd_sc_hd__tapvpwrvgnd_1
XTAP_TAPCELL_ROW_20_340 VSS VDD sky130_fd_sc_hd__tapvpwrvgnd_1
XTAP_TAPCELL_ROW_21_341 VSS VDD sky130_fd_sc_hd__tapvpwrvgnd_1
XTAP_TAPCELL_ROW_21_342 VSS VDD sky130_fd_sc_hd__tapvpwrvgnd_1
XTAP_TAPCELL_ROW_21_343 VSS VDD sky130_fd_sc_hd__tapvpwrvgnd_1
XTAP_TAPCELL_ROW_21_344 VSS VDD sky130_fd_sc_hd__tapvpwrvgnd_1
XTAP_TAPCELL_ROW_21_345 VSS VDD sky130_fd_sc_hd__tapvpwrvgnd_1
XTAP_TAPCELL_ROW_21_346 VSS VDD sky130_fd_sc_hd__tapvpwrvgnd_1
XTAP_TAPCELL_ROW_21_347 VSS VDD sky130_fd_sc_hd__tapvpwrvgnd_1
XTAP_TAPCELL_ROW_21_348 VSS VDD sky130_fd_sc_hd__tapvpwrvgnd_1
XTAP_TAPCELL_ROW_21_349 VSS VDD sky130_fd_sc_hd__tapvpwrvgnd_1
XTAP_TAPCELL_ROW_21_350 VSS VDD sky130_fd_sc_hd__tapvpwrvgnd_1
XTAP_TAPCELL_ROW_21_351 VSS VDD sky130_fd_sc_hd__tapvpwrvgnd_1
XTAP_TAPCELL_ROW_21_352 VSS VDD sky130_fd_sc_hd__tapvpwrvgnd_1
XTAP_TAPCELL_ROW_21_353 VSS VDD sky130_fd_sc_hd__tapvpwrvgnd_1
XTAP_TAPCELL_ROW_21_354 VSS VDD sky130_fd_sc_hd__tapvpwrvgnd_1
XTAP_TAPCELL_ROW_21_355 VSS VDD sky130_fd_sc_hd__tapvpwrvgnd_1
XTAP_TAPCELL_ROW_22_356 VSS VDD sky130_fd_sc_hd__tapvpwrvgnd_1
XTAP_TAPCELL_ROW_22_357 VSS VDD sky130_fd_sc_hd__tapvpwrvgnd_1
XTAP_TAPCELL_ROW_22_358 VSS VDD sky130_fd_sc_hd__tapvpwrvgnd_1
XTAP_TAPCELL_ROW_22_359 VSS VDD sky130_fd_sc_hd__tapvpwrvgnd_1
XTAP_TAPCELL_ROW_22_360 VSS VDD sky130_fd_sc_hd__tapvpwrvgnd_1
XTAP_TAPCELL_ROW_22_361 VSS VDD sky130_fd_sc_hd__tapvpwrvgnd_1
XTAP_TAPCELL_ROW_22_362 VSS VDD sky130_fd_sc_hd__tapvpwrvgnd_1
XTAP_TAPCELL_ROW_22_363 VSS VDD sky130_fd_sc_hd__tapvpwrvgnd_1
XTAP_TAPCELL_ROW_22_364 VSS VDD sky130_fd_sc_hd__tapvpwrvgnd_1
XTAP_TAPCELL_ROW_22_365 VSS VDD sky130_fd_sc_hd__tapvpwrvgnd_1
XTAP_TAPCELL_ROW_22_366 VSS VDD sky130_fd_sc_hd__tapvpwrvgnd_1
XTAP_TAPCELL_ROW_22_367 VSS VDD sky130_fd_sc_hd__tapvpwrvgnd_1
XTAP_TAPCELL_ROW_22_368 VSS VDD sky130_fd_sc_hd__tapvpwrvgnd_1
XTAP_TAPCELL_ROW_22_369 VSS VDD sky130_fd_sc_hd__tapvpwrvgnd_1
XTAP_TAPCELL_ROW_22_370 VSS VDD sky130_fd_sc_hd__tapvpwrvgnd_1
XTAP_TAPCELL_ROW_22_371 VSS VDD sky130_fd_sc_hd__tapvpwrvgnd_1
XTAP_TAPCELL_ROW_23_372 VSS VDD sky130_fd_sc_hd__tapvpwrvgnd_1
XTAP_TAPCELL_ROW_23_373 VSS VDD sky130_fd_sc_hd__tapvpwrvgnd_1
XTAP_TAPCELL_ROW_23_374 VSS VDD sky130_fd_sc_hd__tapvpwrvgnd_1
XTAP_TAPCELL_ROW_23_375 VSS VDD sky130_fd_sc_hd__tapvpwrvgnd_1
XTAP_TAPCELL_ROW_23_376 VSS VDD sky130_fd_sc_hd__tapvpwrvgnd_1
XTAP_TAPCELL_ROW_23_377 VSS VDD sky130_fd_sc_hd__tapvpwrvgnd_1
XTAP_TAPCELL_ROW_23_378 VSS VDD sky130_fd_sc_hd__tapvpwrvgnd_1
XTAP_TAPCELL_ROW_23_379 VSS VDD sky130_fd_sc_hd__tapvpwrvgnd_1
XTAP_TAPCELL_ROW_23_380 VSS VDD sky130_fd_sc_hd__tapvpwrvgnd_1
XTAP_TAPCELL_ROW_23_381 VSS VDD sky130_fd_sc_hd__tapvpwrvgnd_1
XTAP_TAPCELL_ROW_23_382 VSS VDD sky130_fd_sc_hd__tapvpwrvgnd_1
XTAP_TAPCELL_ROW_23_383 VSS VDD sky130_fd_sc_hd__tapvpwrvgnd_1
XTAP_TAPCELL_ROW_23_384 VSS VDD sky130_fd_sc_hd__tapvpwrvgnd_1
XTAP_TAPCELL_ROW_23_385 VSS VDD sky130_fd_sc_hd__tapvpwrvgnd_1
XTAP_TAPCELL_ROW_23_386 VSS VDD sky130_fd_sc_hd__tapvpwrvgnd_1
XTAP_TAPCELL_ROW_24_387 VSS VDD sky130_fd_sc_hd__tapvpwrvgnd_1
XTAP_TAPCELL_ROW_24_388 VSS VDD sky130_fd_sc_hd__tapvpwrvgnd_1
XTAP_TAPCELL_ROW_24_389 VSS VDD sky130_fd_sc_hd__tapvpwrvgnd_1
XTAP_TAPCELL_ROW_24_390 VSS VDD sky130_fd_sc_hd__tapvpwrvgnd_1
XTAP_TAPCELL_ROW_24_391 VSS VDD sky130_fd_sc_hd__tapvpwrvgnd_1
XTAP_TAPCELL_ROW_24_392 VSS VDD sky130_fd_sc_hd__tapvpwrvgnd_1
XTAP_TAPCELL_ROW_24_393 VSS VDD sky130_fd_sc_hd__tapvpwrvgnd_1
XTAP_TAPCELL_ROW_24_394 VSS VDD sky130_fd_sc_hd__tapvpwrvgnd_1
XTAP_TAPCELL_ROW_24_395 VSS VDD sky130_fd_sc_hd__tapvpwrvgnd_1
XTAP_TAPCELL_ROW_24_396 VSS VDD sky130_fd_sc_hd__tapvpwrvgnd_1
XTAP_TAPCELL_ROW_24_397 VSS VDD sky130_fd_sc_hd__tapvpwrvgnd_1
XTAP_TAPCELL_ROW_24_398 VSS VDD sky130_fd_sc_hd__tapvpwrvgnd_1
XTAP_TAPCELL_ROW_24_399 VSS VDD sky130_fd_sc_hd__tapvpwrvgnd_1
XTAP_TAPCELL_ROW_24_400 VSS VDD sky130_fd_sc_hd__tapvpwrvgnd_1
XTAP_TAPCELL_ROW_24_401 VSS VDD sky130_fd_sc_hd__tapvpwrvgnd_1
XTAP_TAPCELL_ROW_24_402 VSS VDD sky130_fd_sc_hd__tapvpwrvgnd_1
XTAP_TAPCELL_ROW_25_403 VSS VDD sky130_fd_sc_hd__tapvpwrvgnd_1
XTAP_TAPCELL_ROW_25_404 VSS VDD sky130_fd_sc_hd__tapvpwrvgnd_1
XTAP_TAPCELL_ROW_25_405 VSS VDD sky130_fd_sc_hd__tapvpwrvgnd_1
XTAP_TAPCELL_ROW_25_406 VSS VDD sky130_fd_sc_hd__tapvpwrvgnd_1
XTAP_TAPCELL_ROW_25_407 VSS VDD sky130_fd_sc_hd__tapvpwrvgnd_1
XTAP_TAPCELL_ROW_25_408 VSS VDD sky130_fd_sc_hd__tapvpwrvgnd_1
XTAP_TAPCELL_ROW_25_409 VSS VDD sky130_fd_sc_hd__tapvpwrvgnd_1
XTAP_TAPCELL_ROW_25_410 VSS VDD sky130_fd_sc_hd__tapvpwrvgnd_1
XTAP_TAPCELL_ROW_25_411 VSS VDD sky130_fd_sc_hd__tapvpwrvgnd_1
XTAP_TAPCELL_ROW_25_412 VSS VDD sky130_fd_sc_hd__tapvpwrvgnd_1
XTAP_TAPCELL_ROW_25_413 VSS VDD sky130_fd_sc_hd__tapvpwrvgnd_1
XTAP_TAPCELL_ROW_25_414 VSS VDD sky130_fd_sc_hd__tapvpwrvgnd_1
XTAP_TAPCELL_ROW_25_415 VSS VDD sky130_fd_sc_hd__tapvpwrvgnd_1
XTAP_TAPCELL_ROW_25_416 VSS VDD sky130_fd_sc_hd__tapvpwrvgnd_1
XTAP_TAPCELL_ROW_25_417 VSS VDD sky130_fd_sc_hd__tapvpwrvgnd_1
XTAP_TAPCELL_ROW_26_418 VSS VDD sky130_fd_sc_hd__tapvpwrvgnd_1
XTAP_TAPCELL_ROW_26_419 VSS VDD sky130_fd_sc_hd__tapvpwrvgnd_1
XTAP_TAPCELL_ROW_26_420 VSS VDD sky130_fd_sc_hd__tapvpwrvgnd_1
XTAP_TAPCELL_ROW_26_421 VSS VDD sky130_fd_sc_hd__tapvpwrvgnd_1
XTAP_TAPCELL_ROW_26_422 VSS VDD sky130_fd_sc_hd__tapvpwrvgnd_1
XTAP_TAPCELL_ROW_26_423 VSS VDD sky130_fd_sc_hd__tapvpwrvgnd_1
XTAP_TAPCELL_ROW_26_424 VSS VDD sky130_fd_sc_hd__tapvpwrvgnd_1
XTAP_TAPCELL_ROW_26_425 VSS VDD sky130_fd_sc_hd__tapvpwrvgnd_1
XTAP_TAPCELL_ROW_26_426 VSS VDD sky130_fd_sc_hd__tapvpwrvgnd_1
XTAP_TAPCELL_ROW_26_427 VSS VDD sky130_fd_sc_hd__tapvpwrvgnd_1
XTAP_TAPCELL_ROW_26_428 VSS VDD sky130_fd_sc_hd__tapvpwrvgnd_1
XTAP_TAPCELL_ROW_26_429 VSS VDD sky130_fd_sc_hd__tapvpwrvgnd_1
XTAP_TAPCELL_ROW_26_430 VSS VDD sky130_fd_sc_hd__tapvpwrvgnd_1
XTAP_TAPCELL_ROW_26_431 VSS VDD sky130_fd_sc_hd__tapvpwrvgnd_1
XTAP_TAPCELL_ROW_26_432 VSS VDD sky130_fd_sc_hd__tapvpwrvgnd_1
XTAP_TAPCELL_ROW_26_433 VSS VDD sky130_fd_sc_hd__tapvpwrvgnd_1
XTAP_TAPCELL_ROW_27_434 VSS VDD sky130_fd_sc_hd__tapvpwrvgnd_1
XTAP_TAPCELL_ROW_27_435 VSS VDD sky130_fd_sc_hd__tapvpwrvgnd_1
XTAP_TAPCELL_ROW_27_436 VSS VDD sky130_fd_sc_hd__tapvpwrvgnd_1
XTAP_TAPCELL_ROW_27_437 VSS VDD sky130_fd_sc_hd__tapvpwrvgnd_1
XTAP_TAPCELL_ROW_27_438 VSS VDD sky130_fd_sc_hd__tapvpwrvgnd_1
XTAP_TAPCELL_ROW_27_439 VSS VDD sky130_fd_sc_hd__tapvpwrvgnd_1
XTAP_TAPCELL_ROW_27_440 VSS VDD sky130_fd_sc_hd__tapvpwrvgnd_1
XTAP_TAPCELL_ROW_27_441 VSS VDD sky130_fd_sc_hd__tapvpwrvgnd_1
XTAP_TAPCELL_ROW_27_442 VSS VDD sky130_fd_sc_hd__tapvpwrvgnd_1
XTAP_TAPCELL_ROW_27_443 VSS VDD sky130_fd_sc_hd__tapvpwrvgnd_1
XTAP_TAPCELL_ROW_27_444 VSS VDD sky130_fd_sc_hd__tapvpwrvgnd_1
XTAP_TAPCELL_ROW_27_445 VSS VDD sky130_fd_sc_hd__tapvpwrvgnd_1
XTAP_TAPCELL_ROW_27_446 VSS VDD sky130_fd_sc_hd__tapvpwrvgnd_1
XTAP_TAPCELL_ROW_27_447 VSS VDD sky130_fd_sc_hd__tapvpwrvgnd_1
XTAP_TAPCELL_ROW_27_448 VSS VDD sky130_fd_sc_hd__tapvpwrvgnd_1
XTAP_TAPCELL_ROW_28_449 VSS VDD sky130_fd_sc_hd__tapvpwrvgnd_1
XTAP_TAPCELL_ROW_28_450 VSS VDD sky130_fd_sc_hd__tapvpwrvgnd_1
XTAP_TAPCELL_ROW_28_451 VSS VDD sky130_fd_sc_hd__tapvpwrvgnd_1
XTAP_TAPCELL_ROW_28_452 VSS VDD sky130_fd_sc_hd__tapvpwrvgnd_1
XTAP_TAPCELL_ROW_28_453 VSS VDD sky130_fd_sc_hd__tapvpwrvgnd_1
XTAP_TAPCELL_ROW_28_454 VSS VDD sky130_fd_sc_hd__tapvpwrvgnd_1
XTAP_TAPCELL_ROW_28_455 VSS VDD sky130_fd_sc_hd__tapvpwrvgnd_1
XTAP_TAPCELL_ROW_28_456 VSS VDD sky130_fd_sc_hd__tapvpwrvgnd_1
XTAP_TAPCELL_ROW_28_457 VSS VDD sky130_fd_sc_hd__tapvpwrvgnd_1
XTAP_TAPCELL_ROW_28_458 VSS VDD sky130_fd_sc_hd__tapvpwrvgnd_1
XTAP_TAPCELL_ROW_28_459 VSS VDD sky130_fd_sc_hd__tapvpwrvgnd_1
XTAP_TAPCELL_ROW_28_460 VSS VDD sky130_fd_sc_hd__tapvpwrvgnd_1
XTAP_TAPCELL_ROW_28_461 VSS VDD sky130_fd_sc_hd__tapvpwrvgnd_1
XTAP_TAPCELL_ROW_28_462 VSS VDD sky130_fd_sc_hd__tapvpwrvgnd_1
XTAP_TAPCELL_ROW_28_463 VSS VDD sky130_fd_sc_hd__tapvpwrvgnd_1
XTAP_TAPCELL_ROW_28_464 VSS VDD sky130_fd_sc_hd__tapvpwrvgnd_1
XTAP_TAPCELL_ROW_29_465 VSS VDD sky130_fd_sc_hd__tapvpwrvgnd_1
XTAP_TAPCELL_ROW_29_466 VSS VDD sky130_fd_sc_hd__tapvpwrvgnd_1
XTAP_TAPCELL_ROW_29_467 VSS VDD sky130_fd_sc_hd__tapvpwrvgnd_1
XTAP_TAPCELL_ROW_29_468 VSS VDD sky130_fd_sc_hd__tapvpwrvgnd_1
XTAP_TAPCELL_ROW_29_469 VSS VDD sky130_fd_sc_hd__tapvpwrvgnd_1
XTAP_TAPCELL_ROW_29_470 VSS VDD sky130_fd_sc_hd__tapvpwrvgnd_1
XTAP_TAPCELL_ROW_29_471 VSS VDD sky130_fd_sc_hd__tapvpwrvgnd_1
XTAP_TAPCELL_ROW_29_472 VSS VDD sky130_fd_sc_hd__tapvpwrvgnd_1
XTAP_TAPCELL_ROW_29_473 VSS VDD sky130_fd_sc_hd__tapvpwrvgnd_1
XTAP_TAPCELL_ROW_29_474 VSS VDD sky130_fd_sc_hd__tapvpwrvgnd_1
XTAP_TAPCELL_ROW_29_475 VSS VDD sky130_fd_sc_hd__tapvpwrvgnd_1
XTAP_TAPCELL_ROW_29_476 VSS VDD sky130_fd_sc_hd__tapvpwrvgnd_1
XTAP_TAPCELL_ROW_29_477 VSS VDD sky130_fd_sc_hd__tapvpwrvgnd_1
XTAP_TAPCELL_ROW_29_478 VSS VDD sky130_fd_sc_hd__tapvpwrvgnd_1
XTAP_TAPCELL_ROW_29_479 VSS VDD sky130_fd_sc_hd__tapvpwrvgnd_1
XTAP_TAPCELL_ROW_30_480 VSS VDD sky130_fd_sc_hd__tapvpwrvgnd_1
XTAP_TAPCELL_ROW_30_481 VSS VDD sky130_fd_sc_hd__tapvpwrvgnd_1
XTAP_TAPCELL_ROW_30_482 VSS VDD sky130_fd_sc_hd__tapvpwrvgnd_1
XTAP_TAPCELL_ROW_30_483 VSS VDD sky130_fd_sc_hd__tapvpwrvgnd_1
XTAP_TAPCELL_ROW_30_484 VSS VDD sky130_fd_sc_hd__tapvpwrvgnd_1
XTAP_TAPCELL_ROW_30_485 VSS VDD sky130_fd_sc_hd__tapvpwrvgnd_1
XTAP_TAPCELL_ROW_30_486 VSS VDD sky130_fd_sc_hd__tapvpwrvgnd_1
XTAP_TAPCELL_ROW_30_487 VSS VDD sky130_fd_sc_hd__tapvpwrvgnd_1
XTAP_TAPCELL_ROW_30_488 VSS VDD sky130_fd_sc_hd__tapvpwrvgnd_1
XTAP_TAPCELL_ROW_30_489 VSS VDD sky130_fd_sc_hd__tapvpwrvgnd_1
XTAP_TAPCELL_ROW_30_490 VSS VDD sky130_fd_sc_hd__tapvpwrvgnd_1
XTAP_TAPCELL_ROW_30_491 VSS VDD sky130_fd_sc_hd__tapvpwrvgnd_1
XTAP_TAPCELL_ROW_30_492 VSS VDD sky130_fd_sc_hd__tapvpwrvgnd_1
XTAP_TAPCELL_ROW_30_493 VSS VDD sky130_fd_sc_hd__tapvpwrvgnd_1
XTAP_TAPCELL_ROW_30_494 VSS VDD sky130_fd_sc_hd__tapvpwrvgnd_1
XTAP_TAPCELL_ROW_30_495 VSS VDD sky130_fd_sc_hd__tapvpwrvgnd_1
XTAP_TAPCELL_ROW_31_496 VSS VDD sky130_fd_sc_hd__tapvpwrvgnd_1
XTAP_TAPCELL_ROW_31_497 VSS VDD sky130_fd_sc_hd__tapvpwrvgnd_1
XTAP_TAPCELL_ROW_31_498 VSS VDD sky130_fd_sc_hd__tapvpwrvgnd_1
XTAP_TAPCELL_ROW_31_499 VSS VDD sky130_fd_sc_hd__tapvpwrvgnd_1
XTAP_TAPCELL_ROW_31_500 VSS VDD sky130_fd_sc_hd__tapvpwrvgnd_1
XTAP_TAPCELL_ROW_31_501 VSS VDD sky130_fd_sc_hd__tapvpwrvgnd_1
XTAP_TAPCELL_ROW_31_502 VSS VDD sky130_fd_sc_hd__tapvpwrvgnd_1
XTAP_TAPCELL_ROW_31_503 VSS VDD sky130_fd_sc_hd__tapvpwrvgnd_1
XTAP_TAPCELL_ROW_31_504 VSS VDD sky130_fd_sc_hd__tapvpwrvgnd_1
XTAP_TAPCELL_ROW_31_505 VSS VDD sky130_fd_sc_hd__tapvpwrvgnd_1
XTAP_TAPCELL_ROW_31_506 VSS VDD sky130_fd_sc_hd__tapvpwrvgnd_1
XTAP_TAPCELL_ROW_31_507 VSS VDD sky130_fd_sc_hd__tapvpwrvgnd_1
XTAP_TAPCELL_ROW_31_508 VSS VDD sky130_fd_sc_hd__tapvpwrvgnd_1
XTAP_TAPCELL_ROW_31_509 VSS VDD sky130_fd_sc_hd__tapvpwrvgnd_1
XTAP_TAPCELL_ROW_31_510 VSS VDD sky130_fd_sc_hd__tapvpwrvgnd_1
XTAP_TAPCELL_ROW_32_511 VSS VDD sky130_fd_sc_hd__tapvpwrvgnd_1
XTAP_TAPCELL_ROW_32_512 VSS VDD sky130_fd_sc_hd__tapvpwrvgnd_1
XTAP_TAPCELL_ROW_32_513 VSS VDD sky130_fd_sc_hd__tapvpwrvgnd_1
XTAP_TAPCELL_ROW_32_514 VSS VDD sky130_fd_sc_hd__tapvpwrvgnd_1
XTAP_TAPCELL_ROW_32_515 VSS VDD sky130_fd_sc_hd__tapvpwrvgnd_1
XTAP_TAPCELL_ROW_32_516 VSS VDD sky130_fd_sc_hd__tapvpwrvgnd_1
XTAP_TAPCELL_ROW_32_517 VSS VDD sky130_fd_sc_hd__tapvpwrvgnd_1
XTAP_TAPCELL_ROW_32_518 VSS VDD sky130_fd_sc_hd__tapvpwrvgnd_1
XTAP_TAPCELL_ROW_32_519 VSS VDD sky130_fd_sc_hd__tapvpwrvgnd_1
XTAP_TAPCELL_ROW_32_520 VSS VDD sky130_fd_sc_hd__tapvpwrvgnd_1
XTAP_TAPCELL_ROW_32_521 VSS VDD sky130_fd_sc_hd__tapvpwrvgnd_1
XTAP_TAPCELL_ROW_32_522 VSS VDD sky130_fd_sc_hd__tapvpwrvgnd_1
XTAP_TAPCELL_ROW_32_523 VSS VDD sky130_fd_sc_hd__tapvpwrvgnd_1
XTAP_TAPCELL_ROW_32_524 VSS VDD sky130_fd_sc_hd__tapvpwrvgnd_1
XTAP_TAPCELL_ROW_32_525 VSS VDD sky130_fd_sc_hd__tapvpwrvgnd_1
XTAP_TAPCELL_ROW_32_526 VSS VDD sky130_fd_sc_hd__tapvpwrvgnd_1
XTAP_TAPCELL_ROW_33_527 VSS VDD sky130_fd_sc_hd__tapvpwrvgnd_1
XTAP_TAPCELL_ROW_33_528 VSS VDD sky130_fd_sc_hd__tapvpwrvgnd_1
XTAP_TAPCELL_ROW_33_529 VSS VDD sky130_fd_sc_hd__tapvpwrvgnd_1
XTAP_TAPCELL_ROW_33_530 VSS VDD sky130_fd_sc_hd__tapvpwrvgnd_1
XTAP_TAPCELL_ROW_33_531 VSS VDD sky130_fd_sc_hd__tapvpwrvgnd_1
XTAP_TAPCELL_ROW_33_532 VSS VDD sky130_fd_sc_hd__tapvpwrvgnd_1
XTAP_TAPCELL_ROW_33_533 VSS VDD sky130_fd_sc_hd__tapvpwrvgnd_1
XTAP_TAPCELL_ROW_33_534 VSS VDD sky130_fd_sc_hd__tapvpwrvgnd_1
XTAP_TAPCELL_ROW_33_535 VSS VDD sky130_fd_sc_hd__tapvpwrvgnd_1
XTAP_TAPCELL_ROW_33_536 VSS VDD sky130_fd_sc_hd__tapvpwrvgnd_1
XTAP_TAPCELL_ROW_33_537 VSS VDD sky130_fd_sc_hd__tapvpwrvgnd_1
XTAP_TAPCELL_ROW_33_538 VSS VDD sky130_fd_sc_hd__tapvpwrvgnd_1
XTAP_TAPCELL_ROW_33_539 VSS VDD sky130_fd_sc_hd__tapvpwrvgnd_1
XTAP_TAPCELL_ROW_33_540 VSS VDD sky130_fd_sc_hd__tapvpwrvgnd_1
XTAP_TAPCELL_ROW_33_541 VSS VDD sky130_fd_sc_hd__tapvpwrvgnd_1
XTAP_TAPCELL_ROW_34_542 VSS VDD sky130_fd_sc_hd__tapvpwrvgnd_1
XTAP_TAPCELL_ROW_34_543 VSS VDD sky130_fd_sc_hd__tapvpwrvgnd_1
XTAP_TAPCELL_ROW_34_544 VSS VDD sky130_fd_sc_hd__tapvpwrvgnd_1
XTAP_TAPCELL_ROW_34_545 VSS VDD sky130_fd_sc_hd__tapvpwrvgnd_1
XTAP_TAPCELL_ROW_34_546 VSS VDD sky130_fd_sc_hd__tapvpwrvgnd_1
XTAP_TAPCELL_ROW_34_547 VSS VDD sky130_fd_sc_hd__tapvpwrvgnd_1
XTAP_TAPCELL_ROW_34_548 VSS VDD sky130_fd_sc_hd__tapvpwrvgnd_1
XTAP_TAPCELL_ROW_34_549 VSS VDD sky130_fd_sc_hd__tapvpwrvgnd_1
XTAP_TAPCELL_ROW_34_550 VSS VDD sky130_fd_sc_hd__tapvpwrvgnd_1
XTAP_TAPCELL_ROW_34_551 VSS VDD sky130_fd_sc_hd__tapvpwrvgnd_1
XTAP_TAPCELL_ROW_34_552 VSS VDD sky130_fd_sc_hd__tapvpwrvgnd_1
XTAP_TAPCELL_ROW_34_553 VSS VDD sky130_fd_sc_hd__tapvpwrvgnd_1
XTAP_TAPCELL_ROW_34_554 VSS VDD sky130_fd_sc_hd__tapvpwrvgnd_1
XTAP_TAPCELL_ROW_34_555 VSS VDD sky130_fd_sc_hd__tapvpwrvgnd_1
XTAP_TAPCELL_ROW_34_556 VSS VDD sky130_fd_sc_hd__tapvpwrvgnd_1
XTAP_TAPCELL_ROW_34_557 VSS VDD sky130_fd_sc_hd__tapvpwrvgnd_1
XTAP_TAPCELL_ROW_35_558 VSS VDD sky130_fd_sc_hd__tapvpwrvgnd_1
XTAP_TAPCELL_ROW_35_559 VSS VDD sky130_fd_sc_hd__tapvpwrvgnd_1
XTAP_TAPCELL_ROW_35_560 VSS VDD sky130_fd_sc_hd__tapvpwrvgnd_1
XTAP_TAPCELL_ROW_35_561 VSS VDD sky130_fd_sc_hd__tapvpwrvgnd_1
XTAP_TAPCELL_ROW_35_562 VSS VDD sky130_fd_sc_hd__tapvpwrvgnd_1
XTAP_TAPCELL_ROW_35_563 VSS VDD sky130_fd_sc_hd__tapvpwrvgnd_1
XTAP_TAPCELL_ROW_35_564 VSS VDD sky130_fd_sc_hd__tapvpwrvgnd_1
XTAP_TAPCELL_ROW_35_565 VSS VDD sky130_fd_sc_hd__tapvpwrvgnd_1
XTAP_TAPCELL_ROW_35_566 VSS VDD sky130_fd_sc_hd__tapvpwrvgnd_1
XTAP_TAPCELL_ROW_35_567 VSS VDD sky130_fd_sc_hd__tapvpwrvgnd_1
XTAP_TAPCELL_ROW_35_568 VSS VDD sky130_fd_sc_hd__tapvpwrvgnd_1
XTAP_TAPCELL_ROW_35_569 VSS VDD sky130_fd_sc_hd__tapvpwrvgnd_1
XTAP_TAPCELL_ROW_35_570 VSS VDD sky130_fd_sc_hd__tapvpwrvgnd_1
XTAP_TAPCELL_ROW_35_571 VSS VDD sky130_fd_sc_hd__tapvpwrvgnd_1
XTAP_TAPCELL_ROW_35_572 VSS VDD sky130_fd_sc_hd__tapvpwrvgnd_1
XTAP_TAPCELL_ROW_36_573 VSS VDD sky130_fd_sc_hd__tapvpwrvgnd_1
XTAP_TAPCELL_ROW_36_574 VSS VDD sky130_fd_sc_hd__tapvpwrvgnd_1
XTAP_TAPCELL_ROW_36_575 VSS VDD sky130_fd_sc_hd__tapvpwrvgnd_1
XTAP_TAPCELL_ROW_36_576 VSS VDD sky130_fd_sc_hd__tapvpwrvgnd_1
XTAP_TAPCELL_ROW_36_577 VSS VDD sky130_fd_sc_hd__tapvpwrvgnd_1
XTAP_TAPCELL_ROW_36_578 VSS VDD sky130_fd_sc_hd__tapvpwrvgnd_1
XTAP_TAPCELL_ROW_36_579 VSS VDD sky130_fd_sc_hd__tapvpwrvgnd_1
XTAP_TAPCELL_ROW_36_580 VSS VDD sky130_fd_sc_hd__tapvpwrvgnd_1
XTAP_TAPCELL_ROW_36_581 VSS VDD sky130_fd_sc_hd__tapvpwrvgnd_1
XTAP_TAPCELL_ROW_36_582 VSS VDD sky130_fd_sc_hd__tapvpwrvgnd_1
XTAP_TAPCELL_ROW_36_583 VSS VDD sky130_fd_sc_hd__tapvpwrvgnd_1
XTAP_TAPCELL_ROW_36_584 VSS VDD sky130_fd_sc_hd__tapvpwrvgnd_1
XTAP_TAPCELL_ROW_36_585 VSS VDD sky130_fd_sc_hd__tapvpwrvgnd_1
XTAP_TAPCELL_ROW_36_586 VSS VDD sky130_fd_sc_hd__tapvpwrvgnd_1
XTAP_TAPCELL_ROW_36_587 VSS VDD sky130_fd_sc_hd__tapvpwrvgnd_1
XTAP_TAPCELL_ROW_36_588 VSS VDD sky130_fd_sc_hd__tapvpwrvgnd_1
XTAP_TAPCELL_ROW_37_589 VSS VDD sky130_fd_sc_hd__tapvpwrvgnd_1
XTAP_TAPCELL_ROW_37_590 VSS VDD sky130_fd_sc_hd__tapvpwrvgnd_1
XTAP_TAPCELL_ROW_37_591 VSS VDD sky130_fd_sc_hd__tapvpwrvgnd_1
XTAP_TAPCELL_ROW_37_592 VSS VDD sky130_fd_sc_hd__tapvpwrvgnd_1
XTAP_TAPCELL_ROW_37_593 VSS VDD sky130_fd_sc_hd__tapvpwrvgnd_1
XTAP_TAPCELL_ROW_37_594 VSS VDD sky130_fd_sc_hd__tapvpwrvgnd_1
XTAP_TAPCELL_ROW_37_595 VSS VDD sky130_fd_sc_hd__tapvpwrvgnd_1
XTAP_TAPCELL_ROW_37_596 VSS VDD sky130_fd_sc_hd__tapvpwrvgnd_1
XTAP_TAPCELL_ROW_37_597 VSS VDD sky130_fd_sc_hd__tapvpwrvgnd_1
XTAP_TAPCELL_ROW_37_598 VSS VDD sky130_fd_sc_hd__tapvpwrvgnd_1
XTAP_TAPCELL_ROW_37_599 VSS VDD sky130_fd_sc_hd__tapvpwrvgnd_1
XTAP_TAPCELL_ROW_37_600 VSS VDD sky130_fd_sc_hd__tapvpwrvgnd_1
XTAP_TAPCELL_ROW_37_601 VSS VDD sky130_fd_sc_hd__tapvpwrvgnd_1
XTAP_TAPCELL_ROW_37_602 VSS VDD sky130_fd_sc_hd__tapvpwrvgnd_1
XTAP_TAPCELL_ROW_37_603 VSS VDD sky130_fd_sc_hd__tapvpwrvgnd_1
XTAP_TAPCELL_ROW_38_604 VSS VDD sky130_fd_sc_hd__tapvpwrvgnd_1
XTAP_TAPCELL_ROW_38_605 VSS VDD sky130_fd_sc_hd__tapvpwrvgnd_1
XTAP_TAPCELL_ROW_38_606 VSS VDD sky130_fd_sc_hd__tapvpwrvgnd_1
XTAP_TAPCELL_ROW_38_607 VSS VDD sky130_fd_sc_hd__tapvpwrvgnd_1
XTAP_TAPCELL_ROW_38_608 VSS VDD sky130_fd_sc_hd__tapvpwrvgnd_1
XTAP_TAPCELL_ROW_38_609 VSS VDD sky130_fd_sc_hd__tapvpwrvgnd_1
XTAP_TAPCELL_ROW_38_610 VSS VDD sky130_fd_sc_hd__tapvpwrvgnd_1
XTAP_TAPCELL_ROW_38_611 VSS VDD sky130_fd_sc_hd__tapvpwrvgnd_1
XTAP_TAPCELL_ROW_38_612 VSS VDD sky130_fd_sc_hd__tapvpwrvgnd_1
XTAP_TAPCELL_ROW_38_613 VSS VDD sky130_fd_sc_hd__tapvpwrvgnd_1
XTAP_TAPCELL_ROW_38_614 VSS VDD sky130_fd_sc_hd__tapvpwrvgnd_1
XTAP_TAPCELL_ROW_38_615 VSS VDD sky130_fd_sc_hd__tapvpwrvgnd_1
XTAP_TAPCELL_ROW_38_616 VSS VDD sky130_fd_sc_hd__tapvpwrvgnd_1
XTAP_TAPCELL_ROW_38_617 VSS VDD sky130_fd_sc_hd__tapvpwrvgnd_1
XTAP_TAPCELL_ROW_38_618 VSS VDD sky130_fd_sc_hd__tapvpwrvgnd_1
XTAP_TAPCELL_ROW_38_619 VSS VDD sky130_fd_sc_hd__tapvpwrvgnd_1
XTAP_TAPCELL_ROW_39_620 VSS VDD sky130_fd_sc_hd__tapvpwrvgnd_1
XTAP_TAPCELL_ROW_39_621 VSS VDD sky130_fd_sc_hd__tapvpwrvgnd_1
XTAP_TAPCELL_ROW_39_622 VSS VDD sky130_fd_sc_hd__tapvpwrvgnd_1
XTAP_TAPCELL_ROW_39_623 VSS VDD sky130_fd_sc_hd__tapvpwrvgnd_1
XTAP_TAPCELL_ROW_39_624 VSS VDD sky130_fd_sc_hd__tapvpwrvgnd_1
XTAP_TAPCELL_ROW_39_625 VSS VDD sky130_fd_sc_hd__tapvpwrvgnd_1
XTAP_TAPCELL_ROW_39_626 VSS VDD sky130_fd_sc_hd__tapvpwrvgnd_1
XTAP_TAPCELL_ROW_39_627 VSS VDD sky130_fd_sc_hd__tapvpwrvgnd_1
XTAP_TAPCELL_ROW_39_628 VSS VDD sky130_fd_sc_hd__tapvpwrvgnd_1
XTAP_TAPCELL_ROW_39_629 VSS VDD sky130_fd_sc_hd__tapvpwrvgnd_1
XTAP_TAPCELL_ROW_39_630 VSS VDD sky130_fd_sc_hd__tapvpwrvgnd_1
XTAP_TAPCELL_ROW_39_631 VSS VDD sky130_fd_sc_hd__tapvpwrvgnd_1
XTAP_TAPCELL_ROW_39_632 VSS VDD sky130_fd_sc_hd__tapvpwrvgnd_1
XTAP_TAPCELL_ROW_39_633 VSS VDD sky130_fd_sc_hd__tapvpwrvgnd_1
XTAP_TAPCELL_ROW_39_634 VSS VDD sky130_fd_sc_hd__tapvpwrvgnd_1
XTAP_TAPCELL_ROW_40_635 VSS VDD sky130_fd_sc_hd__tapvpwrvgnd_1
XTAP_TAPCELL_ROW_40_636 VSS VDD sky130_fd_sc_hd__tapvpwrvgnd_1
XTAP_TAPCELL_ROW_40_637 VSS VDD sky130_fd_sc_hd__tapvpwrvgnd_1
XTAP_TAPCELL_ROW_40_638 VSS VDD sky130_fd_sc_hd__tapvpwrvgnd_1
XTAP_TAPCELL_ROW_40_639 VSS VDD sky130_fd_sc_hd__tapvpwrvgnd_1
XTAP_TAPCELL_ROW_40_640 VSS VDD sky130_fd_sc_hd__tapvpwrvgnd_1
XTAP_TAPCELL_ROW_40_641 VSS VDD sky130_fd_sc_hd__tapvpwrvgnd_1
XTAP_TAPCELL_ROW_40_642 VSS VDD sky130_fd_sc_hd__tapvpwrvgnd_1
XTAP_TAPCELL_ROW_40_643 VSS VDD sky130_fd_sc_hd__tapvpwrvgnd_1
XTAP_TAPCELL_ROW_40_644 VSS VDD sky130_fd_sc_hd__tapvpwrvgnd_1
XTAP_TAPCELL_ROW_40_645 VSS VDD sky130_fd_sc_hd__tapvpwrvgnd_1
XTAP_TAPCELL_ROW_40_646 VSS VDD sky130_fd_sc_hd__tapvpwrvgnd_1
XTAP_TAPCELL_ROW_40_647 VSS VDD sky130_fd_sc_hd__tapvpwrvgnd_1
XTAP_TAPCELL_ROW_40_648 VSS VDD sky130_fd_sc_hd__tapvpwrvgnd_1
XTAP_TAPCELL_ROW_40_649 VSS VDD sky130_fd_sc_hd__tapvpwrvgnd_1
XTAP_TAPCELL_ROW_40_650 VSS VDD sky130_fd_sc_hd__tapvpwrvgnd_1
XTAP_TAPCELL_ROW_41_651 VSS VDD sky130_fd_sc_hd__tapvpwrvgnd_1
XTAP_TAPCELL_ROW_41_652 VSS VDD sky130_fd_sc_hd__tapvpwrvgnd_1
XTAP_TAPCELL_ROW_41_653 VSS VDD sky130_fd_sc_hd__tapvpwrvgnd_1
XTAP_TAPCELL_ROW_41_654 VSS VDD sky130_fd_sc_hd__tapvpwrvgnd_1
XTAP_TAPCELL_ROW_41_655 VSS VDD sky130_fd_sc_hd__tapvpwrvgnd_1
XTAP_TAPCELL_ROW_41_656 VSS VDD sky130_fd_sc_hd__tapvpwrvgnd_1
XTAP_TAPCELL_ROW_41_657 VSS VDD sky130_fd_sc_hd__tapvpwrvgnd_1
XTAP_TAPCELL_ROW_41_658 VSS VDD sky130_fd_sc_hd__tapvpwrvgnd_1
XTAP_TAPCELL_ROW_41_659 VSS VDD sky130_fd_sc_hd__tapvpwrvgnd_1
XTAP_TAPCELL_ROW_41_660 VSS VDD sky130_fd_sc_hd__tapvpwrvgnd_1
XTAP_TAPCELL_ROW_41_661 VSS VDD sky130_fd_sc_hd__tapvpwrvgnd_1
XTAP_TAPCELL_ROW_41_662 VSS VDD sky130_fd_sc_hd__tapvpwrvgnd_1
XTAP_TAPCELL_ROW_41_663 VSS VDD sky130_fd_sc_hd__tapvpwrvgnd_1
XTAP_TAPCELL_ROW_41_664 VSS VDD sky130_fd_sc_hd__tapvpwrvgnd_1
XTAP_TAPCELL_ROW_41_665 VSS VDD sky130_fd_sc_hd__tapvpwrvgnd_1
XTAP_TAPCELL_ROW_42_666 VSS VDD sky130_fd_sc_hd__tapvpwrvgnd_1
XTAP_TAPCELL_ROW_42_667 VSS VDD sky130_fd_sc_hd__tapvpwrvgnd_1
XTAP_TAPCELL_ROW_42_668 VSS VDD sky130_fd_sc_hd__tapvpwrvgnd_1
XTAP_TAPCELL_ROW_42_669 VSS VDD sky130_fd_sc_hd__tapvpwrvgnd_1
XTAP_TAPCELL_ROW_42_670 VSS VDD sky130_fd_sc_hd__tapvpwrvgnd_1
XTAP_TAPCELL_ROW_42_671 VSS VDD sky130_fd_sc_hd__tapvpwrvgnd_1
XTAP_TAPCELL_ROW_42_672 VSS VDD sky130_fd_sc_hd__tapvpwrvgnd_1
XTAP_TAPCELL_ROW_42_673 VSS VDD sky130_fd_sc_hd__tapvpwrvgnd_1
XTAP_TAPCELL_ROW_42_674 VSS VDD sky130_fd_sc_hd__tapvpwrvgnd_1
XTAP_TAPCELL_ROW_42_675 VSS VDD sky130_fd_sc_hd__tapvpwrvgnd_1
XTAP_TAPCELL_ROW_42_676 VSS VDD sky130_fd_sc_hd__tapvpwrvgnd_1
XTAP_TAPCELL_ROW_42_677 VSS VDD sky130_fd_sc_hd__tapvpwrvgnd_1
XTAP_TAPCELL_ROW_42_678 VSS VDD sky130_fd_sc_hd__tapvpwrvgnd_1
XTAP_TAPCELL_ROW_42_679 VSS VDD sky130_fd_sc_hd__tapvpwrvgnd_1
XTAP_TAPCELL_ROW_42_680 VSS VDD sky130_fd_sc_hd__tapvpwrvgnd_1
XTAP_TAPCELL_ROW_42_681 VSS VDD sky130_fd_sc_hd__tapvpwrvgnd_1
XTAP_TAPCELL_ROW_43_682 VSS VDD sky130_fd_sc_hd__tapvpwrvgnd_1
XTAP_TAPCELL_ROW_43_683 VSS VDD sky130_fd_sc_hd__tapvpwrvgnd_1
XTAP_TAPCELL_ROW_43_684 VSS VDD sky130_fd_sc_hd__tapvpwrvgnd_1
XTAP_TAPCELL_ROW_43_685 VSS VDD sky130_fd_sc_hd__tapvpwrvgnd_1
XTAP_TAPCELL_ROW_43_686 VSS VDD sky130_fd_sc_hd__tapvpwrvgnd_1
XTAP_TAPCELL_ROW_43_687 VSS VDD sky130_fd_sc_hd__tapvpwrvgnd_1
XTAP_TAPCELL_ROW_43_688 VSS VDD sky130_fd_sc_hd__tapvpwrvgnd_1
XTAP_TAPCELL_ROW_43_689 VSS VDD sky130_fd_sc_hd__tapvpwrvgnd_1
XTAP_TAPCELL_ROW_43_690 VSS VDD sky130_fd_sc_hd__tapvpwrvgnd_1
XTAP_TAPCELL_ROW_43_691 VSS VDD sky130_fd_sc_hd__tapvpwrvgnd_1
XTAP_TAPCELL_ROW_43_692 VSS VDD sky130_fd_sc_hd__tapvpwrvgnd_1
XTAP_TAPCELL_ROW_43_693 VSS VDD sky130_fd_sc_hd__tapvpwrvgnd_1
XTAP_TAPCELL_ROW_43_694 VSS VDD sky130_fd_sc_hd__tapvpwrvgnd_1
XTAP_TAPCELL_ROW_43_695 VSS VDD sky130_fd_sc_hd__tapvpwrvgnd_1
XTAP_TAPCELL_ROW_43_696 VSS VDD sky130_fd_sc_hd__tapvpwrvgnd_1
XTAP_TAPCELL_ROW_44_697 VSS VDD sky130_fd_sc_hd__tapvpwrvgnd_1
XTAP_TAPCELL_ROW_44_698 VSS VDD sky130_fd_sc_hd__tapvpwrvgnd_1
XTAP_TAPCELL_ROW_44_699 VSS VDD sky130_fd_sc_hd__tapvpwrvgnd_1
XTAP_TAPCELL_ROW_44_700 VSS VDD sky130_fd_sc_hd__tapvpwrvgnd_1
XTAP_TAPCELL_ROW_44_701 VSS VDD sky130_fd_sc_hd__tapvpwrvgnd_1
XTAP_TAPCELL_ROW_44_702 VSS VDD sky130_fd_sc_hd__tapvpwrvgnd_1
XTAP_TAPCELL_ROW_44_703 VSS VDD sky130_fd_sc_hd__tapvpwrvgnd_1
XTAP_TAPCELL_ROW_44_704 VSS VDD sky130_fd_sc_hd__tapvpwrvgnd_1
XTAP_TAPCELL_ROW_44_705 VSS VDD sky130_fd_sc_hd__tapvpwrvgnd_1
XTAP_TAPCELL_ROW_44_706 VSS VDD sky130_fd_sc_hd__tapvpwrvgnd_1
XTAP_TAPCELL_ROW_44_707 VSS VDD sky130_fd_sc_hd__tapvpwrvgnd_1
XTAP_TAPCELL_ROW_44_708 VSS VDD sky130_fd_sc_hd__tapvpwrvgnd_1
XTAP_TAPCELL_ROW_44_709 VSS VDD sky130_fd_sc_hd__tapvpwrvgnd_1
XTAP_TAPCELL_ROW_44_710 VSS VDD sky130_fd_sc_hd__tapvpwrvgnd_1
XTAP_TAPCELL_ROW_44_711 VSS VDD sky130_fd_sc_hd__tapvpwrvgnd_1
XTAP_TAPCELL_ROW_44_712 VSS VDD sky130_fd_sc_hd__tapvpwrvgnd_1
XTAP_TAPCELL_ROW_45_713 VSS VDD sky130_fd_sc_hd__tapvpwrvgnd_1
XTAP_TAPCELL_ROW_45_714 VSS VDD sky130_fd_sc_hd__tapvpwrvgnd_1
XTAP_TAPCELL_ROW_45_715 VSS VDD sky130_fd_sc_hd__tapvpwrvgnd_1
XTAP_TAPCELL_ROW_45_716 VSS VDD sky130_fd_sc_hd__tapvpwrvgnd_1
XTAP_TAPCELL_ROW_45_717 VSS VDD sky130_fd_sc_hd__tapvpwrvgnd_1
XTAP_TAPCELL_ROW_45_718 VSS VDD sky130_fd_sc_hd__tapvpwrvgnd_1
XTAP_TAPCELL_ROW_45_719 VSS VDD sky130_fd_sc_hd__tapvpwrvgnd_1
XTAP_TAPCELL_ROW_45_720 VSS VDD sky130_fd_sc_hd__tapvpwrvgnd_1
XTAP_TAPCELL_ROW_45_721 VSS VDD sky130_fd_sc_hd__tapvpwrvgnd_1
XTAP_TAPCELL_ROW_45_722 VSS VDD sky130_fd_sc_hd__tapvpwrvgnd_1
XTAP_TAPCELL_ROW_45_723 VSS VDD sky130_fd_sc_hd__tapvpwrvgnd_1
XTAP_TAPCELL_ROW_45_724 VSS VDD sky130_fd_sc_hd__tapvpwrvgnd_1
XTAP_TAPCELL_ROW_45_725 VSS VDD sky130_fd_sc_hd__tapvpwrvgnd_1
XTAP_TAPCELL_ROW_45_726 VSS VDD sky130_fd_sc_hd__tapvpwrvgnd_1
XTAP_TAPCELL_ROW_45_727 VSS VDD sky130_fd_sc_hd__tapvpwrvgnd_1
XTAP_TAPCELL_ROW_46_728 VSS VDD sky130_fd_sc_hd__tapvpwrvgnd_1
XTAP_TAPCELL_ROW_46_729 VSS VDD sky130_fd_sc_hd__tapvpwrvgnd_1
XTAP_TAPCELL_ROW_46_730 VSS VDD sky130_fd_sc_hd__tapvpwrvgnd_1
XTAP_TAPCELL_ROW_46_731 VSS VDD sky130_fd_sc_hd__tapvpwrvgnd_1
XTAP_TAPCELL_ROW_46_732 VSS VDD sky130_fd_sc_hd__tapvpwrvgnd_1
XTAP_TAPCELL_ROW_46_733 VSS VDD sky130_fd_sc_hd__tapvpwrvgnd_1
XTAP_TAPCELL_ROW_46_734 VSS VDD sky130_fd_sc_hd__tapvpwrvgnd_1
XTAP_TAPCELL_ROW_46_735 VSS VDD sky130_fd_sc_hd__tapvpwrvgnd_1
XTAP_TAPCELL_ROW_46_736 VSS VDD sky130_fd_sc_hd__tapvpwrvgnd_1
XTAP_TAPCELL_ROW_46_737 VSS VDD sky130_fd_sc_hd__tapvpwrvgnd_1
XTAP_TAPCELL_ROW_46_738 VSS VDD sky130_fd_sc_hd__tapvpwrvgnd_1
XTAP_TAPCELL_ROW_46_739 VSS VDD sky130_fd_sc_hd__tapvpwrvgnd_1
XTAP_TAPCELL_ROW_46_740 VSS VDD sky130_fd_sc_hd__tapvpwrvgnd_1
XTAP_TAPCELL_ROW_46_741 VSS VDD sky130_fd_sc_hd__tapvpwrvgnd_1
XTAP_TAPCELL_ROW_46_742 VSS VDD sky130_fd_sc_hd__tapvpwrvgnd_1
XTAP_TAPCELL_ROW_46_743 VSS VDD sky130_fd_sc_hd__tapvpwrvgnd_1
XTAP_TAPCELL_ROW_47_744 VSS VDD sky130_fd_sc_hd__tapvpwrvgnd_1
XTAP_TAPCELL_ROW_47_745 VSS VDD sky130_fd_sc_hd__tapvpwrvgnd_1
XTAP_TAPCELL_ROW_47_746 VSS VDD sky130_fd_sc_hd__tapvpwrvgnd_1
XTAP_TAPCELL_ROW_47_747 VSS VDD sky130_fd_sc_hd__tapvpwrvgnd_1
XTAP_TAPCELL_ROW_47_748 VSS VDD sky130_fd_sc_hd__tapvpwrvgnd_1
XTAP_TAPCELL_ROW_47_749 VSS VDD sky130_fd_sc_hd__tapvpwrvgnd_1
XTAP_TAPCELL_ROW_47_750 VSS VDD sky130_fd_sc_hd__tapvpwrvgnd_1
XTAP_TAPCELL_ROW_47_751 VSS VDD sky130_fd_sc_hd__tapvpwrvgnd_1
XTAP_TAPCELL_ROW_47_752 VSS VDD sky130_fd_sc_hd__tapvpwrvgnd_1
XTAP_TAPCELL_ROW_47_753 VSS VDD sky130_fd_sc_hd__tapvpwrvgnd_1
XTAP_TAPCELL_ROW_47_754 VSS VDD sky130_fd_sc_hd__tapvpwrvgnd_1
XTAP_TAPCELL_ROW_47_755 VSS VDD sky130_fd_sc_hd__tapvpwrvgnd_1
XTAP_TAPCELL_ROW_47_756 VSS VDD sky130_fd_sc_hd__tapvpwrvgnd_1
XTAP_TAPCELL_ROW_47_757 VSS VDD sky130_fd_sc_hd__tapvpwrvgnd_1
XTAP_TAPCELL_ROW_47_758 VSS VDD sky130_fd_sc_hd__tapvpwrvgnd_1
XTAP_TAPCELL_ROW_48_759 VSS VDD sky130_fd_sc_hd__tapvpwrvgnd_1
XTAP_TAPCELL_ROW_48_760 VSS VDD sky130_fd_sc_hd__tapvpwrvgnd_1
XTAP_TAPCELL_ROW_48_761 VSS VDD sky130_fd_sc_hd__tapvpwrvgnd_1
XTAP_TAPCELL_ROW_48_762 VSS VDD sky130_fd_sc_hd__tapvpwrvgnd_1
XTAP_TAPCELL_ROW_48_763 VSS VDD sky130_fd_sc_hd__tapvpwrvgnd_1
XTAP_TAPCELL_ROW_48_764 VSS VDD sky130_fd_sc_hd__tapvpwrvgnd_1
XTAP_TAPCELL_ROW_48_765 VSS VDD sky130_fd_sc_hd__tapvpwrvgnd_1
XTAP_TAPCELL_ROW_48_766 VSS VDD sky130_fd_sc_hd__tapvpwrvgnd_1
XTAP_TAPCELL_ROW_48_767 VSS VDD sky130_fd_sc_hd__tapvpwrvgnd_1
XTAP_TAPCELL_ROW_48_768 VSS VDD sky130_fd_sc_hd__tapvpwrvgnd_1
XTAP_TAPCELL_ROW_48_769 VSS VDD sky130_fd_sc_hd__tapvpwrvgnd_1
XTAP_TAPCELL_ROW_48_770 VSS VDD sky130_fd_sc_hd__tapvpwrvgnd_1
XTAP_TAPCELL_ROW_48_771 VSS VDD sky130_fd_sc_hd__tapvpwrvgnd_1
XTAP_TAPCELL_ROW_48_772 VSS VDD sky130_fd_sc_hd__tapvpwrvgnd_1
XTAP_TAPCELL_ROW_48_773 VSS VDD sky130_fd_sc_hd__tapvpwrvgnd_1
XTAP_TAPCELL_ROW_48_774 VSS VDD sky130_fd_sc_hd__tapvpwrvgnd_1
XTAP_TAPCELL_ROW_49_775 VSS VDD sky130_fd_sc_hd__tapvpwrvgnd_1
XTAP_TAPCELL_ROW_49_776 VSS VDD sky130_fd_sc_hd__tapvpwrvgnd_1
XTAP_TAPCELL_ROW_49_777 VSS VDD sky130_fd_sc_hd__tapvpwrvgnd_1
XTAP_TAPCELL_ROW_49_778 VSS VDD sky130_fd_sc_hd__tapvpwrvgnd_1
XTAP_TAPCELL_ROW_49_779 VSS VDD sky130_fd_sc_hd__tapvpwrvgnd_1
XTAP_TAPCELL_ROW_49_780 VSS VDD sky130_fd_sc_hd__tapvpwrvgnd_1
XTAP_TAPCELL_ROW_49_781 VSS VDD sky130_fd_sc_hd__tapvpwrvgnd_1
XTAP_TAPCELL_ROW_49_782 VSS VDD sky130_fd_sc_hd__tapvpwrvgnd_1
XTAP_TAPCELL_ROW_49_783 VSS VDD sky130_fd_sc_hd__tapvpwrvgnd_1
XTAP_TAPCELL_ROW_49_784 VSS VDD sky130_fd_sc_hd__tapvpwrvgnd_1
XTAP_TAPCELL_ROW_49_785 VSS VDD sky130_fd_sc_hd__tapvpwrvgnd_1
XTAP_TAPCELL_ROW_49_786 VSS VDD sky130_fd_sc_hd__tapvpwrvgnd_1
XTAP_TAPCELL_ROW_49_787 VSS VDD sky130_fd_sc_hd__tapvpwrvgnd_1
XTAP_TAPCELL_ROW_49_788 VSS VDD sky130_fd_sc_hd__tapvpwrvgnd_1
XTAP_TAPCELL_ROW_49_789 VSS VDD sky130_fd_sc_hd__tapvpwrvgnd_1
XTAP_TAPCELL_ROW_50_790 VSS VDD sky130_fd_sc_hd__tapvpwrvgnd_1
XTAP_TAPCELL_ROW_50_791 VSS VDD sky130_fd_sc_hd__tapvpwrvgnd_1
XTAP_TAPCELL_ROW_50_792 VSS VDD sky130_fd_sc_hd__tapvpwrvgnd_1
XTAP_TAPCELL_ROW_50_793 VSS VDD sky130_fd_sc_hd__tapvpwrvgnd_1
XTAP_TAPCELL_ROW_50_794 VSS VDD sky130_fd_sc_hd__tapvpwrvgnd_1
XTAP_TAPCELL_ROW_50_795 VSS VDD sky130_fd_sc_hd__tapvpwrvgnd_1
XTAP_TAPCELL_ROW_50_796 VSS VDD sky130_fd_sc_hd__tapvpwrvgnd_1
XTAP_TAPCELL_ROW_50_797 VSS VDD sky130_fd_sc_hd__tapvpwrvgnd_1
XTAP_TAPCELL_ROW_50_798 VSS VDD sky130_fd_sc_hd__tapvpwrvgnd_1
XTAP_TAPCELL_ROW_50_799 VSS VDD sky130_fd_sc_hd__tapvpwrvgnd_1
XTAP_TAPCELL_ROW_50_800 VSS VDD sky130_fd_sc_hd__tapvpwrvgnd_1
XTAP_TAPCELL_ROW_50_801 VSS VDD sky130_fd_sc_hd__tapvpwrvgnd_1
XTAP_TAPCELL_ROW_50_802 VSS VDD sky130_fd_sc_hd__tapvpwrvgnd_1
XTAP_TAPCELL_ROW_50_803 VSS VDD sky130_fd_sc_hd__tapvpwrvgnd_1
XTAP_TAPCELL_ROW_50_804 VSS VDD sky130_fd_sc_hd__tapvpwrvgnd_1
XTAP_TAPCELL_ROW_50_805 VSS VDD sky130_fd_sc_hd__tapvpwrvgnd_1
XTAP_TAPCELL_ROW_51_806 VSS VDD sky130_fd_sc_hd__tapvpwrvgnd_1
XTAP_TAPCELL_ROW_51_807 VSS VDD sky130_fd_sc_hd__tapvpwrvgnd_1
XTAP_TAPCELL_ROW_51_808 VSS VDD sky130_fd_sc_hd__tapvpwrvgnd_1
XTAP_TAPCELL_ROW_51_809 VSS VDD sky130_fd_sc_hd__tapvpwrvgnd_1
XTAP_TAPCELL_ROW_51_810 VSS VDD sky130_fd_sc_hd__tapvpwrvgnd_1
XTAP_TAPCELL_ROW_51_811 VSS VDD sky130_fd_sc_hd__tapvpwrvgnd_1
XTAP_TAPCELL_ROW_51_812 VSS VDD sky130_fd_sc_hd__tapvpwrvgnd_1
XTAP_TAPCELL_ROW_51_813 VSS VDD sky130_fd_sc_hd__tapvpwrvgnd_1
XTAP_TAPCELL_ROW_51_814 VSS VDD sky130_fd_sc_hd__tapvpwrvgnd_1
XTAP_TAPCELL_ROW_51_815 VSS VDD sky130_fd_sc_hd__tapvpwrvgnd_1
XTAP_TAPCELL_ROW_51_816 VSS VDD sky130_fd_sc_hd__tapvpwrvgnd_1
XTAP_TAPCELL_ROW_51_817 VSS VDD sky130_fd_sc_hd__tapvpwrvgnd_1
XTAP_TAPCELL_ROW_51_818 VSS VDD sky130_fd_sc_hd__tapvpwrvgnd_1
XTAP_TAPCELL_ROW_51_819 VSS VDD sky130_fd_sc_hd__tapvpwrvgnd_1
XTAP_TAPCELL_ROW_51_820 VSS VDD sky130_fd_sc_hd__tapvpwrvgnd_1
XTAP_TAPCELL_ROW_52_821 VSS VDD sky130_fd_sc_hd__tapvpwrvgnd_1
XTAP_TAPCELL_ROW_52_822 VSS VDD sky130_fd_sc_hd__tapvpwrvgnd_1
XTAP_TAPCELL_ROW_52_823 VSS VDD sky130_fd_sc_hd__tapvpwrvgnd_1
XTAP_TAPCELL_ROW_52_824 VSS VDD sky130_fd_sc_hd__tapvpwrvgnd_1
XTAP_TAPCELL_ROW_52_825 VSS VDD sky130_fd_sc_hd__tapvpwrvgnd_1
XTAP_TAPCELL_ROW_52_826 VSS VDD sky130_fd_sc_hd__tapvpwrvgnd_1
XTAP_TAPCELL_ROW_52_827 VSS VDD sky130_fd_sc_hd__tapvpwrvgnd_1
XTAP_TAPCELL_ROW_52_828 VSS VDD sky130_fd_sc_hd__tapvpwrvgnd_1
XTAP_TAPCELL_ROW_52_829 VSS VDD sky130_fd_sc_hd__tapvpwrvgnd_1
XTAP_TAPCELL_ROW_52_830 VSS VDD sky130_fd_sc_hd__tapvpwrvgnd_1
XTAP_TAPCELL_ROW_52_831 VSS VDD sky130_fd_sc_hd__tapvpwrvgnd_1
XTAP_TAPCELL_ROW_52_832 VSS VDD sky130_fd_sc_hd__tapvpwrvgnd_1
XTAP_TAPCELL_ROW_52_833 VSS VDD sky130_fd_sc_hd__tapvpwrvgnd_1
XTAP_TAPCELL_ROW_52_834 VSS VDD sky130_fd_sc_hd__tapvpwrvgnd_1
XTAP_TAPCELL_ROW_52_835 VSS VDD sky130_fd_sc_hd__tapvpwrvgnd_1
XTAP_TAPCELL_ROW_52_836 VSS VDD sky130_fd_sc_hd__tapvpwrvgnd_1
XTAP_TAPCELL_ROW_53_837 VSS VDD sky130_fd_sc_hd__tapvpwrvgnd_1
XTAP_TAPCELL_ROW_53_838 VSS VDD sky130_fd_sc_hd__tapvpwrvgnd_1
XTAP_TAPCELL_ROW_53_839 VSS VDD sky130_fd_sc_hd__tapvpwrvgnd_1
XTAP_TAPCELL_ROW_53_840 VSS VDD sky130_fd_sc_hd__tapvpwrvgnd_1
XTAP_TAPCELL_ROW_53_841 VSS VDD sky130_fd_sc_hd__tapvpwrvgnd_1
XTAP_TAPCELL_ROW_53_842 VSS VDD sky130_fd_sc_hd__tapvpwrvgnd_1
XTAP_TAPCELL_ROW_53_843 VSS VDD sky130_fd_sc_hd__tapvpwrvgnd_1
XTAP_TAPCELL_ROW_53_844 VSS VDD sky130_fd_sc_hd__tapvpwrvgnd_1
XTAP_TAPCELL_ROW_53_845 VSS VDD sky130_fd_sc_hd__tapvpwrvgnd_1
XTAP_TAPCELL_ROW_53_846 VSS VDD sky130_fd_sc_hd__tapvpwrvgnd_1
XTAP_TAPCELL_ROW_53_847 VSS VDD sky130_fd_sc_hd__tapvpwrvgnd_1
XTAP_TAPCELL_ROW_53_848 VSS VDD sky130_fd_sc_hd__tapvpwrvgnd_1
XTAP_TAPCELL_ROW_53_849 VSS VDD sky130_fd_sc_hd__tapvpwrvgnd_1
XTAP_TAPCELL_ROW_53_850 VSS VDD sky130_fd_sc_hd__tapvpwrvgnd_1
XTAP_TAPCELL_ROW_53_851 VSS VDD sky130_fd_sc_hd__tapvpwrvgnd_1
XTAP_TAPCELL_ROW_54_852 VSS VDD sky130_fd_sc_hd__tapvpwrvgnd_1
XTAP_TAPCELL_ROW_54_853 VSS VDD sky130_fd_sc_hd__tapvpwrvgnd_1
XTAP_TAPCELL_ROW_54_854 VSS VDD sky130_fd_sc_hd__tapvpwrvgnd_1
XTAP_TAPCELL_ROW_54_855 VSS VDD sky130_fd_sc_hd__tapvpwrvgnd_1
XTAP_TAPCELL_ROW_54_856 VSS VDD sky130_fd_sc_hd__tapvpwrvgnd_1
XTAP_TAPCELL_ROW_54_857 VSS VDD sky130_fd_sc_hd__tapvpwrvgnd_1
XTAP_TAPCELL_ROW_54_858 VSS VDD sky130_fd_sc_hd__tapvpwrvgnd_1
XTAP_TAPCELL_ROW_54_859 VSS VDD sky130_fd_sc_hd__tapvpwrvgnd_1
XTAP_TAPCELL_ROW_54_860 VSS VDD sky130_fd_sc_hd__tapvpwrvgnd_1
XTAP_TAPCELL_ROW_54_861 VSS VDD sky130_fd_sc_hd__tapvpwrvgnd_1
XTAP_TAPCELL_ROW_54_862 VSS VDD sky130_fd_sc_hd__tapvpwrvgnd_1
XTAP_TAPCELL_ROW_54_863 VSS VDD sky130_fd_sc_hd__tapvpwrvgnd_1
XTAP_TAPCELL_ROW_54_864 VSS VDD sky130_fd_sc_hd__tapvpwrvgnd_1
XTAP_TAPCELL_ROW_54_865 VSS VDD sky130_fd_sc_hd__tapvpwrvgnd_1
XTAP_TAPCELL_ROW_54_866 VSS VDD sky130_fd_sc_hd__tapvpwrvgnd_1
XTAP_TAPCELL_ROW_54_867 VSS VDD sky130_fd_sc_hd__tapvpwrvgnd_1
XTAP_TAPCELL_ROW_55_868 VSS VDD sky130_fd_sc_hd__tapvpwrvgnd_1
XTAP_TAPCELL_ROW_55_869 VSS VDD sky130_fd_sc_hd__tapvpwrvgnd_1
XTAP_TAPCELL_ROW_55_870 VSS VDD sky130_fd_sc_hd__tapvpwrvgnd_1
XTAP_TAPCELL_ROW_55_871 VSS VDD sky130_fd_sc_hd__tapvpwrvgnd_1
XTAP_TAPCELL_ROW_55_872 VSS VDD sky130_fd_sc_hd__tapvpwrvgnd_1
XTAP_TAPCELL_ROW_55_873 VSS VDD sky130_fd_sc_hd__tapvpwrvgnd_1
XTAP_TAPCELL_ROW_55_874 VSS VDD sky130_fd_sc_hd__tapvpwrvgnd_1
XTAP_TAPCELL_ROW_55_875 VSS VDD sky130_fd_sc_hd__tapvpwrvgnd_1
XTAP_TAPCELL_ROW_55_876 VSS VDD sky130_fd_sc_hd__tapvpwrvgnd_1
XTAP_TAPCELL_ROW_55_877 VSS VDD sky130_fd_sc_hd__tapvpwrvgnd_1
XTAP_TAPCELL_ROW_55_878 VSS VDD sky130_fd_sc_hd__tapvpwrvgnd_1
XTAP_TAPCELL_ROW_55_879 VSS VDD sky130_fd_sc_hd__tapvpwrvgnd_1
XTAP_TAPCELL_ROW_55_880 VSS VDD sky130_fd_sc_hd__tapvpwrvgnd_1
XTAP_TAPCELL_ROW_55_881 VSS VDD sky130_fd_sc_hd__tapvpwrvgnd_1
XTAP_TAPCELL_ROW_55_882 VSS VDD sky130_fd_sc_hd__tapvpwrvgnd_1
XTAP_TAPCELL_ROW_56_883 VSS VDD sky130_fd_sc_hd__tapvpwrvgnd_1
XTAP_TAPCELL_ROW_56_884 VSS VDD sky130_fd_sc_hd__tapvpwrvgnd_1
XTAP_TAPCELL_ROW_56_885 VSS VDD sky130_fd_sc_hd__tapvpwrvgnd_1
XTAP_TAPCELL_ROW_56_886 VSS VDD sky130_fd_sc_hd__tapvpwrvgnd_1
XTAP_TAPCELL_ROW_56_887 VSS VDD sky130_fd_sc_hd__tapvpwrvgnd_1
XTAP_TAPCELL_ROW_56_888 VSS VDD sky130_fd_sc_hd__tapvpwrvgnd_1
XTAP_TAPCELL_ROW_56_889 VSS VDD sky130_fd_sc_hd__tapvpwrvgnd_1
XTAP_TAPCELL_ROW_56_890 VSS VDD sky130_fd_sc_hd__tapvpwrvgnd_1
XTAP_TAPCELL_ROW_56_891 VSS VDD sky130_fd_sc_hd__tapvpwrvgnd_1
XTAP_TAPCELL_ROW_56_892 VSS VDD sky130_fd_sc_hd__tapvpwrvgnd_1
XTAP_TAPCELL_ROW_56_893 VSS VDD sky130_fd_sc_hd__tapvpwrvgnd_1
XTAP_TAPCELL_ROW_56_894 VSS VDD sky130_fd_sc_hd__tapvpwrvgnd_1
XTAP_TAPCELL_ROW_56_895 VSS VDD sky130_fd_sc_hd__tapvpwrvgnd_1
XTAP_TAPCELL_ROW_56_896 VSS VDD sky130_fd_sc_hd__tapvpwrvgnd_1
XTAP_TAPCELL_ROW_56_897 VSS VDD sky130_fd_sc_hd__tapvpwrvgnd_1
XTAP_TAPCELL_ROW_56_898 VSS VDD sky130_fd_sc_hd__tapvpwrvgnd_1
XTAP_TAPCELL_ROW_57_899 VSS VDD sky130_fd_sc_hd__tapvpwrvgnd_1
XTAP_TAPCELL_ROW_57_900 VSS VDD sky130_fd_sc_hd__tapvpwrvgnd_1
XTAP_TAPCELL_ROW_57_901 VSS VDD sky130_fd_sc_hd__tapvpwrvgnd_1
XTAP_TAPCELL_ROW_57_902 VSS VDD sky130_fd_sc_hd__tapvpwrvgnd_1
XTAP_TAPCELL_ROW_57_903 VSS VDD sky130_fd_sc_hd__tapvpwrvgnd_1
XTAP_TAPCELL_ROW_57_904 VSS VDD sky130_fd_sc_hd__tapvpwrvgnd_1
XTAP_TAPCELL_ROW_57_905 VSS VDD sky130_fd_sc_hd__tapvpwrvgnd_1
XTAP_TAPCELL_ROW_57_906 VSS VDD sky130_fd_sc_hd__tapvpwrvgnd_1
XTAP_TAPCELL_ROW_57_907 VSS VDD sky130_fd_sc_hd__tapvpwrvgnd_1
XTAP_TAPCELL_ROW_57_908 VSS VDD sky130_fd_sc_hd__tapvpwrvgnd_1
XTAP_TAPCELL_ROW_57_909 VSS VDD sky130_fd_sc_hd__tapvpwrvgnd_1
XTAP_TAPCELL_ROW_57_910 VSS VDD sky130_fd_sc_hd__tapvpwrvgnd_1
XTAP_TAPCELL_ROW_57_911 VSS VDD sky130_fd_sc_hd__tapvpwrvgnd_1
XTAP_TAPCELL_ROW_57_912 VSS VDD sky130_fd_sc_hd__tapvpwrvgnd_1
XTAP_TAPCELL_ROW_57_913 VSS VDD sky130_fd_sc_hd__tapvpwrvgnd_1
XTAP_TAPCELL_ROW_58_914 VSS VDD sky130_fd_sc_hd__tapvpwrvgnd_1
XTAP_TAPCELL_ROW_58_915 VSS VDD sky130_fd_sc_hd__tapvpwrvgnd_1
XTAP_TAPCELL_ROW_58_916 VSS VDD sky130_fd_sc_hd__tapvpwrvgnd_1
XTAP_TAPCELL_ROW_58_917 VSS VDD sky130_fd_sc_hd__tapvpwrvgnd_1
XTAP_TAPCELL_ROW_58_918 VSS VDD sky130_fd_sc_hd__tapvpwrvgnd_1
XTAP_TAPCELL_ROW_58_919 VSS VDD sky130_fd_sc_hd__tapvpwrvgnd_1
XTAP_TAPCELL_ROW_58_920 VSS VDD sky130_fd_sc_hd__tapvpwrvgnd_1
XTAP_TAPCELL_ROW_58_921 VSS VDD sky130_fd_sc_hd__tapvpwrvgnd_1
XTAP_TAPCELL_ROW_58_922 VSS VDD sky130_fd_sc_hd__tapvpwrvgnd_1
XTAP_TAPCELL_ROW_58_923 VSS VDD sky130_fd_sc_hd__tapvpwrvgnd_1
XTAP_TAPCELL_ROW_58_924 VSS VDD sky130_fd_sc_hd__tapvpwrvgnd_1
XTAP_TAPCELL_ROW_58_925 VSS VDD sky130_fd_sc_hd__tapvpwrvgnd_1
XTAP_TAPCELL_ROW_58_926 VSS VDD sky130_fd_sc_hd__tapvpwrvgnd_1
XTAP_TAPCELL_ROW_58_927 VSS VDD sky130_fd_sc_hd__tapvpwrvgnd_1
XTAP_TAPCELL_ROW_58_928 VSS VDD sky130_fd_sc_hd__tapvpwrvgnd_1
XTAP_TAPCELL_ROW_58_929 VSS VDD sky130_fd_sc_hd__tapvpwrvgnd_1
XTAP_TAPCELL_ROW_59_930 VSS VDD sky130_fd_sc_hd__tapvpwrvgnd_1
XTAP_TAPCELL_ROW_59_931 VSS VDD sky130_fd_sc_hd__tapvpwrvgnd_1
XTAP_TAPCELL_ROW_59_932 VSS VDD sky130_fd_sc_hd__tapvpwrvgnd_1
XTAP_TAPCELL_ROW_59_933 VSS VDD sky130_fd_sc_hd__tapvpwrvgnd_1
XTAP_TAPCELL_ROW_59_934 VSS VDD sky130_fd_sc_hd__tapvpwrvgnd_1
XTAP_TAPCELL_ROW_59_935 VSS VDD sky130_fd_sc_hd__tapvpwrvgnd_1
XTAP_TAPCELL_ROW_59_936 VSS VDD sky130_fd_sc_hd__tapvpwrvgnd_1
XTAP_TAPCELL_ROW_59_937 VSS VDD sky130_fd_sc_hd__tapvpwrvgnd_1
XTAP_TAPCELL_ROW_59_938 VSS VDD sky130_fd_sc_hd__tapvpwrvgnd_1
XTAP_TAPCELL_ROW_59_939 VSS VDD sky130_fd_sc_hd__tapvpwrvgnd_1
XTAP_TAPCELL_ROW_59_940 VSS VDD sky130_fd_sc_hd__tapvpwrvgnd_1
XTAP_TAPCELL_ROW_59_941 VSS VDD sky130_fd_sc_hd__tapvpwrvgnd_1
XTAP_TAPCELL_ROW_59_942 VSS VDD sky130_fd_sc_hd__tapvpwrvgnd_1
XTAP_TAPCELL_ROW_59_943 VSS VDD sky130_fd_sc_hd__tapvpwrvgnd_1
XTAP_TAPCELL_ROW_59_944 VSS VDD sky130_fd_sc_hd__tapvpwrvgnd_1
XTAP_TAPCELL_ROW_60_945 VSS VDD sky130_fd_sc_hd__tapvpwrvgnd_1
XTAP_TAPCELL_ROW_60_946 VSS VDD sky130_fd_sc_hd__tapvpwrvgnd_1
XTAP_TAPCELL_ROW_60_947 VSS VDD sky130_fd_sc_hd__tapvpwrvgnd_1
XTAP_TAPCELL_ROW_60_948 VSS VDD sky130_fd_sc_hd__tapvpwrvgnd_1
XTAP_TAPCELL_ROW_60_949 VSS VDD sky130_fd_sc_hd__tapvpwrvgnd_1
XTAP_TAPCELL_ROW_60_950 VSS VDD sky130_fd_sc_hd__tapvpwrvgnd_1
XTAP_TAPCELL_ROW_60_951 VSS VDD sky130_fd_sc_hd__tapvpwrvgnd_1
XTAP_TAPCELL_ROW_60_952 VSS VDD sky130_fd_sc_hd__tapvpwrvgnd_1
XTAP_TAPCELL_ROW_60_953 VSS VDD sky130_fd_sc_hd__tapvpwrvgnd_1
XTAP_TAPCELL_ROW_60_954 VSS VDD sky130_fd_sc_hd__tapvpwrvgnd_1
XTAP_TAPCELL_ROW_60_955 VSS VDD sky130_fd_sc_hd__tapvpwrvgnd_1
XTAP_TAPCELL_ROW_60_956 VSS VDD sky130_fd_sc_hd__tapvpwrvgnd_1
XTAP_TAPCELL_ROW_60_957 VSS VDD sky130_fd_sc_hd__tapvpwrvgnd_1
XTAP_TAPCELL_ROW_60_958 VSS VDD sky130_fd_sc_hd__tapvpwrvgnd_1
XTAP_TAPCELL_ROW_60_959 VSS VDD sky130_fd_sc_hd__tapvpwrvgnd_1
XTAP_TAPCELL_ROW_60_960 VSS VDD sky130_fd_sc_hd__tapvpwrvgnd_1
XTAP_TAPCELL_ROW_61_961 VSS VDD sky130_fd_sc_hd__tapvpwrvgnd_1
XTAP_TAPCELL_ROW_61_962 VSS VDD sky130_fd_sc_hd__tapvpwrvgnd_1
XTAP_TAPCELL_ROW_61_963 VSS VDD sky130_fd_sc_hd__tapvpwrvgnd_1
XTAP_TAPCELL_ROW_61_964 VSS VDD sky130_fd_sc_hd__tapvpwrvgnd_1
XTAP_TAPCELL_ROW_61_965 VSS VDD sky130_fd_sc_hd__tapvpwrvgnd_1
XTAP_TAPCELL_ROW_61_966 VSS VDD sky130_fd_sc_hd__tapvpwrvgnd_1
XTAP_TAPCELL_ROW_61_967 VSS VDD sky130_fd_sc_hd__tapvpwrvgnd_1
XTAP_TAPCELL_ROW_61_968 VSS VDD sky130_fd_sc_hd__tapvpwrvgnd_1
XTAP_TAPCELL_ROW_61_969 VSS VDD sky130_fd_sc_hd__tapvpwrvgnd_1
XTAP_TAPCELL_ROW_61_970 VSS VDD sky130_fd_sc_hd__tapvpwrvgnd_1
XTAP_TAPCELL_ROW_61_971 VSS VDD sky130_fd_sc_hd__tapvpwrvgnd_1
XTAP_TAPCELL_ROW_61_972 VSS VDD sky130_fd_sc_hd__tapvpwrvgnd_1
XTAP_TAPCELL_ROW_61_973 VSS VDD sky130_fd_sc_hd__tapvpwrvgnd_1
XTAP_TAPCELL_ROW_61_974 VSS VDD sky130_fd_sc_hd__tapvpwrvgnd_1
XTAP_TAPCELL_ROW_61_975 VSS VDD sky130_fd_sc_hd__tapvpwrvgnd_1
XTAP_TAPCELL_ROW_62_976 VSS VDD sky130_fd_sc_hd__tapvpwrvgnd_1
XTAP_TAPCELL_ROW_62_977 VSS VDD sky130_fd_sc_hd__tapvpwrvgnd_1
XTAP_TAPCELL_ROW_62_978 VSS VDD sky130_fd_sc_hd__tapvpwrvgnd_1
XTAP_TAPCELL_ROW_62_979 VSS VDD sky130_fd_sc_hd__tapvpwrvgnd_1
XTAP_TAPCELL_ROW_62_980 VSS VDD sky130_fd_sc_hd__tapvpwrvgnd_1
XTAP_TAPCELL_ROW_62_981 VSS VDD sky130_fd_sc_hd__tapvpwrvgnd_1
XTAP_TAPCELL_ROW_62_982 VSS VDD sky130_fd_sc_hd__tapvpwrvgnd_1
XTAP_TAPCELL_ROW_62_983 VSS VDD sky130_fd_sc_hd__tapvpwrvgnd_1
XTAP_TAPCELL_ROW_62_984 VSS VDD sky130_fd_sc_hd__tapvpwrvgnd_1
XTAP_TAPCELL_ROW_62_985 VSS VDD sky130_fd_sc_hd__tapvpwrvgnd_1
XTAP_TAPCELL_ROW_62_986 VSS VDD sky130_fd_sc_hd__tapvpwrvgnd_1
XTAP_TAPCELL_ROW_62_987 VSS VDD sky130_fd_sc_hd__tapvpwrvgnd_1
XTAP_TAPCELL_ROW_62_988 VSS VDD sky130_fd_sc_hd__tapvpwrvgnd_1
XTAP_TAPCELL_ROW_62_989 VSS VDD sky130_fd_sc_hd__tapvpwrvgnd_1
XTAP_TAPCELL_ROW_62_990 VSS VDD sky130_fd_sc_hd__tapvpwrvgnd_1
XTAP_TAPCELL_ROW_62_991 VSS VDD sky130_fd_sc_hd__tapvpwrvgnd_1
XTAP_TAPCELL_ROW_63_992 VSS VDD sky130_fd_sc_hd__tapvpwrvgnd_1
XTAP_TAPCELL_ROW_63_993 VSS VDD sky130_fd_sc_hd__tapvpwrvgnd_1
XTAP_TAPCELL_ROW_63_994 VSS VDD sky130_fd_sc_hd__tapvpwrvgnd_1
XTAP_TAPCELL_ROW_63_995 VSS VDD sky130_fd_sc_hd__tapvpwrvgnd_1
XTAP_TAPCELL_ROW_63_996 VSS VDD sky130_fd_sc_hd__tapvpwrvgnd_1
XTAP_TAPCELL_ROW_63_997 VSS VDD sky130_fd_sc_hd__tapvpwrvgnd_1
XTAP_TAPCELL_ROW_63_998 VSS VDD sky130_fd_sc_hd__tapvpwrvgnd_1
XTAP_TAPCELL_ROW_63_999 VSS VDD sky130_fd_sc_hd__tapvpwrvgnd_1
XTAP_TAPCELL_ROW_63_1000 VSS VDD sky130_fd_sc_hd__tapvpwrvgnd_1
XTAP_TAPCELL_ROW_63_1001 VSS VDD sky130_fd_sc_hd__tapvpwrvgnd_1
XTAP_TAPCELL_ROW_63_1002 VSS VDD sky130_fd_sc_hd__tapvpwrvgnd_1
XTAP_TAPCELL_ROW_63_1003 VSS VDD sky130_fd_sc_hd__tapvpwrvgnd_1
XTAP_TAPCELL_ROW_63_1004 VSS VDD sky130_fd_sc_hd__tapvpwrvgnd_1
XTAP_TAPCELL_ROW_63_1005 VSS VDD sky130_fd_sc_hd__tapvpwrvgnd_1
XTAP_TAPCELL_ROW_63_1006 VSS VDD sky130_fd_sc_hd__tapvpwrvgnd_1
XTAP_TAPCELL_ROW_64_1007 VSS VDD sky130_fd_sc_hd__tapvpwrvgnd_1
XTAP_TAPCELL_ROW_64_1008 VSS VDD sky130_fd_sc_hd__tapvpwrvgnd_1
XTAP_TAPCELL_ROW_64_1009 VSS VDD sky130_fd_sc_hd__tapvpwrvgnd_1
XTAP_TAPCELL_ROW_64_1010 VSS VDD sky130_fd_sc_hd__tapvpwrvgnd_1
XTAP_TAPCELL_ROW_64_1011 VSS VDD sky130_fd_sc_hd__tapvpwrvgnd_1
XTAP_TAPCELL_ROW_64_1012 VSS VDD sky130_fd_sc_hd__tapvpwrvgnd_1
XTAP_TAPCELL_ROW_64_1013 VSS VDD sky130_fd_sc_hd__tapvpwrvgnd_1
XTAP_TAPCELL_ROW_64_1014 VSS VDD sky130_fd_sc_hd__tapvpwrvgnd_1
XTAP_TAPCELL_ROW_64_1015 VSS VDD sky130_fd_sc_hd__tapvpwrvgnd_1
XTAP_TAPCELL_ROW_64_1016 VSS VDD sky130_fd_sc_hd__tapvpwrvgnd_1
XTAP_TAPCELL_ROW_64_1017 VSS VDD sky130_fd_sc_hd__tapvpwrvgnd_1
XTAP_TAPCELL_ROW_64_1018 VSS VDD sky130_fd_sc_hd__tapvpwrvgnd_1
XTAP_TAPCELL_ROW_64_1019 VSS VDD sky130_fd_sc_hd__tapvpwrvgnd_1
XTAP_TAPCELL_ROW_64_1020 VSS VDD sky130_fd_sc_hd__tapvpwrvgnd_1
XTAP_TAPCELL_ROW_64_1021 VSS VDD sky130_fd_sc_hd__tapvpwrvgnd_1
XTAP_TAPCELL_ROW_64_1022 VSS VDD sky130_fd_sc_hd__tapvpwrvgnd_1
XTAP_TAPCELL_ROW_65_1023 VSS VDD sky130_fd_sc_hd__tapvpwrvgnd_1
XTAP_TAPCELL_ROW_65_1024 VSS VDD sky130_fd_sc_hd__tapvpwrvgnd_1
XTAP_TAPCELL_ROW_65_1025 VSS VDD sky130_fd_sc_hd__tapvpwrvgnd_1
XTAP_TAPCELL_ROW_65_1026 VSS VDD sky130_fd_sc_hd__tapvpwrvgnd_1
XTAP_TAPCELL_ROW_65_1027 VSS VDD sky130_fd_sc_hd__tapvpwrvgnd_1
XTAP_TAPCELL_ROW_65_1028 VSS VDD sky130_fd_sc_hd__tapvpwrvgnd_1
XTAP_TAPCELL_ROW_65_1029 VSS VDD sky130_fd_sc_hd__tapvpwrvgnd_1
XTAP_TAPCELL_ROW_65_1030 VSS VDD sky130_fd_sc_hd__tapvpwrvgnd_1
XTAP_TAPCELL_ROW_65_1031 VSS VDD sky130_fd_sc_hd__tapvpwrvgnd_1
XTAP_TAPCELL_ROW_65_1032 VSS VDD sky130_fd_sc_hd__tapvpwrvgnd_1
XTAP_TAPCELL_ROW_65_1033 VSS VDD sky130_fd_sc_hd__tapvpwrvgnd_1
XTAP_TAPCELL_ROW_65_1034 VSS VDD sky130_fd_sc_hd__tapvpwrvgnd_1
XTAP_TAPCELL_ROW_65_1035 VSS VDD sky130_fd_sc_hd__tapvpwrvgnd_1
XTAP_TAPCELL_ROW_65_1036 VSS VDD sky130_fd_sc_hd__tapvpwrvgnd_1
XTAP_TAPCELL_ROW_65_1037 VSS VDD sky130_fd_sc_hd__tapvpwrvgnd_1
XTAP_TAPCELL_ROW_66_1038 VSS VDD sky130_fd_sc_hd__tapvpwrvgnd_1
XTAP_TAPCELL_ROW_66_1039 VSS VDD sky130_fd_sc_hd__tapvpwrvgnd_1
XTAP_TAPCELL_ROW_66_1040 VSS VDD sky130_fd_sc_hd__tapvpwrvgnd_1
XTAP_TAPCELL_ROW_66_1041 VSS VDD sky130_fd_sc_hd__tapvpwrvgnd_1
XTAP_TAPCELL_ROW_66_1042 VSS VDD sky130_fd_sc_hd__tapvpwrvgnd_1
XTAP_TAPCELL_ROW_66_1043 VSS VDD sky130_fd_sc_hd__tapvpwrvgnd_1
XTAP_TAPCELL_ROW_66_1044 VSS VDD sky130_fd_sc_hd__tapvpwrvgnd_1
XTAP_TAPCELL_ROW_66_1045 VSS VDD sky130_fd_sc_hd__tapvpwrvgnd_1
XTAP_TAPCELL_ROW_66_1046 VSS VDD sky130_fd_sc_hd__tapvpwrvgnd_1
XTAP_TAPCELL_ROW_66_1047 VSS VDD sky130_fd_sc_hd__tapvpwrvgnd_1
XTAP_TAPCELL_ROW_66_1048 VSS VDD sky130_fd_sc_hd__tapvpwrvgnd_1
XTAP_TAPCELL_ROW_66_1049 VSS VDD sky130_fd_sc_hd__tapvpwrvgnd_1
XTAP_TAPCELL_ROW_66_1050 VSS VDD sky130_fd_sc_hd__tapvpwrvgnd_1
XTAP_TAPCELL_ROW_66_1051 VSS VDD sky130_fd_sc_hd__tapvpwrvgnd_1
XTAP_TAPCELL_ROW_66_1052 VSS VDD sky130_fd_sc_hd__tapvpwrvgnd_1
XTAP_TAPCELL_ROW_66_1053 VSS VDD sky130_fd_sc_hd__tapvpwrvgnd_1
XTAP_TAPCELL_ROW_67_1054 VSS VDD sky130_fd_sc_hd__tapvpwrvgnd_1
XTAP_TAPCELL_ROW_67_1055 VSS VDD sky130_fd_sc_hd__tapvpwrvgnd_1
XTAP_TAPCELL_ROW_67_1056 VSS VDD sky130_fd_sc_hd__tapvpwrvgnd_1
XTAP_TAPCELL_ROW_67_1057 VSS VDD sky130_fd_sc_hd__tapvpwrvgnd_1
XTAP_TAPCELL_ROW_67_1058 VSS VDD sky130_fd_sc_hd__tapvpwrvgnd_1
XTAP_TAPCELL_ROW_67_1059 VSS VDD sky130_fd_sc_hd__tapvpwrvgnd_1
XTAP_TAPCELL_ROW_67_1060 VSS VDD sky130_fd_sc_hd__tapvpwrvgnd_1
XTAP_TAPCELL_ROW_67_1061 VSS VDD sky130_fd_sc_hd__tapvpwrvgnd_1
XTAP_TAPCELL_ROW_67_1062 VSS VDD sky130_fd_sc_hd__tapvpwrvgnd_1
XTAP_TAPCELL_ROW_67_1063 VSS VDD sky130_fd_sc_hd__tapvpwrvgnd_1
XTAP_TAPCELL_ROW_67_1064 VSS VDD sky130_fd_sc_hd__tapvpwrvgnd_1
XTAP_TAPCELL_ROW_67_1065 VSS VDD sky130_fd_sc_hd__tapvpwrvgnd_1
XTAP_TAPCELL_ROW_67_1066 VSS VDD sky130_fd_sc_hd__tapvpwrvgnd_1
XTAP_TAPCELL_ROW_67_1067 VSS VDD sky130_fd_sc_hd__tapvpwrvgnd_1
XTAP_TAPCELL_ROW_67_1068 VSS VDD sky130_fd_sc_hd__tapvpwrvgnd_1
XTAP_TAPCELL_ROW_68_1069 VSS VDD sky130_fd_sc_hd__tapvpwrvgnd_1
XTAP_TAPCELL_ROW_68_1070 VSS VDD sky130_fd_sc_hd__tapvpwrvgnd_1
XTAP_TAPCELL_ROW_68_1071 VSS VDD sky130_fd_sc_hd__tapvpwrvgnd_1
XTAP_TAPCELL_ROW_68_1072 VSS VDD sky130_fd_sc_hd__tapvpwrvgnd_1
XTAP_TAPCELL_ROW_68_1073 VSS VDD sky130_fd_sc_hd__tapvpwrvgnd_1
XTAP_TAPCELL_ROW_68_1074 VSS VDD sky130_fd_sc_hd__tapvpwrvgnd_1
XTAP_TAPCELL_ROW_68_1075 VSS VDD sky130_fd_sc_hd__tapvpwrvgnd_1
XTAP_TAPCELL_ROW_68_1076 VSS VDD sky130_fd_sc_hd__tapvpwrvgnd_1
XTAP_TAPCELL_ROW_68_1077 VSS VDD sky130_fd_sc_hd__tapvpwrvgnd_1
XTAP_TAPCELL_ROW_68_1078 VSS VDD sky130_fd_sc_hd__tapvpwrvgnd_1
XTAP_TAPCELL_ROW_68_1079 VSS VDD sky130_fd_sc_hd__tapvpwrvgnd_1
XTAP_TAPCELL_ROW_68_1080 VSS VDD sky130_fd_sc_hd__tapvpwrvgnd_1
XTAP_TAPCELL_ROW_68_1081 VSS VDD sky130_fd_sc_hd__tapvpwrvgnd_1
XTAP_TAPCELL_ROW_68_1082 VSS VDD sky130_fd_sc_hd__tapvpwrvgnd_1
XTAP_TAPCELL_ROW_68_1083 VSS VDD sky130_fd_sc_hd__tapvpwrvgnd_1
XTAP_TAPCELL_ROW_68_1084 VSS VDD sky130_fd_sc_hd__tapvpwrvgnd_1
XTAP_TAPCELL_ROW_69_1085 VSS VDD sky130_fd_sc_hd__tapvpwrvgnd_1
XTAP_TAPCELL_ROW_69_1086 VSS VDD sky130_fd_sc_hd__tapvpwrvgnd_1
XTAP_TAPCELL_ROW_69_1087 VSS VDD sky130_fd_sc_hd__tapvpwrvgnd_1
XTAP_TAPCELL_ROW_69_1088 VSS VDD sky130_fd_sc_hd__tapvpwrvgnd_1
XTAP_TAPCELL_ROW_69_1089 VSS VDD sky130_fd_sc_hd__tapvpwrvgnd_1
XTAP_TAPCELL_ROW_69_1090 VSS VDD sky130_fd_sc_hd__tapvpwrvgnd_1
XTAP_TAPCELL_ROW_69_1091 VSS VDD sky130_fd_sc_hd__tapvpwrvgnd_1
XTAP_TAPCELL_ROW_69_1092 VSS VDD sky130_fd_sc_hd__tapvpwrvgnd_1
XTAP_TAPCELL_ROW_69_1093 VSS VDD sky130_fd_sc_hd__tapvpwrvgnd_1
XTAP_TAPCELL_ROW_69_1094 VSS VDD sky130_fd_sc_hd__tapvpwrvgnd_1
XTAP_TAPCELL_ROW_69_1095 VSS VDD sky130_fd_sc_hd__tapvpwrvgnd_1
XTAP_TAPCELL_ROW_69_1096 VSS VDD sky130_fd_sc_hd__tapvpwrvgnd_1
XTAP_TAPCELL_ROW_69_1097 VSS VDD sky130_fd_sc_hd__tapvpwrvgnd_1
XTAP_TAPCELL_ROW_69_1098 VSS VDD sky130_fd_sc_hd__tapvpwrvgnd_1
XTAP_TAPCELL_ROW_69_1099 VSS VDD sky130_fd_sc_hd__tapvpwrvgnd_1
XTAP_TAPCELL_ROW_70_1100 VSS VDD sky130_fd_sc_hd__tapvpwrvgnd_1
XTAP_TAPCELL_ROW_70_1101 VSS VDD sky130_fd_sc_hd__tapvpwrvgnd_1
XTAP_TAPCELL_ROW_70_1102 VSS VDD sky130_fd_sc_hd__tapvpwrvgnd_1
XTAP_TAPCELL_ROW_70_1103 VSS VDD sky130_fd_sc_hd__tapvpwrvgnd_1
XTAP_TAPCELL_ROW_70_1104 VSS VDD sky130_fd_sc_hd__tapvpwrvgnd_1
XTAP_TAPCELL_ROW_70_1105 VSS VDD sky130_fd_sc_hd__tapvpwrvgnd_1
XTAP_TAPCELL_ROW_70_1106 VSS VDD sky130_fd_sc_hd__tapvpwrvgnd_1
XTAP_TAPCELL_ROW_70_1107 VSS VDD sky130_fd_sc_hd__tapvpwrvgnd_1
XTAP_TAPCELL_ROW_70_1108 VSS VDD sky130_fd_sc_hd__tapvpwrvgnd_1
XTAP_TAPCELL_ROW_70_1109 VSS VDD sky130_fd_sc_hd__tapvpwrvgnd_1
XTAP_TAPCELL_ROW_70_1110 VSS VDD sky130_fd_sc_hd__tapvpwrvgnd_1
XTAP_TAPCELL_ROW_70_1111 VSS VDD sky130_fd_sc_hd__tapvpwrvgnd_1
XTAP_TAPCELL_ROW_70_1112 VSS VDD sky130_fd_sc_hd__tapvpwrvgnd_1
XTAP_TAPCELL_ROW_70_1113 VSS VDD sky130_fd_sc_hd__tapvpwrvgnd_1
XTAP_TAPCELL_ROW_70_1114 VSS VDD sky130_fd_sc_hd__tapvpwrvgnd_1
XTAP_TAPCELL_ROW_70_1115 VSS VDD sky130_fd_sc_hd__tapvpwrvgnd_1
XTAP_TAPCELL_ROW_71_1116 VSS VDD sky130_fd_sc_hd__tapvpwrvgnd_1
XTAP_TAPCELL_ROW_71_1117 VSS VDD sky130_fd_sc_hd__tapvpwrvgnd_1
XTAP_TAPCELL_ROW_71_1118 VSS VDD sky130_fd_sc_hd__tapvpwrvgnd_1
XTAP_TAPCELL_ROW_71_1119 VSS VDD sky130_fd_sc_hd__tapvpwrvgnd_1
XTAP_TAPCELL_ROW_71_1120 VSS VDD sky130_fd_sc_hd__tapvpwrvgnd_1
XTAP_TAPCELL_ROW_71_1121 VSS VDD sky130_fd_sc_hd__tapvpwrvgnd_1
XTAP_TAPCELL_ROW_71_1122 VSS VDD sky130_fd_sc_hd__tapvpwrvgnd_1
XTAP_TAPCELL_ROW_71_1123 VSS VDD sky130_fd_sc_hd__tapvpwrvgnd_1
XTAP_TAPCELL_ROW_71_1124 VSS VDD sky130_fd_sc_hd__tapvpwrvgnd_1
XTAP_TAPCELL_ROW_71_1125 VSS VDD sky130_fd_sc_hd__tapvpwrvgnd_1
XTAP_TAPCELL_ROW_71_1126 VSS VDD sky130_fd_sc_hd__tapvpwrvgnd_1
XTAP_TAPCELL_ROW_71_1127 VSS VDD sky130_fd_sc_hd__tapvpwrvgnd_1
XTAP_TAPCELL_ROW_71_1128 VSS VDD sky130_fd_sc_hd__tapvpwrvgnd_1
XTAP_TAPCELL_ROW_71_1129 VSS VDD sky130_fd_sc_hd__tapvpwrvgnd_1
XTAP_TAPCELL_ROW_71_1130 VSS VDD sky130_fd_sc_hd__tapvpwrvgnd_1
XTAP_TAPCELL_ROW_72_1131 VSS VDD sky130_fd_sc_hd__tapvpwrvgnd_1
XTAP_TAPCELL_ROW_72_1132 VSS VDD sky130_fd_sc_hd__tapvpwrvgnd_1
XTAP_TAPCELL_ROW_72_1133 VSS VDD sky130_fd_sc_hd__tapvpwrvgnd_1
XTAP_TAPCELL_ROW_72_1134 VSS VDD sky130_fd_sc_hd__tapvpwrvgnd_1
XTAP_TAPCELL_ROW_72_1135 VSS VDD sky130_fd_sc_hd__tapvpwrvgnd_1
XTAP_TAPCELL_ROW_72_1136 VSS VDD sky130_fd_sc_hd__tapvpwrvgnd_1
XTAP_TAPCELL_ROW_72_1137 VSS VDD sky130_fd_sc_hd__tapvpwrvgnd_1
XTAP_TAPCELL_ROW_72_1138 VSS VDD sky130_fd_sc_hd__tapvpwrvgnd_1
XTAP_TAPCELL_ROW_72_1139 VSS VDD sky130_fd_sc_hd__tapvpwrvgnd_1
XTAP_TAPCELL_ROW_72_1140 VSS VDD sky130_fd_sc_hd__tapvpwrvgnd_1
XTAP_TAPCELL_ROW_72_1141 VSS VDD sky130_fd_sc_hd__tapvpwrvgnd_1
XTAP_TAPCELL_ROW_72_1142 VSS VDD sky130_fd_sc_hd__tapvpwrvgnd_1
XTAP_TAPCELL_ROW_72_1143 VSS VDD sky130_fd_sc_hd__tapvpwrvgnd_1
XTAP_TAPCELL_ROW_72_1144 VSS VDD sky130_fd_sc_hd__tapvpwrvgnd_1
XTAP_TAPCELL_ROW_72_1145 VSS VDD sky130_fd_sc_hd__tapvpwrvgnd_1
XTAP_TAPCELL_ROW_72_1146 VSS VDD sky130_fd_sc_hd__tapvpwrvgnd_1
XTAP_TAPCELL_ROW_73_1147 VSS VDD sky130_fd_sc_hd__tapvpwrvgnd_1
XTAP_TAPCELL_ROW_73_1148 VSS VDD sky130_fd_sc_hd__tapvpwrvgnd_1
XTAP_TAPCELL_ROW_73_1149 VSS VDD sky130_fd_sc_hd__tapvpwrvgnd_1
XTAP_TAPCELL_ROW_73_1150 VSS VDD sky130_fd_sc_hd__tapvpwrvgnd_1
XTAP_TAPCELL_ROW_73_1151 VSS VDD sky130_fd_sc_hd__tapvpwrvgnd_1
XTAP_TAPCELL_ROW_73_1152 VSS VDD sky130_fd_sc_hd__tapvpwrvgnd_1
XTAP_TAPCELL_ROW_73_1153 VSS VDD sky130_fd_sc_hd__tapvpwrvgnd_1
XTAP_TAPCELL_ROW_73_1154 VSS VDD sky130_fd_sc_hd__tapvpwrvgnd_1
XTAP_TAPCELL_ROW_73_1155 VSS VDD sky130_fd_sc_hd__tapvpwrvgnd_1
XTAP_TAPCELL_ROW_73_1156 VSS VDD sky130_fd_sc_hd__tapvpwrvgnd_1
XTAP_TAPCELL_ROW_73_1157 VSS VDD sky130_fd_sc_hd__tapvpwrvgnd_1
XTAP_TAPCELL_ROW_73_1158 VSS VDD sky130_fd_sc_hd__tapvpwrvgnd_1
XTAP_TAPCELL_ROW_73_1159 VSS VDD sky130_fd_sc_hd__tapvpwrvgnd_1
XTAP_TAPCELL_ROW_73_1160 VSS VDD sky130_fd_sc_hd__tapvpwrvgnd_1
XTAP_TAPCELL_ROW_73_1161 VSS VDD sky130_fd_sc_hd__tapvpwrvgnd_1
XTAP_TAPCELL_ROW_74_1162 VSS VDD sky130_fd_sc_hd__tapvpwrvgnd_1
XTAP_TAPCELL_ROW_74_1163 VSS VDD sky130_fd_sc_hd__tapvpwrvgnd_1
XTAP_TAPCELL_ROW_74_1164 VSS VDD sky130_fd_sc_hd__tapvpwrvgnd_1
XTAP_TAPCELL_ROW_74_1165 VSS VDD sky130_fd_sc_hd__tapvpwrvgnd_1
XTAP_TAPCELL_ROW_74_1166 VSS VDD sky130_fd_sc_hd__tapvpwrvgnd_1
XTAP_TAPCELL_ROW_74_1167 VSS VDD sky130_fd_sc_hd__tapvpwrvgnd_1
XTAP_TAPCELL_ROW_74_1168 VSS VDD sky130_fd_sc_hd__tapvpwrvgnd_1
XTAP_TAPCELL_ROW_74_1169 VSS VDD sky130_fd_sc_hd__tapvpwrvgnd_1
XTAP_TAPCELL_ROW_74_1170 VSS VDD sky130_fd_sc_hd__tapvpwrvgnd_1
XTAP_TAPCELL_ROW_74_1171 VSS VDD sky130_fd_sc_hd__tapvpwrvgnd_1
XTAP_TAPCELL_ROW_74_1172 VSS VDD sky130_fd_sc_hd__tapvpwrvgnd_1
XTAP_TAPCELL_ROW_74_1173 VSS VDD sky130_fd_sc_hd__tapvpwrvgnd_1
XTAP_TAPCELL_ROW_74_1174 VSS VDD sky130_fd_sc_hd__tapvpwrvgnd_1
XTAP_TAPCELL_ROW_74_1175 VSS VDD sky130_fd_sc_hd__tapvpwrvgnd_1
XTAP_TAPCELL_ROW_74_1176 VSS VDD sky130_fd_sc_hd__tapvpwrvgnd_1
XTAP_TAPCELL_ROW_74_1177 VSS VDD sky130_fd_sc_hd__tapvpwrvgnd_1
XTAP_TAPCELL_ROW_75_1178 VSS VDD sky130_fd_sc_hd__tapvpwrvgnd_1
XTAP_TAPCELL_ROW_75_1179 VSS VDD sky130_fd_sc_hd__tapvpwrvgnd_1
XTAP_TAPCELL_ROW_75_1180 VSS VDD sky130_fd_sc_hd__tapvpwrvgnd_1
XTAP_TAPCELL_ROW_75_1181 VSS VDD sky130_fd_sc_hd__tapvpwrvgnd_1
XTAP_TAPCELL_ROW_75_1182 VSS VDD sky130_fd_sc_hd__tapvpwrvgnd_1
XTAP_TAPCELL_ROW_75_1183 VSS VDD sky130_fd_sc_hd__tapvpwrvgnd_1
XTAP_TAPCELL_ROW_75_1184 VSS VDD sky130_fd_sc_hd__tapvpwrvgnd_1
XTAP_TAPCELL_ROW_75_1185 VSS VDD sky130_fd_sc_hd__tapvpwrvgnd_1
XTAP_TAPCELL_ROW_75_1186 VSS VDD sky130_fd_sc_hd__tapvpwrvgnd_1
XTAP_TAPCELL_ROW_75_1187 VSS VDD sky130_fd_sc_hd__tapvpwrvgnd_1
XTAP_TAPCELL_ROW_75_1188 VSS VDD sky130_fd_sc_hd__tapvpwrvgnd_1
XTAP_TAPCELL_ROW_75_1189 VSS VDD sky130_fd_sc_hd__tapvpwrvgnd_1
XTAP_TAPCELL_ROW_75_1190 VSS VDD sky130_fd_sc_hd__tapvpwrvgnd_1
XTAP_TAPCELL_ROW_75_1191 VSS VDD sky130_fd_sc_hd__tapvpwrvgnd_1
XTAP_TAPCELL_ROW_75_1192 VSS VDD sky130_fd_sc_hd__tapvpwrvgnd_1
XTAP_TAPCELL_ROW_76_1193 VSS VDD sky130_fd_sc_hd__tapvpwrvgnd_1
XTAP_TAPCELL_ROW_76_1194 VSS VDD sky130_fd_sc_hd__tapvpwrvgnd_1
XTAP_TAPCELL_ROW_76_1195 VSS VDD sky130_fd_sc_hd__tapvpwrvgnd_1
XTAP_TAPCELL_ROW_76_1196 VSS VDD sky130_fd_sc_hd__tapvpwrvgnd_1
XTAP_TAPCELL_ROW_76_1197 VSS VDD sky130_fd_sc_hd__tapvpwrvgnd_1
XTAP_TAPCELL_ROW_76_1198 VSS VDD sky130_fd_sc_hd__tapvpwrvgnd_1
XTAP_TAPCELL_ROW_76_1199 VSS VDD sky130_fd_sc_hd__tapvpwrvgnd_1
XTAP_TAPCELL_ROW_76_1200 VSS VDD sky130_fd_sc_hd__tapvpwrvgnd_1
XTAP_TAPCELL_ROW_76_1201 VSS VDD sky130_fd_sc_hd__tapvpwrvgnd_1
XTAP_TAPCELL_ROW_76_1202 VSS VDD sky130_fd_sc_hd__tapvpwrvgnd_1
XTAP_TAPCELL_ROW_76_1203 VSS VDD sky130_fd_sc_hd__tapvpwrvgnd_1
XTAP_TAPCELL_ROW_76_1204 VSS VDD sky130_fd_sc_hd__tapvpwrvgnd_1
XTAP_TAPCELL_ROW_76_1205 VSS VDD sky130_fd_sc_hd__tapvpwrvgnd_1
XTAP_TAPCELL_ROW_76_1206 VSS VDD sky130_fd_sc_hd__tapvpwrvgnd_1
XTAP_TAPCELL_ROW_76_1207 VSS VDD sky130_fd_sc_hd__tapvpwrvgnd_1
XTAP_TAPCELL_ROW_76_1208 VSS VDD sky130_fd_sc_hd__tapvpwrvgnd_1
XTAP_TAPCELL_ROW_77_1209 VSS VDD sky130_fd_sc_hd__tapvpwrvgnd_1
XTAP_TAPCELL_ROW_77_1210 VSS VDD sky130_fd_sc_hd__tapvpwrvgnd_1
XTAP_TAPCELL_ROW_77_1211 VSS VDD sky130_fd_sc_hd__tapvpwrvgnd_1
XTAP_TAPCELL_ROW_77_1212 VSS VDD sky130_fd_sc_hd__tapvpwrvgnd_1
XTAP_TAPCELL_ROW_77_1213 VSS VDD sky130_fd_sc_hd__tapvpwrvgnd_1
XTAP_TAPCELL_ROW_77_1214 VSS VDD sky130_fd_sc_hd__tapvpwrvgnd_1
XTAP_TAPCELL_ROW_77_1215 VSS VDD sky130_fd_sc_hd__tapvpwrvgnd_1
XTAP_TAPCELL_ROW_77_1216 VSS VDD sky130_fd_sc_hd__tapvpwrvgnd_1
XTAP_TAPCELL_ROW_77_1217 VSS VDD sky130_fd_sc_hd__tapvpwrvgnd_1
XTAP_TAPCELL_ROW_77_1218 VSS VDD sky130_fd_sc_hd__tapvpwrvgnd_1
XTAP_TAPCELL_ROW_77_1219 VSS VDD sky130_fd_sc_hd__tapvpwrvgnd_1
XTAP_TAPCELL_ROW_77_1220 VSS VDD sky130_fd_sc_hd__tapvpwrvgnd_1
XTAP_TAPCELL_ROW_77_1221 VSS VDD sky130_fd_sc_hd__tapvpwrvgnd_1
XTAP_TAPCELL_ROW_77_1222 VSS VDD sky130_fd_sc_hd__tapvpwrvgnd_1
XTAP_TAPCELL_ROW_77_1223 VSS VDD sky130_fd_sc_hd__tapvpwrvgnd_1
XTAP_TAPCELL_ROW_78_1224 VSS VDD sky130_fd_sc_hd__tapvpwrvgnd_1
XTAP_TAPCELL_ROW_78_1225 VSS VDD sky130_fd_sc_hd__tapvpwrvgnd_1
XTAP_TAPCELL_ROW_78_1226 VSS VDD sky130_fd_sc_hd__tapvpwrvgnd_1
XTAP_TAPCELL_ROW_78_1227 VSS VDD sky130_fd_sc_hd__tapvpwrvgnd_1
XTAP_TAPCELL_ROW_78_1228 VSS VDD sky130_fd_sc_hd__tapvpwrvgnd_1
XTAP_TAPCELL_ROW_78_1229 VSS VDD sky130_fd_sc_hd__tapvpwrvgnd_1
XTAP_TAPCELL_ROW_78_1230 VSS VDD sky130_fd_sc_hd__tapvpwrvgnd_1
XTAP_TAPCELL_ROW_78_1231 VSS VDD sky130_fd_sc_hd__tapvpwrvgnd_1
XTAP_TAPCELL_ROW_78_1232 VSS VDD sky130_fd_sc_hd__tapvpwrvgnd_1
XTAP_TAPCELL_ROW_78_1233 VSS VDD sky130_fd_sc_hd__tapvpwrvgnd_1
XTAP_TAPCELL_ROW_78_1234 VSS VDD sky130_fd_sc_hd__tapvpwrvgnd_1
XTAP_TAPCELL_ROW_78_1235 VSS VDD sky130_fd_sc_hd__tapvpwrvgnd_1
XTAP_TAPCELL_ROW_78_1236 VSS VDD sky130_fd_sc_hd__tapvpwrvgnd_1
XTAP_TAPCELL_ROW_78_1237 VSS VDD sky130_fd_sc_hd__tapvpwrvgnd_1
XTAP_TAPCELL_ROW_78_1238 VSS VDD sky130_fd_sc_hd__tapvpwrvgnd_1
XTAP_TAPCELL_ROW_78_1239 VSS VDD sky130_fd_sc_hd__tapvpwrvgnd_1
XTAP_TAPCELL_ROW_79_1240 VSS VDD sky130_fd_sc_hd__tapvpwrvgnd_1
XTAP_TAPCELL_ROW_79_1241 VSS VDD sky130_fd_sc_hd__tapvpwrvgnd_1
XTAP_TAPCELL_ROW_79_1242 VSS VDD sky130_fd_sc_hd__tapvpwrvgnd_1
XTAP_TAPCELL_ROW_79_1243 VSS VDD sky130_fd_sc_hd__tapvpwrvgnd_1
XTAP_TAPCELL_ROW_79_1244 VSS VDD sky130_fd_sc_hd__tapvpwrvgnd_1
XTAP_TAPCELL_ROW_79_1245 VSS VDD sky130_fd_sc_hd__tapvpwrvgnd_1
XTAP_TAPCELL_ROW_79_1246 VSS VDD sky130_fd_sc_hd__tapvpwrvgnd_1
XTAP_TAPCELL_ROW_79_1247 VSS VDD sky130_fd_sc_hd__tapvpwrvgnd_1
XTAP_TAPCELL_ROW_79_1248 VSS VDD sky130_fd_sc_hd__tapvpwrvgnd_1
XTAP_TAPCELL_ROW_79_1249 VSS VDD sky130_fd_sc_hd__tapvpwrvgnd_1
XTAP_TAPCELL_ROW_79_1250 VSS VDD sky130_fd_sc_hd__tapvpwrvgnd_1
XTAP_TAPCELL_ROW_79_1251 VSS VDD sky130_fd_sc_hd__tapvpwrvgnd_1
XTAP_TAPCELL_ROW_79_1252 VSS VDD sky130_fd_sc_hd__tapvpwrvgnd_1
XTAP_TAPCELL_ROW_79_1253 VSS VDD sky130_fd_sc_hd__tapvpwrvgnd_1
XTAP_TAPCELL_ROW_79_1254 VSS VDD sky130_fd_sc_hd__tapvpwrvgnd_1
XTAP_TAPCELL_ROW_80_1255 VSS VDD sky130_fd_sc_hd__tapvpwrvgnd_1
XTAP_TAPCELL_ROW_80_1256 VSS VDD sky130_fd_sc_hd__tapvpwrvgnd_1
XTAP_TAPCELL_ROW_80_1257 VSS VDD sky130_fd_sc_hd__tapvpwrvgnd_1
XTAP_TAPCELL_ROW_80_1258 VSS VDD sky130_fd_sc_hd__tapvpwrvgnd_1
XTAP_TAPCELL_ROW_80_1259 VSS VDD sky130_fd_sc_hd__tapvpwrvgnd_1
XTAP_TAPCELL_ROW_80_1260 VSS VDD sky130_fd_sc_hd__tapvpwrvgnd_1
XTAP_TAPCELL_ROW_80_1261 VSS VDD sky130_fd_sc_hd__tapvpwrvgnd_1
XTAP_TAPCELL_ROW_80_1262 VSS VDD sky130_fd_sc_hd__tapvpwrvgnd_1
XTAP_TAPCELL_ROW_80_1263 VSS VDD sky130_fd_sc_hd__tapvpwrvgnd_1
XTAP_TAPCELL_ROW_80_1264 VSS VDD sky130_fd_sc_hd__tapvpwrvgnd_1
XTAP_TAPCELL_ROW_80_1265 VSS VDD sky130_fd_sc_hd__tapvpwrvgnd_1
XTAP_TAPCELL_ROW_80_1266 VSS VDD sky130_fd_sc_hd__tapvpwrvgnd_1
XTAP_TAPCELL_ROW_80_1267 VSS VDD sky130_fd_sc_hd__tapvpwrvgnd_1
XTAP_TAPCELL_ROW_80_1268 VSS VDD sky130_fd_sc_hd__tapvpwrvgnd_1
XTAP_TAPCELL_ROW_80_1269 VSS VDD sky130_fd_sc_hd__tapvpwrvgnd_1
XTAP_TAPCELL_ROW_80_1270 VSS VDD sky130_fd_sc_hd__tapvpwrvgnd_1
XTAP_TAPCELL_ROW_81_1271 VSS VDD sky130_fd_sc_hd__tapvpwrvgnd_1
XTAP_TAPCELL_ROW_81_1272 VSS VDD sky130_fd_sc_hd__tapvpwrvgnd_1
XTAP_TAPCELL_ROW_81_1273 VSS VDD sky130_fd_sc_hd__tapvpwrvgnd_1
XTAP_TAPCELL_ROW_81_1274 VSS VDD sky130_fd_sc_hd__tapvpwrvgnd_1
XTAP_TAPCELL_ROW_81_1275 VSS VDD sky130_fd_sc_hd__tapvpwrvgnd_1
XTAP_TAPCELL_ROW_81_1276 VSS VDD sky130_fd_sc_hd__tapvpwrvgnd_1
XTAP_TAPCELL_ROW_81_1277 VSS VDD sky130_fd_sc_hd__tapvpwrvgnd_1
XTAP_TAPCELL_ROW_81_1278 VSS VDD sky130_fd_sc_hd__tapvpwrvgnd_1
XTAP_TAPCELL_ROW_81_1279 VSS VDD sky130_fd_sc_hd__tapvpwrvgnd_1
XTAP_TAPCELL_ROW_81_1280 VSS VDD sky130_fd_sc_hd__tapvpwrvgnd_1
XTAP_TAPCELL_ROW_81_1281 VSS VDD sky130_fd_sc_hd__tapvpwrvgnd_1
XTAP_TAPCELL_ROW_81_1282 VSS VDD sky130_fd_sc_hd__tapvpwrvgnd_1
XTAP_TAPCELL_ROW_81_1283 VSS VDD sky130_fd_sc_hd__tapvpwrvgnd_1
XTAP_TAPCELL_ROW_81_1284 VSS VDD sky130_fd_sc_hd__tapvpwrvgnd_1
XTAP_TAPCELL_ROW_81_1285 VSS VDD sky130_fd_sc_hd__tapvpwrvgnd_1
XTAP_TAPCELL_ROW_82_1286 VSS VDD sky130_fd_sc_hd__tapvpwrvgnd_1
XTAP_TAPCELL_ROW_82_1287 VSS VDD sky130_fd_sc_hd__tapvpwrvgnd_1
XTAP_TAPCELL_ROW_82_1288 VSS VDD sky130_fd_sc_hd__tapvpwrvgnd_1
XTAP_TAPCELL_ROW_82_1289 VSS VDD sky130_fd_sc_hd__tapvpwrvgnd_1
XTAP_TAPCELL_ROW_82_1290 VSS VDD sky130_fd_sc_hd__tapvpwrvgnd_1
XTAP_TAPCELL_ROW_82_1291 VSS VDD sky130_fd_sc_hd__tapvpwrvgnd_1
XTAP_TAPCELL_ROW_82_1292 VSS VDD sky130_fd_sc_hd__tapvpwrvgnd_1
XTAP_TAPCELL_ROW_82_1293 VSS VDD sky130_fd_sc_hd__tapvpwrvgnd_1
XTAP_TAPCELL_ROW_82_1294 VSS VDD sky130_fd_sc_hd__tapvpwrvgnd_1
XTAP_TAPCELL_ROW_82_1295 VSS VDD sky130_fd_sc_hd__tapvpwrvgnd_1
XTAP_TAPCELL_ROW_82_1296 VSS VDD sky130_fd_sc_hd__tapvpwrvgnd_1
XTAP_TAPCELL_ROW_82_1297 VSS VDD sky130_fd_sc_hd__tapvpwrvgnd_1
XTAP_TAPCELL_ROW_82_1298 VSS VDD sky130_fd_sc_hd__tapvpwrvgnd_1
XTAP_TAPCELL_ROW_82_1299 VSS VDD sky130_fd_sc_hd__tapvpwrvgnd_1
XTAP_TAPCELL_ROW_82_1300 VSS VDD sky130_fd_sc_hd__tapvpwrvgnd_1
XTAP_TAPCELL_ROW_82_1301 VSS VDD sky130_fd_sc_hd__tapvpwrvgnd_1
XTAP_TAPCELL_ROW_83_1302 VSS VDD sky130_fd_sc_hd__tapvpwrvgnd_1
XTAP_TAPCELL_ROW_83_1303 VSS VDD sky130_fd_sc_hd__tapvpwrvgnd_1
XTAP_TAPCELL_ROW_83_1304 VSS VDD sky130_fd_sc_hd__tapvpwrvgnd_1
XTAP_TAPCELL_ROW_83_1305 VSS VDD sky130_fd_sc_hd__tapvpwrvgnd_1
XTAP_TAPCELL_ROW_83_1306 VSS VDD sky130_fd_sc_hd__tapvpwrvgnd_1
XTAP_TAPCELL_ROW_83_1307 VSS VDD sky130_fd_sc_hd__tapvpwrvgnd_1
XTAP_TAPCELL_ROW_83_1308 VSS VDD sky130_fd_sc_hd__tapvpwrvgnd_1
XTAP_TAPCELL_ROW_83_1309 VSS VDD sky130_fd_sc_hd__tapvpwrvgnd_1
XTAP_TAPCELL_ROW_83_1310 VSS VDD sky130_fd_sc_hd__tapvpwrvgnd_1
XTAP_TAPCELL_ROW_83_1311 VSS VDD sky130_fd_sc_hd__tapvpwrvgnd_1
XTAP_TAPCELL_ROW_83_1312 VSS VDD sky130_fd_sc_hd__tapvpwrvgnd_1
XTAP_TAPCELL_ROW_83_1313 VSS VDD sky130_fd_sc_hd__tapvpwrvgnd_1
XTAP_TAPCELL_ROW_83_1314 VSS VDD sky130_fd_sc_hd__tapvpwrvgnd_1
XTAP_TAPCELL_ROW_83_1315 VSS VDD sky130_fd_sc_hd__tapvpwrvgnd_1
XTAP_TAPCELL_ROW_83_1316 VSS VDD sky130_fd_sc_hd__tapvpwrvgnd_1
XTAP_TAPCELL_ROW_84_1317 VSS VDD sky130_fd_sc_hd__tapvpwrvgnd_1
XTAP_TAPCELL_ROW_84_1318 VSS VDD sky130_fd_sc_hd__tapvpwrvgnd_1
XTAP_TAPCELL_ROW_84_1319 VSS VDD sky130_fd_sc_hd__tapvpwrvgnd_1
XTAP_TAPCELL_ROW_84_1320 VSS VDD sky130_fd_sc_hd__tapvpwrvgnd_1
XTAP_TAPCELL_ROW_84_1321 VSS VDD sky130_fd_sc_hd__tapvpwrvgnd_1
XTAP_TAPCELL_ROW_84_1322 VSS VDD sky130_fd_sc_hd__tapvpwrvgnd_1
XTAP_TAPCELL_ROW_84_1323 VSS VDD sky130_fd_sc_hd__tapvpwrvgnd_1
XTAP_TAPCELL_ROW_84_1324 VSS VDD sky130_fd_sc_hd__tapvpwrvgnd_1
XTAP_TAPCELL_ROW_84_1325 VSS VDD sky130_fd_sc_hd__tapvpwrvgnd_1
XTAP_TAPCELL_ROW_84_1326 VSS VDD sky130_fd_sc_hd__tapvpwrvgnd_1
XTAP_TAPCELL_ROW_84_1327 VSS VDD sky130_fd_sc_hd__tapvpwrvgnd_1
XTAP_TAPCELL_ROW_84_1328 VSS VDD sky130_fd_sc_hd__tapvpwrvgnd_1
XTAP_TAPCELL_ROW_84_1329 VSS VDD sky130_fd_sc_hd__tapvpwrvgnd_1
XTAP_TAPCELL_ROW_84_1330 VSS VDD sky130_fd_sc_hd__tapvpwrvgnd_1
XTAP_TAPCELL_ROW_84_1331 VSS VDD sky130_fd_sc_hd__tapvpwrvgnd_1
XTAP_TAPCELL_ROW_84_1332 VSS VDD sky130_fd_sc_hd__tapvpwrvgnd_1
XTAP_TAPCELL_ROW_85_1333 VSS VDD sky130_fd_sc_hd__tapvpwrvgnd_1
XTAP_TAPCELL_ROW_85_1334 VSS VDD sky130_fd_sc_hd__tapvpwrvgnd_1
XTAP_TAPCELL_ROW_85_1335 VSS VDD sky130_fd_sc_hd__tapvpwrvgnd_1
XTAP_TAPCELL_ROW_85_1336 VSS VDD sky130_fd_sc_hd__tapvpwrvgnd_1
XTAP_TAPCELL_ROW_85_1337 VSS VDD sky130_fd_sc_hd__tapvpwrvgnd_1
XTAP_TAPCELL_ROW_85_1338 VSS VDD sky130_fd_sc_hd__tapvpwrvgnd_1
XTAP_TAPCELL_ROW_85_1339 VSS VDD sky130_fd_sc_hd__tapvpwrvgnd_1
XTAP_TAPCELL_ROW_85_1340 VSS VDD sky130_fd_sc_hd__tapvpwrvgnd_1
XTAP_TAPCELL_ROW_85_1341 VSS VDD sky130_fd_sc_hd__tapvpwrvgnd_1
XTAP_TAPCELL_ROW_85_1342 VSS VDD sky130_fd_sc_hd__tapvpwrvgnd_1
XTAP_TAPCELL_ROW_85_1343 VSS VDD sky130_fd_sc_hd__tapvpwrvgnd_1
XTAP_TAPCELL_ROW_85_1344 VSS VDD sky130_fd_sc_hd__tapvpwrvgnd_1
XTAP_TAPCELL_ROW_85_1345 VSS VDD sky130_fd_sc_hd__tapvpwrvgnd_1
XTAP_TAPCELL_ROW_85_1346 VSS VDD sky130_fd_sc_hd__tapvpwrvgnd_1
XTAP_TAPCELL_ROW_85_1347 VSS VDD sky130_fd_sc_hd__tapvpwrvgnd_1
XTAP_TAPCELL_ROW_86_1348 VSS VDD sky130_fd_sc_hd__tapvpwrvgnd_1
XTAP_TAPCELL_ROW_86_1349 VSS VDD sky130_fd_sc_hd__tapvpwrvgnd_1
XTAP_TAPCELL_ROW_86_1350 VSS VDD sky130_fd_sc_hd__tapvpwrvgnd_1
XTAP_TAPCELL_ROW_86_1351 VSS VDD sky130_fd_sc_hd__tapvpwrvgnd_1
XTAP_TAPCELL_ROW_86_1352 VSS VDD sky130_fd_sc_hd__tapvpwrvgnd_1
XTAP_TAPCELL_ROW_86_1353 VSS VDD sky130_fd_sc_hd__tapvpwrvgnd_1
XTAP_TAPCELL_ROW_86_1354 VSS VDD sky130_fd_sc_hd__tapvpwrvgnd_1
XTAP_TAPCELL_ROW_86_1355 VSS VDD sky130_fd_sc_hd__tapvpwrvgnd_1
XTAP_TAPCELL_ROW_86_1356 VSS VDD sky130_fd_sc_hd__tapvpwrvgnd_1
XTAP_TAPCELL_ROW_86_1357 VSS VDD sky130_fd_sc_hd__tapvpwrvgnd_1
XTAP_TAPCELL_ROW_86_1358 VSS VDD sky130_fd_sc_hd__tapvpwrvgnd_1
XTAP_TAPCELL_ROW_86_1359 VSS VDD sky130_fd_sc_hd__tapvpwrvgnd_1
XTAP_TAPCELL_ROW_86_1360 VSS VDD sky130_fd_sc_hd__tapvpwrvgnd_1
XTAP_TAPCELL_ROW_86_1361 VSS VDD sky130_fd_sc_hd__tapvpwrvgnd_1
XTAP_TAPCELL_ROW_86_1362 VSS VDD sky130_fd_sc_hd__tapvpwrvgnd_1
XTAP_TAPCELL_ROW_86_1363 VSS VDD sky130_fd_sc_hd__tapvpwrvgnd_1
XTAP_TAPCELL_ROW_87_1364 VSS VDD sky130_fd_sc_hd__tapvpwrvgnd_1
XTAP_TAPCELL_ROW_87_1365 VSS VDD sky130_fd_sc_hd__tapvpwrvgnd_1
XTAP_TAPCELL_ROW_87_1366 VSS VDD sky130_fd_sc_hd__tapvpwrvgnd_1
XTAP_TAPCELL_ROW_87_1367 VSS VDD sky130_fd_sc_hd__tapvpwrvgnd_1
XTAP_TAPCELL_ROW_87_1368 VSS VDD sky130_fd_sc_hd__tapvpwrvgnd_1
XTAP_TAPCELL_ROW_87_1369 VSS VDD sky130_fd_sc_hd__tapvpwrvgnd_1
XTAP_TAPCELL_ROW_87_1370 VSS VDD sky130_fd_sc_hd__tapvpwrvgnd_1
XTAP_TAPCELL_ROW_87_1371 VSS VDD sky130_fd_sc_hd__tapvpwrvgnd_1
XTAP_TAPCELL_ROW_87_1372 VSS VDD sky130_fd_sc_hd__tapvpwrvgnd_1
XTAP_TAPCELL_ROW_87_1373 VSS VDD sky130_fd_sc_hd__tapvpwrvgnd_1
XTAP_TAPCELL_ROW_87_1374 VSS VDD sky130_fd_sc_hd__tapvpwrvgnd_1
XTAP_TAPCELL_ROW_87_1375 VSS VDD sky130_fd_sc_hd__tapvpwrvgnd_1
XTAP_TAPCELL_ROW_87_1376 VSS VDD sky130_fd_sc_hd__tapvpwrvgnd_1
XTAP_TAPCELL_ROW_87_1377 VSS VDD sky130_fd_sc_hd__tapvpwrvgnd_1
XTAP_TAPCELL_ROW_87_1378 VSS VDD sky130_fd_sc_hd__tapvpwrvgnd_1
XTAP_TAPCELL_ROW_88_1379 VSS VDD sky130_fd_sc_hd__tapvpwrvgnd_1
XTAP_TAPCELL_ROW_88_1380 VSS VDD sky130_fd_sc_hd__tapvpwrvgnd_1
XTAP_TAPCELL_ROW_88_1381 VSS VDD sky130_fd_sc_hd__tapvpwrvgnd_1
XTAP_TAPCELL_ROW_88_1382 VSS VDD sky130_fd_sc_hd__tapvpwrvgnd_1
XTAP_TAPCELL_ROW_88_1383 VSS VDD sky130_fd_sc_hd__tapvpwrvgnd_1
XTAP_TAPCELL_ROW_88_1384 VSS VDD sky130_fd_sc_hd__tapvpwrvgnd_1
XTAP_TAPCELL_ROW_88_1385 VSS VDD sky130_fd_sc_hd__tapvpwrvgnd_1
XTAP_TAPCELL_ROW_88_1386 VSS VDD sky130_fd_sc_hd__tapvpwrvgnd_1
XTAP_TAPCELL_ROW_88_1387 VSS VDD sky130_fd_sc_hd__tapvpwrvgnd_1
XTAP_TAPCELL_ROW_88_1388 VSS VDD sky130_fd_sc_hd__tapvpwrvgnd_1
XTAP_TAPCELL_ROW_88_1389 VSS VDD sky130_fd_sc_hd__tapvpwrvgnd_1
XTAP_TAPCELL_ROW_88_1390 VSS VDD sky130_fd_sc_hd__tapvpwrvgnd_1
XTAP_TAPCELL_ROW_88_1391 VSS VDD sky130_fd_sc_hd__tapvpwrvgnd_1
XTAP_TAPCELL_ROW_88_1392 VSS VDD sky130_fd_sc_hd__tapvpwrvgnd_1
XTAP_TAPCELL_ROW_88_1393 VSS VDD sky130_fd_sc_hd__tapvpwrvgnd_1
XTAP_TAPCELL_ROW_88_1394 VSS VDD sky130_fd_sc_hd__tapvpwrvgnd_1
XTAP_TAPCELL_ROW_89_1395 VSS VDD sky130_fd_sc_hd__tapvpwrvgnd_1
XTAP_TAPCELL_ROW_89_1396 VSS VDD sky130_fd_sc_hd__tapvpwrvgnd_1
XTAP_TAPCELL_ROW_89_1397 VSS VDD sky130_fd_sc_hd__tapvpwrvgnd_1
XTAP_TAPCELL_ROW_89_1398 VSS VDD sky130_fd_sc_hd__tapvpwrvgnd_1
XTAP_TAPCELL_ROW_89_1399 VSS VDD sky130_fd_sc_hd__tapvpwrvgnd_1
XTAP_TAPCELL_ROW_89_1400 VSS VDD sky130_fd_sc_hd__tapvpwrvgnd_1
XTAP_TAPCELL_ROW_89_1401 VSS VDD sky130_fd_sc_hd__tapvpwrvgnd_1
XTAP_TAPCELL_ROW_89_1402 VSS VDD sky130_fd_sc_hd__tapvpwrvgnd_1
XTAP_TAPCELL_ROW_89_1403 VSS VDD sky130_fd_sc_hd__tapvpwrvgnd_1
XTAP_TAPCELL_ROW_89_1404 VSS VDD sky130_fd_sc_hd__tapvpwrvgnd_1
XTAP_TAPCELL_ROW_89_1405 VSS VDD sky130_fd_sc_hd__tapvpwrvgnd_1
XTAP_TAPCELL_ROW_89_1406 VSS VDD sky130_fd_sc_hd__tapvpwrvgnd_1
XTAP_TAPCELL_ROW_89_1407 VSS VDD sky130_fd_sc_hd__tapvpwrvgnd_1
XTAP_TAPCELL_ROW_89_1408 VSS VDD sky130_fd_sc_hd__tapvpwrvgnd_1
XTAP_TAPCELL_ROW_89_1409 VSS VDD sky130_fd_sc_hd__tapvpwrvgnd_1
XTAP_TAPCELL_ROW_90_1410 VSS VDD sky130_fd_sc_hd__tapvpwrvgnd_1
XTAP_TAPCELL_ROW_90_1411 VSS VDD sky130_fd_sc_hd__tapvpwrvgnd_1
XTAP_TAPCELL_ROW_90_1412 VSS VDD sky130_fd_sc_hd__tapvpwrvgnd_1
XTAP_TAPCELL_ROW_90_1413 VSS VDD sky130_fd_sc_hd__tapvpwrvgnd_1
XTAP_TAPCELL_ROW_90_1414 VSS VDD sky130_fd_sc_hd__tapvpwrvgnd_1
XTAP_TAPCELL_ROW_90_1415 VSS VDD sky130_fd_sc_hd__tapvpwrvgnd_1
XTAP_TAPCELL_ROW_90_1416 VSS VDD sky130_fd_sc_hd__tapvpwrvgnd_1
XTAP_TAPCELL_ROW_90_1417 VSS VDD sky130_fd_sc_hd__tapvpwrvgnd_1
XTAP_TAPCELL_ROW_90_1418 VSS VDD sky130_fd_sc_hd__tapvpwrvgnd_1
XTAP_TAPCELL_ROW_90_1419 VSS VDD sky130_fd_sc_hd__tapvpwrvgnd_1
XTAP_TAPCELL_ROW_90_1420 VSS VDD sky130_fd_sc_hd__tapvpwrvgnd_1
XTAP_TAPCELL_ROW_90_1421 VSS VDD sky130_fd_sc_hd__tapvpwrvgnd_1
XTAP_TAPCELL_ROW_90_1422 VSS VDD sky130_fd_sc_hd__tapvpwrvgnd_1
XTAP_TAPCELL_ROW_90_1423 VSS VDD sky130_fd_sc_hd__tapvpwrvgnd_1
XTAP_TAPCELL_ROW_90_1424 VSS VDD sky130_fd_sc_hd__tapvpwrvgnd_1
XTAP_TAPCELL_ROW_90_1425 VSS VDD sky130_fd_sc_hd__tapvpwrvgnd_1
XTAP_TAPCELL_ROW_91_1426 VSS VDD sky130_fd_sc_hd__tapvpwrvgnd_1
XTAP_TAPCELL_ROW_91_1427 VSS VDD sky130_fd_sc_hd__tapvpwrvgnd_1
XTAP_TAPCELL_ROW_91_1428 VSS VDD sky130_fd_sc_hd__tapvpwrvgnd_1
XTAP_TAPCELL_ROW_91_1429 VSS VDD sky130_fd_sc_hd__tapvpwrvgnd_1
XTAP_TAPCELL_ROW_91_1430 VSS VDD sky130_fd_sc_hd__tapvpwrvgnd_1
XTAP_TAPCELL_ROW_91_1431 VSS VDD sky130_fd_sc_hd__tapvpwrvgnd_1
XTAP_TAPCELL_ROW_91_1432 VSS VDD sky130_fd_sc_hd__tapvpwrvgnd_1
XTAP_TAPCELL_ROW_91_1433 VSS VDD sky130_fd_sc_hd__tapvpwrvgnd_1
XTAP_TAPCELL_ROW_91_1434 VSS VDD sky130_fd_sc_hd__tapvpwrvgnd_1
XTAP_TAPCELL_ROW_91_1435 VSS VDD sky130_fd_sc_hd__tapvpwrvgnd_1
XTAP_TAPCELL_ROW_91_1436 VSS VDD sky130_fd_sc_hd__tapvpwrvgnd_1
XTAP_TAPCELL_ROW_91_1437 VSS VDD sky130_fd_sc_hd__tapvpwrvgnd_1
XTAP_TAPCELL_ROW_91_1438 VSS VDD sky130_fd_sc_hd__tapvpwrvgnd_1
XTAP_TAPCELL_ROW_91_1439 VSS VDD sky130_fd_sc_hd__tapvpwrvgnd_1
XTAP_TAPCELL_ROW_91_1440 VSS VDD sky130_fd_sc_hd__tapvpwrvgnd_1
XTAP_TAPCELL_ROW_92_1441 VSS VDD sky130_fd_sc_hd__tapvpwrvgnd_1
XTAP_TAPCELL_ROW_92_1442 VSS VDD sky130_fd_sc_hd__tapvpwrvgnd_1
XTAP_TAPCELL_ROW_92_1443 VSS VDD sky130_fd_sc_hd__tapvpwrvgnd_1
XTAP_TAPCELL_ROW_92_1444 VSS VDD sky130_fd_sc_hd__tapvpwrvgnd_1
XTAP_TAPCELL_ROW_92_1445 VSS VDD sky130_fd_sc_hd__tapvpwrvgnd_1
XTAP_TAPCELL_ROW_92_1446 VSS VDD sky130_fd_sc_hd__tapvpwrvgnd_1
XTAP_TAPCELL_ROW_92_1447 VSS VDD sky130_fd_sc_hd__tapvpwrvgnd_1
XTAP_TAPCELL_ROW_92_1448 VSS VDD sky130_fd_sc_hd__tapvpwrvgnd_1
XTAP_TAPCELL_ROW_92_1449 VSS VDD sky130_fd_sc_hd__tapvpwrvgnd_1
XTAP_TAPCELL_ROW_92_1450 VSS VDD sky130_fd_sc_hd__tapvpwrvgnd_1
XTAP_TAPCELL_ROW_92_1451 VSS VDD sky130_fd_sc_hd__tapvpwrvgnd_1
XTAP_TAPCELL_ROW_92_1452 VSS VDD sky130_fd_sc_hd__tapvpwrvgnd_1
XTAP_TAPCELL_ROW_92_1453 VSS VDD sky130_fd_sc_hd__tapvpwrvgnd_1
XTAP_TAPCELL_ROW_92_1454 VSS VDD sky130_fd_sc_hd__tapvpwrvgnd_1
XTAP_TAPCELL_ROW_92_1455 VSS VDD sky130_fd_sc_hd__tapvpwrvgnd_1
XTAP_TAPCELL_ROW_92_1456 VSS VDD sky130_fd_sc_hd__tapvpwrvgnd_1
XTAP_TAPCELL_ROW_93_1457 VSS VDD sky130_fd_sc_hd__tapvpwrvgnd_1
XTAP_TAPCELL_ROW_93_1458 VSS VDD sky130_fd_sc_hd__tapvpwrvgnd_1
XTAP_TAPCELL_ROW_93_1459 VSS VDD sky130_fd_sc_hd__tapvpwrvgnd_1
XTAP_TAPCELL_ROW_93_1460 VSS VDD sky130_fd_sc_hd__tapvpwrvgnd_1
XTAP_TAPCELL_ROW_93_1461 VSS VDD sky130_fd_sc_hd__tapvpwrvgnd_1
XTAP_TAPCELL_ROW_93_1462 VSS VDD sky130_fd_sc_hd__tapvpwrvgnd_1
XTAP_TAPCELL_ROW_93_1463 VSS VDD sky130_fd_sc_hd__tapvpwrvgnd_1
XTAP_TAPCELL_ROW_93_1464 VSS VDD sky130_fd_sc_hd__tapvpwrvgnd_1
XTAP_TAPCELL_ROW_93_1465 VSS VDD sky130_fd_sc_hd__tapvpwrvgnd_1
XTAP_TAPCELL_ROW_93_1466 VSS VDD sky130_fd_sc_hd__tapvpwrvgnd_1
XTAP_TAPCELL_ROW_93_1467 VSS VDD sky130_fd_sc_hd__tapvpwrvgnd_1
XTAP_TAPCELL_ROW_93_1468 VSS VDD sky130_fd_sc_hd__tapvpwrvgnd_1
XTAP_TAPCELL_ROW_93_1469 VSS VDD sky130_fd_sc_hd__tapvpwrvgnd_1
XTAP_TAPCELL_ROW_93_1470 VSS VDD sky130_fd_sc_hd__tapvpwrvgnd_1
XTAP_TAPCELL_ROW_93_1471 VSS VDD sky130_fd_sc_hd__tapvpwrvgnd_1
XTAP_TAPCELL_ROW_94_1472 VSS VDD sky130_fd_sc_hd__tapvpwrvgnd_1
XTAP_TAPCELL_ROW_94_1473 VSS VDD sky130_fd_sc_hd__tapvpwrvgnd_1
XTAP_TAPCELL_ROW_94_1474 VSS VDD sky130_fd_sc_hd__tapvpwrvgnd_1
XTAP_TAPCELL_ROW_94_1475 VSS VDD sky130_fd_sc_hd__tapvpwrvgnd_1
XTAP_TAPCELL_ROW_94_1476 VSS VDD sky130_fd_sc_hd__tapvpwrvgnd_1
XTAP_TAPCELL_ROW_94_1477 VSS VDD sky130_fd_sc_hd__tapvpwrvgnd_1
XTAP_TAPCELL_ROW_94_1478 VSS VDD sky130_fd_sc_hd__tapvpwrvgnd_1
XTAP_TAPCELL_ROW_94_1479 VSS VDD sky130_fd_sc_hd__tapvpwrvgnd_1
XTAP_TAPCELL_ROW_94_1480 VSS VDD sky130_fd_sc_hd__tapvpwrvgnd_1
XTAP_TAPCELL_ROW_94_1481 VSS VDD sky130_fd_sc_hd__tapvpwrvgnd_1
XTAP_TAPCELL_ROW_94_1482 VSS VDD sky130_fd_sc_hd__tapvpwrvgnd_1
XTAP_TAPCELL_ROW_94_1483 VSS VDD sky130_fd_sc_hd__tapvpwrvgnd_1
XTAP_TAPCELL_ROW_94_1484 VSS VDD sky130_fd_sc_hd__tapvpwrvgnd_1
XTAP_TAPCELL_ROW_94_1485 VSS VDD sky130_fd_sc_hd__tapvpwrvgnd_1
XTAP_TAPCELL_ROW_94_1486 VSS VDD sky130_fd_sc_hd__tapvpwrvgnd_1
XTAP_TAPCELL_ROW_94_1487 VSS VDD sky130_fd_sc_hd__tapvpwrvgnd_1
XTAP_TAPCELL_ROW_95_1488 VSS VDD sky130_fd_sc_hd__tapvpwrvgnd_1
XTAP_TAPCELL_ROW_95_1489 VSS VDD sky130_fd_sc_hd__tapvpwrvgnd_1
XTAP_TAPCELL_ROW_95_1490 VSS VDD sky130_fd_sc_hd__tapvpwrvgnd_1
XTAP_TAPCELL_ROW_95_1491 VSS VDD sky130_fd_sc_hd__tapvpwrvgnd_1
XTAP_TAPCELL_ROW_95_1492 VSS VDD sky130_fd_sc_hd__tapvpwrvgnd_1
XTAP_TAPCELL_ROW_95_1493 VSS VDD sky130_fd_sc_hd__tapvpwrvgnd_1
XTAP_TAPCELL_ROW_95_1494 VSS VDD sky130_fd_sc_hd__tapvpwrvgnd_1
XTAP_TAPCELL_ROW_95_1495 VSS VDD sky130_fd_sc_hd__tapvpwrvgnd_1
XTAP_TAPCELL_ROW_95_1496 VSS VDD sky130_fd_sc_hd__tapvpwrvgnd_1
XTAP_TAPCELL_ROW_95_1497 VSS VDD sky130_fd_sc_hd__tapvpwrvgnd_1
XTAP_TAPCELL_ROW_95_1498 VSS VDD sky130_fd_sc_hd__tapvpwrvgnd_1
XTAP_TAPCELL_ROW_95_1499 VSS VDD sky130_fd_sc_hd__tapvpwrvgnd_1
XTAP_TAPCELL_ROW_95_1500 VSS VDD sky130_fd_sc_hd__tapvpwrvgnd_1
XTAP_TAPCELL_ROW_95_1501 VSS VDD sky130_fd_sc_hd__tapvpwrvgnd_1
XTAP_TAPCELL_ROW_95_1502 VSS VDD sky130_fd_sc_hd__tapvpwrvgnd_1
XTAP_TAPCELL_ROW_96_1503 VSS VDD sky130_fd_sc_hd__tapvpwrvgnd_1
XTAP_TAPCELL_ROW_96_1504 VSS VDD sky130_fd_sc_hd__tapvpwrvgnd_1
XTAP_TAPCELL_ROW_96_1505 VSS VDD sky130_fd_sc_hd__tapvpwrvgnd_1
XTAP_TAPCELL_ROW_96_1506 VSS VDD sky130_fd_sc_hd__tapvpwrvgnd_1
XTAP_TAPCELL_ROW_96_1507 VSS VDD sky130_fd_sc_hd__tapvpwrvgnd_1
XTAP_TAPCELL_ROW_96_1508 VSS VDD sky130_fd_sc_hd__tapvpwrvgnd_1
XTAP_TAPCELL_ROW_96_1509 VSS VDD sky130_fd_sc_hd__tapvpwrvgnd_1
XTAP_TAPCELL_ROW_96_1510 VSS VDD sky130_fd_sc_hd__tapvpwrvgnd_1
XTAP_TAPCELL_ROW_96_1511 VSS VDD sky130_fd_sc_hd__tapvpwrvgnd_1
XTAP_TAPCELL_ROW_96_1512 VSS VDD sky130_fd_sc_hd__tapvpwrvgnd_1
XTAP_TAPCELL_ROW_96_1513 VSS VDD sky130_fd_sc_hd__tapvpwrvgnd_1
XTAP_TAPCELL_ROW_96_1514 VSS VDD sky130_fd_sc_hd__tapvpwrvgnd_1
XTAP_TAPCELL_ROW_96_1515 VSS VDD sky130_fd_sc_hd__tapvpwrvgnd_1
XTAP_TAPCELL_ROW_96_1516 VSS VDD sky130_fd_sc_hd__tapvpwrvgnd_1
XTAP_TAPCELL_ROW_96_1517 VSS VDD sky130_fd_sc_hd__tapvpwrvgnd_1
XTAP_TAPCELL_ROW_96_1518 VSS VDD sky130_fd_sc_hd__tapvpwrvgnd_1
XTAP_TAPCELL_ROW_97_1519 VSS VDD sky130_fd_sc_hd__tapvpwrvgnd_1
XTAP_TAPCELL_ROW_97_1520 VSS VDD sky130_fd_sc_hd__tapvpwrvgnd_1
XTAP_TAPCELL_ROW_97_1521 VSS VDD sky130_fd_sc_hd__tapvpwrvgnd_1
XTAP_TAPCELL_ROW_97_1522 VSS VDD sky130_fd_sc_hd__tapvpwrvgnd_1
XTAP_TAPCELL_ROW_97_1523 VSS VDD sky130_fd_sc_hd__tapvpwrvgnd_1
XTAP_TAPCELL_ROW_97_1524 VSS VDD sky130_fd_sc_hd__tapvpwrvgnd_1
XTAP_TAPCELL_ROW_97_1525 VSS VDD sky130_fd_sc_hd__tapvpwrvgnd_1
XTAP_TAPCELL_ROW_97_1526 VSS VDD sky130_fd_sc_hd__tapvpwrvgnd_1
XTAP_TAPCELL_ROW_97_1527 VSS VDD sky130_fd_sc_hd__tapvpwrvgnd_1
XTAP_TAPCELL_ROW_97_1528 VSS VDD sky130_fd_sc_hd__tapvpwrvgnd_1
XTAP_TAPCELL_ROW_97_1529 VSS VDD sky130_fd_sc_hd__tapvpwrvgnd_1
XTAP_TAPCELL_ROW_97_1530 VSS VDD sky130_fd_sc_hd__tapvpwrvgnd_1
XTAP_TAPCELL_ROW_97_1531 VSS VDD sky130_fd_sc_hd__tapvpwrvgnd_1
XTAP_TAPCELL_ROW_97_1532 VSS VDD sky130_fd_sc_hd__tapvpwrvgnd_1
XTAP_TAPCELL_ROW_97_1533 VSS VDD sky130_fd_sc_hd__tapvpwrvgnd_1
XTAP_TAPCELL_ROW_98_1534 VSS VDD sky130_fd_sc_hd__tapvpwrvgnd_1
XTAP_TAPCELL_ROW_98_1535 VSS VDD sky130_fd_sc_hd__tapvpwrvgnd_1
XTAP_TAPCELL_ROW_98_1536 VSS VDD sky130_fd_sc_hd__tapvpwrvgnd_1
XTAP_TAPCELL_ROW_98_1537 VSS VDD sky130_fd_sc_hd__tapvpwrvgnd_1
XTAP_TAPCELL_ROW_98_1538 VSS VDD sky130_fd_sc_hd__tapvpwrvgnd_1
XTAP_TAPCELL_ROW_98_1539 VSS VDD sky130_fd_sc_hd__tapvpwrvgnd_1
XTAP_TAPCELL_ROW_98_1540 VSS VDD sky130_fd_sc_hd__tapvpwrvgnd_1
XTAP_TAPCELL_ROW_98_1541 VSS VDD sky130_fd_sc_hd__tapvpwrvgnd_1
XTAP_TAPCELL_ROW_98_1542 VSS VDD sky130_fd_sc_hd__tapvpwrvgnd_1
XTAP_TAPCELL_ROW_98_1543 VSS VDD sky130_fd_sc_hd__tapvpwrvgnd_1
XTAP_TAPCELL_ROW_98_1544 VSS VDD sky130_fd_sc_hd__tapvpwrvgnd_1
XTAP_TAPCELL_ROW_98_1545 VSS VDD sky130_fd_sc_hd__tapvpwrvgnd_1
XTAP_TAPCELL_ROW_98_1546 VSS VDD sky130_fd_sc_hd__tapvpwrvgnd_1
XTAP_TAPCELL_ROW_98_1547 VSS VDD sky130_fd_sc_hd__tapvpwrvgnd_1
XTAP_TAPCELL_ROW_98_1548 VSS VDD sky130_fd_sc_hd__tapvpwrvgnd_1
XTAP_TAPCELL_ROW_98_1549 VSS VDD sky130_fd_sc_hd__tapvpwrvgnd_1
XTAP_TAPCELL_ROW_99_1550 VSS VDD sky130_fd_sc_hd__tapvpwrvgnd_1
XTAP_TAPCELL_ROW_99_1551 VSS VDD sky130_fd_sc_hd__tapvpwrvgnd_1
XTAP_TAPCELL_ROW_99_1552 VSS VDD sky130_fd_sc_hd__tapvpwrvgnd_1
XTAP_TAPCELL_ROW_99_1553 VSS VDD sky130_fd_sc_hd__tapvpwrvgnd_1
XTAP_TAPCELL_ROW_99_1554 VSS VDD sky130_fd_sc_hd__tapvpwrvgnd_1
XTAP_TAPCELL_ROW_99_1555 VSS VDD sky130_fd_sc_hd__tapvpwrvgnd_1
XTAP_TAPCELL_ROW_99_1556 VSS VDD sky130_fd_sc_hd__tapvpwrvgnd_1
XTAP_TAPCELL_ROW_99_1557 VSS VDD sky130_fd_sc_hd__tapvpwrvgnd_1
XTAP_TAPCELL_ROW_99_1558 VSS VDD sky130_fd_sc_hd__tapvpwrvgnd_1
XTAP_TAPCELL_ROW_99_1559 VSS VDD sky130_fd_sc_hd__tapvpwrvgnd_1
XTAP_TAPCELL_ROW_99_1560 VSS VDD sky130_fd_sc_hd__tapvpwrvgnd_1
XTAP_TAPCELL_ROW_99_1561 VSS VDD sky130_fd_sc_hd__tapvpwrvgnd_1
XTAP_TAPCELL_ROW_99_1562 VSS VDD sky130_fd_sc_hd__tapvpwrvgnd_1
XTAP_TAPCELL_ROW_99_1563 VSS VDD sky130_fd_sc_hd__tapvpwrvgnd_1
XTAP_TAPCELL_ROW_99_1564 VSS VDD sky130_fd_sc_hd__tapvpwrvgnd_1
XTAP_TAPCELL_ROW_100_1565 VSS VDD sky130_fd_sc_hd__tapvpwrvgnd_1
XTAP_TAPCELL_ROW_100_1566 VSS VDD sky130_fd_sc_hd__tapvpwrvgnd_1
XTAP_TAPCELL_ROW_100_1567 VSS VDD sky130_fd_sc_hd__tapvpwrvgnd_1
XTAP_TAPCELL_ROW_100_1568 VSS VDD sky130_fd_sc_hd__tapvpwrvgnd_1
XTAP_TAPCELL_ROW_100_1569 VSS VDD sky130_fd_sc_hd__tapvpwrvgnd_1
XTAP_TAPCELL_ROW_100_1570 VSS VDD sky130_fd_sc_hd__tapvpwrvgnd_1
XTAP_TAPCELL_ROW_100_1571 VSS VDD sky130_fd_sc_hd__tapvpwrvgnd_1
XTAP_TAPCELL_ROW_100_1572 VSS VDD sky130_fd_sc_hd__tapvpwrvgnd_1
XTAP_TAPCELL_ROW_100_1573 VSS VDD sky130_fd_sc_hd__tapvpwrvgnd_1
XTAP_TAPCELL_ROW_100_1574 VSS VDD sky130_fd_sc_hd__tapvpwrvgnd_1
XTAP_TAPCELL_ROW_100_1575 VSS VDD sky130_fd_sc_hd__tapvpwrvgnd_1
XTAP_TAPCELL_ROW_100_1576 VSS VDD sky130_fd_sc_hd__tapvpwrvgnd_1
XTAP_TAPCELL_ROW_100_1577 VSS VDD sky130_fd_sc_hd__tapvpwrvgnd_1
XTAP_TAPCELL_ROW_100_1578 VSS VDD sky130_fd_sc_hd__tapvpwrvgnd_1
XTAP_TAPCELL_ROW_100_1579 VSS VDD sky130_fd_sc_hd__tapvpwrvgnd_1
XTAP_TAPCELL_ROW_100_1580 VSS VDD sky130_fd_sc_hd__tapvpwrvgnd_1
XTAP_TAPCELL_ROW_101_1581 VSS VDD sky130_fd_sc_hd__tapvpwrvgnd_1
XTAP_TAPCELL_ROW_101_1582 VSS VDD sky130_fd_sc_hd__tapvpwrvgnd_1
XTAP_TAPCELL_ROW_101_1583 VSS VDD sky130_fd_sc_hd__tapvpwrvgnd_1
XTAP_TAPCELL_ROW_101_1584 VSS VDD sky130_fd_sc_hd__tapvpwrvgnd_1
XTAP_TAPCELL_ROW_101_1585 VSS VDD sky130_fd_sc_hd__tapvpwrvgnd_1
XTAP_TAPCELL_ROW_101_1586 VSS VDD sky130_fd_sc_hd__tapvpwrvgnd_1
XTAP_TAPCELL_ROW_101_1587 VSS VDD sky130_fd_sc_hd__tapvpwrvgnd_1
XTAP_TAPCELL_ROW_101_1588 VSS VDD sky130_fd_sc_hd__tapvpwrvgnd_1
XTAP_TAPCELL_ROW_101_1589 VSS VDD sky130_fd_sc_hd__tapvpwrvgnd_1
XTAP_TAPCELL_ROW_101_1590 VSS VDD sky130_fd_sc_hd__tapvpwrvgnd_1
XTAP_TAPCELL_ROW_101_1591 VSS VDD sky130_fd_sc_hd__tapvpwrvgnd_1
XTAP_TAPCELL_ROW_101_1592 VSS VDD sky130_fd_sc_hd__tapvpwrvgnd_1
XTAP_TAPCELL_ROW_101_1593 VSS VDD sky130_fd_sc_hd__tapvpwrvgnd_1
XTAP_TAPCELL_ROW_101_1594 VSS VDD sky130_fd_sc_hd__tapvpwrvgnd_1
XTAP_TAPCELL_ROW_101_1595 VSS VDD sky130_fd_sc_hd__tapvpwrvgnd_1
XTAP_TAPCELL_ROW_102_1596 VSS VDD sky130_fd_sc_hd__tapvpwrvgnd_1
XTAP_TAPCELL_ROW_102_1597 VSS VDD sky130_fd_sc_hd__tapvpwrvgnd_1
XTAP_TAPCELL_ROW_102_1598 VSS VDD sky130_fd_sc_hd__tapvpwrvgnd_1
XTAP_TAPCELL_ROW_102_1599 VSS VDD sky130_fd_sc_hd__tapvpwrvgnd_1
XTAP_TAPCELL_ROW_102_1600 VSS VDD sky130_fd_sc_hd__tapvpwrvgnd_1
XTAP_TAPCELL_ROW_102_1601 VSS VDD sky130_fd_sc_hd__tapvpwrvgnd_1
XTAP_TAPCELL_ROW_102_1602 VSS VDD sky130_fd_sc_hd__tapvpwrvgnd_1
XTAP_TAPCELL_ROW_102_1603 VSS VDD sky130_fd_sc_hd__tapvpwrvgnd_1
XTAP_TAPCELL_ROW_102_1604 VSS VDD sky130_fd_sc_hd__tapvpwrvgnd_1
XTAP_TAPCELL_ROW_102_1605 VSS VDD sky130_fd_sc_hd__tapvpwrvgnd_1
XTAP_TAPCELL_ROW_102_1606 VSS VDD sky130_fd_sc_hd__tapvpwrvgnd_1
XTAP_TAPCELL_ROW_102_1607 VSS VDD sky130_fd_sc_hd__tapvpwrvgnd_1
XTAP_TAPCELL_ROW_102_1608 VSS VDD sky130_fd_sc_hd__tapvpwrvgnd_1
XTAP_TAPCELL_ROW_102_1609 VSS VDD sky130_fd_sc_hd__tapvpwrvgnd_1
XTAP_TAPCELL_ROW_102_1610 VSS VDD sky130_fd_sc_hd__tapvpwrvgnd_1
XTAP_TAPCELL_ROW_102_1611 VSS VDD sky130_fd_sc_hd__tapvpwrvgnd_1
XTAP_TAPCELL_ROW_103_1612 VSS VDD sky130_fd_sc_hd__tapvpwrvgnd_1
XTAP_TAPCELL_ROW_103_1613 VSS VDD sky130_fd_sc_hd__tapvpwrvgnd_1
XTAP_TAPCELL_ROW_103_1614 VSS VDD sky130_fd_sc_hd__tapvpwrvgnd_1
XTAP_TAPCELL_ROW_103_1615 VSS VDD sky130_fd_sc_hd__tapvpwrvgnd_1
XTAP_TAPCELL_ROW_103_1616 VSS VDD sky130_fd_sc_hd__tapvpwrvgnd_1
XTAP_TAPCELL_ROW_103_1617 VSS VDD sky130_fd_sc_hd__tapvpwrvgnd_1
XTAP_TAPCELL_ROW_103_1618 VSS VDD sky130_fd_sc_hd__tapvpwrvgnd_1
XTAP_TAPCELL_ROW_103_1619 VSS VDD sky130_fd_sc_hd__tapvpwrvgnd_1
XTAP_TAPCELL_ROW_103_1620 VSS VDD sky130_fd_sc_hd__tapvpwrvgnd_1
XTAP_TAPCELL_ROW_103_1621 VSS VDD sky130_fd_sc_hd__tapvpwrvgnd_1
XTAP_TAPCELL_ROW_103_1622 VSS VDD sky130_fd_sc_hd__tapvpwrvgnd_1
XTAP_TAPCELL_ROW_103_1623 VSS VDD sky130_fd_sc_hd__tapvpwrvgnd_1
XTAP_TAPCELL_ROW_103_1624 VSS VDD sky130_fd_sc_hd__tapvpwrvgnd_1
XTAP_TAPCELL_ROW_103_1625 VSS VDD sky130_fd_sc_hd__tapvpwrvgnd_1
XTAP_TAPCELL_ROW_103_1626 VSS VDD sky130_fd_sc_hd__tapvpwrvgnd_1
XTAP_TAPCELL_ROW_104_1627 VSS VDD sky130_fd_sc_hd__tapvpwrvgnd_1
XTAP_TAPCELL_ROW_104_1628 VSS VDD sky130_fd_sc_hd__tapvpwrvgnd_1
XTAP_TAPCELL_ROW_104_1629 VSS VDD sky130_fd_sc_hd__tapvpwrvgnd_1
XTAP_TAPCELL_ROW_104_1630 VSS VDD sky130_fd_sc_hd__tapvpwrvgnd_1
XTAP_TAPCELL_ROW_104_1631 VSS VDD sky130_fd_sc_hd__tapvpwrvgnd_1
XTAP_TAPCELL_ROW_104_1632 VSS VDD sky130_fd_sc_hd__tapvpwrvgnd_1
XTAP_TAPCELL_ROW_104_1633 VSS VDD sky130_fd_sc_hd__tapvpwrvgnd_1
XTAP_TAPCELL_ROW_104_1634 VSS VDD sky130_fd_sc_hd__tapvpwrvgnd_1
XTAP_TAPCELL_ROW_104_1635 VSS VDD sky130_fd_sc_hd__tapvpwrvgnd_1
XTAP_TAPCELL_ROW_104_1636 VSS VDD sky130_fd_sc_hd__tapvpwrvgnd_1
XTAP_TAPCELL_ROW_104_1637 VSS VDD sky130_fd_sc_hd__tapvpwrvgnd_1
XTAP_TAPCELL_ROW_104_1638 VSS VDD sky130_fd_sc_hd__tapvpwrvgnd_1
XTAP_TAPCELL_ROW_104_1639 VSS VDD sky130_fd_sc_hd__tapvpwrvgnd_1
XTAP_TAPCELL_ROW_104_1640 VSS VDD sky130_fd_sc_hd__tapvpwrvgnd_1
XTAP_TAPCELL_ROW_104_1641 VSS VDD sky130_fd_sc_hd__tapvpwrvgnd_1
XTAP_TAPCELL_ROW_104_1642 VSS VDD sky130_fd_sc_hd__tapvpwrvgnd_1
XTAP_TAPCELL_ROW_105_1643 VSS VDD sky130_fd_sc_hd__tapvpwrvgnd_1
XTAP_TAPCELL_ROW_105_1644 VSS VDD sky130_fd_sc_hd__tapvpwrvgnd_1
XTAP_TAPCELL_ROW_105_1645 VSS VDD sky130_fd_sc_hd__tapvpwrvgnd_1
XTAP_TAPCELL_ROW_105_1646 VSS VDD sky130_fd_sc_hd__tapvpwrvgnd_1
XTAP_TAPCELL_ROW_105_1647 VSS VDD sky130_fd_sc_hd__tapvpwrvgnd_1
XTAP_TAPCELL_ROW_105_1648 VSS VDD sky130_fd_sc_hd__tapvpwrvgnd_1
XTAP_TAPCELL_ROW_105_1649 VSS VDD sky130_fd_sc_hd__tapvpwrvgnd_1
XTAP_TAPCELL_ROW_105_1650 VSS VDD sky130_fd_sc_hd__tapvpwrvgnd_1
XTAP_TAPCELL_ROW_105_1651 VSS VDD sky130_fd_sc_hd__tapvpwrvgnd_1
XTAP_TAPCELL_ROW_105_1652 VSS VDD sky130_fd_sc_hd__tapvpwrvgnd_1
XTAP_TAPCELL_ROW_105_1653 VSS VDD sky130_fd_sc_hd__tapvpwrvgnd_1
XTAP_TAPCELL_ROW_105_1654 VSS VDD sky130_fd_sc_hd__tapvpwrvgnd_1
XTAP_TAPCELL_ROW_105_1655 VSS VDD sky130_fd_sc_hd__tapvpwrvgnd_1
XTAP_TAPCELL_ROW_105_1656 VSS VDD sky130_fd_sc_hd__tapvpwrvgnd_1
XTAP_TAPCELL_ROW_105_1657 VSS VDD sky130_fd_sc_hd__tapvpwrvgnd_1
XTAP_TAPCELL_ROW_106_1658 VSS VDD sky130_fd_sc_hd__tapvpwrvgnd_1
XTAP_TAPCELL_ROW_106_1659 VSS VDD sky130_fd_sc_hd__tapvpwrvgnd_1
XTAP_TAPCELL_ROW_106_1660 VSS VDD sky130_fd_sc_hd__tapvpwrvgnd_1
XTAP_TAPCELL_ROW_106_1661 VSS VDD sky130_fd_sc_hd__tapvpwrvgnd_1
XTAP_TAPCELL_ROW_106_1662 VSS VDD sky130_fd_sc_hd__tapvpwrvgnd_1
XTAP_TAPCELL_ROW_106_1663 VSS VDD sky130_fd_sc_hd__tapvpwrvgnd_1
XTAP_TAPCELL_ROW_106_1664 VSS VDD sky130_fd_sc_hd__tapvpwrvgnd_1
XTAP_TAPCELL_ROW_106_1665 VSS VDD sky130_fd_sc_hd__tapvpwrvgnd_1
XTAP_TAPCELL_ROW_106_1666 VSS VDD sky130_fd_sc_hd__tapvpwrvgnd_1
XTAP_TAPCELL_ROW_106_1667 VSS VDD sky130_fd_sc_hd__tapvpwrvgnd_1
XTAP_TAPCELL_ROW_106_1668 VSS VDD sky130_fd_sc_hd__tapvpwrvgnd_1
XTAP_TAPCELL_ROW_106_1669 VSS VDD sky130_fd_sc_hd__tapvpwrvgnd_1
XTAP_TAPCELL_ROW_106_1670 VSS VDD sky130_fd_sc_hd__tapvpwrvgnd_1
XTAP_TAPCELL_ROW_106_1671 VSS VDD sky130_fd_sc_hd__tapvpwrvgnd_1
XTAP_TAPCELL_ROW_106_1672 VSS VDD sky130_fd_sc_hd__tapvpwrvgnd_1
XTAP_TAPCELL_ROW_106_1673 VSS VDD sky130_fd_sc_hd__tapvpwrvgnd_1
XTAP_TAPCELL_ROW_107_1674 VSS VDD sky130_fd_sc_hd__tapvpwrvgnd_1
XTAP_TAPCELL_ROW_107_1675 VSS VDD sky130_fd_sc_hd__tapvpwrvgnd_1
XTAP_TAPCELL_ROW_107_1676 VSS VDD sky130_fd_sc_hd__tapvpwrvgnd_1
XTAP_TAPCELL_ROW_107_1677 VSS VDD sky130_fd_sc_hd__tapvpwrvgnd_1
XTAP_TAPCELL_ROW_107_1678 VSS VDD sky130_fd_sc_hd__tapvpwrvgnd_1
XTAP_TAPCELL_ROW_107_1679 VSS VDD sky130_fd_sc_hd__tapvpwrvgnd_1
XTAP_TAPCELL_ROW_107_1680 VSS VDD sky130_fd_sc_hd__tapvpwrvgnd_1
XTAP_TAPCELL_ROW_107_1681 VSS VDD sky130_fd_sc_hd__tapvpwrvgnd_1
XTAP_TAPCELL_ROW_107_1682 VSS VDD sky130_fd_sc_hd__tapvpwrvgnd_1
XTAP_TAPCELL_ROW_107_1683 VSS VDD sky130_fd_sc_hd__tapvpwrvgnd_1
XTAP_TAPCELL_ROW_107_1684 VSS VDD sky130_fd_sc_hd__tapvpwrvgnd_1
XTAP_TAPCELL_ROW_107_1685 VSS VDD sky130_fd_sc_hd__tapvpwrvgnd_1
XTAP_TAPCELL_ROW_107_1686 VSS VDD sky130_fd_sc_hd__tapvpwrvgnd_1
XTAP_TAPCELL_ROW_107_1687 VSS VDD sky130_fd_sc_hd__tapvpwrvgnd_1
XTAP_TAPCELL_ROW_107_1688 VSS VDD sky130_fd_sc_hd__tapvpwrvgnd_1
XTAP_TAPCELL_ROW_108_1689 VSS VDD sky130_fd_sc_hd__tapvpwrvgnd_1
XTAP_TAPCELL_ROW_108_1690 VSS VDD sky130_fd_sc_hd__tapvpwrvgnd_1
XTAP_TAPCELL_ROW_108_1691 VSS VDD sky130_fd_sc_hd__tapvpwrvgnd_1
XTAP_TAPCELL_ROW_108_1692 VSS VDD sky130_fd_sc_hd__tapvpwrvgnd_1
XTAP_TAPCELL_ROW_108_1693 VSS VDD sky130_fd_sc_hd__tapvpwrvgnd_1
XTAP_TAPCELL_ROW_108_1694 VSS VDD sky130_fd_sc_hd__tapvpwrvgnd_1
XTAP_TAPCELL_ROW_108_1695 VSS VDD sky130_fd_sc_hd__tapvpwrvgnd_1
XTAP_TAPCELL_ROW_108_1696 VSS VDD sky130_fd_sc_hd__tapvpwrvgnd_1
XTAP_TAPCELL_ROW_108_1697 VSS VDD sky130_fd_sc_hd__tapvpwrvgnd_1
XTAP_TAPCELL_ROW_108_1698 VSS VDD sky130_fd_sc_hd__tapvpwrvgnd_1
XTAP_TAPCELL_ROW_108_1699 VSS VDD sky130_fd_sc_hd__tapvpwrvgnd_1
XTAP_TAPCELL_ROW_108_1700 VSS VDD sky130_fd_sc_hd__tapvpwrvgnd_1
XTAP_TAPCELL_ROW_108_1701 VSS VDD sky130_fd_sc_hd__tapvpwrvgnd_1
XTAP_TAPCELL_ROW_108_1702 VSS VDD sky130_fd_sc_hd__tapvpwrvgnd_1
XTAP_TAPCELL_ROW_108_1703 VSS VDD sky130_fd_sc_hd__tapvpwrvgnd_1
XTAP_TAPCELL_ROW_108_1704 VSS VDD sky130_fd_sc_hd__tapvpwrvgnd_1
XTAP_TAPCELL_ROW_109_1705 VSS VDD sky130_fd_sc_hd__tapvpwrvgnd_1
XTAP_TAPCELL_ROW_109_1706 VSS VDD sky130_fd_sc_hd__tapvpwrvgnd_1
XTAP_TAPCELL_ROW_109_1707 VSS VDD sky130_fd_sc_hd__tapvpwrvgnd_1
XTAP_TAPCELL_ROW_109_1708 VSS VDD sky130_fd_sc_hd__tapvpwrvgnd_1
XTAP_TAPCELL_ROW_109_1709 VSS VDD sky130_fd_sc_hd__tapvpwrvgnd_1
XTAP_TAPCELL_ROW_109_1710 VSS VDD sky130_fd_sc_hd__tapvpwrvgnd_1
XTAP_TAPCELL_ROW_109_1711 VSS VDD sky130_fd_sc_hd__tapvpwrvgnd_1
XTAP_TAPCELL_ROW_109_1712 VSS VDD sky130_fd_sc_hd__tapvpwrvgnd_1
XTAP_TAPCELL_ROW_109_1713 VSS VDD sky130_fd_sc_hd__tapvpwrvgnd_1
XTAP_TAPCELL_ROW_109_1714 VSS VDD sky130_fd_sc_hd__tapvpwrvgnd_1
XTAP_TAPCELL_ROW_109_1715 VSS VDD sky130_fd_sc_hd__tapvpwrvgnd_1
XTAP_TAPCELL_ROW_109_1716 VSS VDD sky130_fd_sc_hd__tapvpwrvgnd_1
XTAP_TAPCELL_ROW_109_1717 VSS VDD sky130_fd_sc_hd__tapvpwrvgnd_1
XTAP_TAPCELL_ROW_109_1718 VSS VDD sky130_fd_sc_hd__tapvpwrvgnd_1
XTAP_TAPCELL_ROW_109_1719 VSS VDD sky130_fd_sc_hd__tapvpwrvgnd_1
XTAP_TAPCELL_ROW_110_1720 VSS VDD sky130_fd_sc_hd__tapvpwrvgnd_1
XTAP_TAPCELL_ROW_110_1721 VSS VDD sky130_fd_sc_hd__tapvpwrvgnd_1
XTAP_TAPCELL_ROW_110_1722 VSS VDD sky130_fd_sc_hd__tapvpwrvgnd_1
XTAP_TAPCELL_ROW_110_1723 VSS VDD sky130_fd_sc_hd__tapvpwrvgnd_1
XTAP_TAPCELL_ROW_110_1724 VSS VDD sky130_fd_sc_hd__tapvpwrvgnd_1
XTAP_TAPCELL_ROW_110_1725 VSS VDD sky130_fd_sc_hd__tapvpwrvgnd_1
XTAP_TAPCELL_ROW_110_1726 VSS VDD sky130_fd_sc_hd__tapvpwrvgnd_1
XTAP_TAPCELL_ROW_110_1727 VSS VDD sky130_fd_sc_hd__tapvpwrvgnd_1
XTAP_TAPCELL_ROW_110_1728 VSS VDD sky130_fd_sc_hd__tapvpwrvgnd_1
XTAP_TAPCELL_ROW_110_1729 VSS VDD sky130_fd_sc_hd__tapvpwrvgnd_1
XTAP_TAPCELL_ROW_110_1730 VSS VDD sky130_fd_sc_hd__tapvpwrvgnd_1
XTAP_TAPCELL_ROW_110_1731 VSS VDD sky130_fd_sc_hd__tapvpwrvgnd_1
XTAP_TAPCELL_ROW_110_1732 VSS VDD sky130_fd_sc_hd__tapvpwrvgnd_1
XTAP_TAPCELL_ROW_110_1733 VSS VDD sky130_fd_sc_hd__tapvpwrvgnd_1
XTAP_TAPCELL_ROW_110_1734 VSS VDD sky130_fd_sc_hd__tapvpwrvgnd_1
XTAP_TAPCELL_ROW_110_1735 VSS VDD sky130_fd_sc_hd__tapvpwrvgnd_1
XTAP_TAPCELL_ROW_111_1736 VSS VDD sky130_fd_sc_hd__tapvpwrvgnd_1
XTAP_TAPCELL_ROW_111_1737 VSS VDD sky130_fd_sc_hd__tapvpwrvgnd_1
XTAP_TAPCELL_ROW_111_1738 VSS VDD sky130_fd_sc_hd__tapvpwrvgnd_1
XTAP_TAPCELL_ROW_111_1739 VSS VDD sky130_fd_sc_hd__tapvpwrvgnd_1
XTAP_TAPCELL_ROW_111_1740 VSS VDD sky130_fd_sc_hd__tapvpwrvgnd_1
XTAP_TAPCELL_ROW_111_1741 VSS VDD sky130_fd_sc_hd__tapvpwrvgnd_1
XTAP_TAPCELL_ROW_111_1742 VSS VDD sky130_fd_sc_hd__tapvpwrvgnd_1
XTAP_TAPCELL_ROW_111_1743 VSS VDD sky130_fd_sc_hd__tapvpwrvgnd_1
XTAP_TAPCELL_ROW_111_1744 VSS VDD sky130_fd_sc_hd__tapvpwrvgnd_1
XTAP_TAPCELL_ROW_111_1745 VSS VDD sky130_fd_sc_hd__tapvpwrvgnd_1
XTAP_TAPCELL_ROW_111_1746 VSS VDD sky130_fd_sc_hd__tapvpwrvgnd_1
XTAP_TAPCELL_ROW_111_1747 VSS VDD sky130_fd_sc_hd__tapvpwrvgnd_1
XTAP_TAPCELL_ROW_111_1748 VSS VDD sky130_fd_sc_hd__tapvpwrvgnd_1
XTAP_TAPCELL_ROW_111_1749 VSS VDD sky130_fd_sc_hd__tapvpwrvgnd_1
XTAP_TAPCELL_ROW_111_1750 VSS VDD sky130_fd_sc_hd__tapvpwrvgnd_1
XTAP_TAPCELL_ROW_112_1751 VSS VDD sky130_fd_sc_hd__tapvpwrvgnd_1
XTAP_TAPCELL_ROW_112_1752 VSS VDD sky130_fd_sc_hd__tapvpwrvgnd_1
XTAP_TAPCELL_ROW_112_1753 VSS VDD sky130_fd_sc_hd__tapvpwrvgnd_1
XTAP_TAPCELL_ROW_112_1754 VSS VDD sky130_fd_sc_hd__tapvpwrvgnd_1
XTAP_TAPCELL_ROW_112_1755 VSS VDD sky130_fd_sc_hd__tapvpwrvgnd_1
XTAP_TAPCELL_ROW_112_1756 VSS VDD sky130_fd_sc_hd__tapvpwrvgnd_1
XTAP_TAPCELL_ROW_112_1757 VSS VDD sky130_fd_sc_hd__tapvpwrvgnd_1
XTAP_TAPCELL_ROW_112_1758 VSS VDD sky130_fd_sc_hd__tapvpwrvgnd_1
XTAP_TAPCELL_ROW_112_1759 VSS VDD sky130_fd_sc_hd__tapvpwrvgnd_1
XTAP_TAPCELL_ROW_112_1760 VSS VDD sky130_fd_sc_hd__tapvpwrvgnd_1
XTAP_TAPCELL_ROW_112_1761 VSS VDD sky130_fd_sc_hd__tapvpwrvgnd_1
XTAP_TAPCELL_ROW_112_1762 VSS VDD sky130_fd_sc_hd__tapvpwrvgnd_1
XTAP_TAPCELL_ROW_112_1763 VSS VDD sky130_fd_sc_hd__tapvpwrvgnd_1
XTAP_TAPCELL_ROW_112_1764 VSS VDD sky130_fd_sc_hd__tapvpwrvgnd_1
XTAP_TAPCELL_ROW_112_1765 VSS VDD sky130_fd_sc_hd__tapvpwrvgnd_1
XTAP_TAPCELL_ROW_112_1766 VSS VDD sky130_fd_sc_hd__tapvpwrvgnd_1
XTAP_TAPCELL_ROW_113_1767 VSS VDD sky130_fd_sc_hd__tapvpwrvgnd_1
XTAP_TAPCELL_ROW_113_1768 VSS VDD sky130_fd_sc_hd__tapvpwrvgnd_1
XTAP_TAPCELL_ROW_113_1769 VSS VDD sky130_fd_sc_hd__tapvpwrvgnd_1
XTAP_TAPCELL_ROW_113_1770 VSS VDD sky130_fd_sc_hd__tapvpwrvgnd_1
XTAP_TAPCELL_ROW_113_1771 VSS VDD sky130_fd_sc_hd__tapvpwrvgnd_1
XTAP_TAPCELL_ROW_113_1772 VSS VDD sky130_fd_sc_hd__tapvpwrvgnd_1
XTAP_TAPCELL_ROW_113_1773 VSS VDD sky130_fd_sc_hd__tapvpwrvgnd_1
XTAP_TAPCELL_ROW_113_1774 VSS VDD sky130_fd_sc_hd__tapvpwrvgnd_1
XTAP_TAPCELL_ROW_113_1775 VSS VDD sky130_fd_sc_hd__tapvpwrvgnd_1
XTAP_TAPCELL_ROW_113_1776 VSS VDD sky130_fd_sc_hd__tapvpwrvgnd_1
XTAP_TAPCELL_ROW_113_1777 VSS VDD sky130_fd_sc_hd__tapvpwrvgnd_1
XTAP_TAPCELL_ROW_113_1778 VSS VDD sky130_fd_sc_hd__tapvpwrvgnd_1
XTAP_TAPCELL_ROW_113_1779 VSS VDD sky130_fd_sc_hd__tapvpwrvgnd_1
XTAP_TAPCELL_ROW_113_1780 VSS VDD sky130_fd_sc_hd__tapvpwrvgnd_1
XTAP_TAPCELL_ROW_113_1781 VSS VDD sky130_fd_sc_hd__tapvpwrvgnd_1
XTAP_TAPCELL_ROW_114_1782 VSS VDD sky130_fd_sc_hd__tapvpwrvgnd_1
XTAP_TAPCELL_ROW_114_1783 VSS VDD sky130_fd_sc_hd__tapvpwrvgnd_1
XTAP_TAPCELL_ROW_114_1784 VSS VDD sky130_fd_sc_hd__tapvpwrvgnd_1
XTAP_TAPCELL_ROW_114_1785 VSS VDD sky130_fd_sc_hd__tapvpwrvgnd_1
XTAP_TAPCELL_ROW_114_1786 VSS VDD sky130_fd_sc_hd__tapvpwrvgnd_1
XTAP_TAPCELL_ROW_114_1787 VSS VDD sky130_fd_sc_hd__tapvpwrvgnd_1
XTAP_TAPCELL_ROW_114_1788 VSS VDD sky130_fd_sc_hd__tapvpwrvgnd_1
XTAP_TAPCELL_ROW_114_1789 VSS VDD sky130_fd_sc_hd__tapvpwrvgnd_1
XTAP_TAPCELL_ROW_114_1790 VSS VDD sky130_fd_sc_hd__tapvpwrvgnd_1
XTAP_TAPCELL_ROW_114_1791 VSS VDD sky130_fd_sc_hd__tapvpwrvgnd_1
XTAP_TAPCELL_ROW_114_1792 VSS VDD sky130_fd_sc_hd__tapvpwrvgnd_1
XTAP_TAPCELL_ROW_114_1793 VSS VDD sky130_fd_sc_hd__tapvpwrvgnd_1
XTAP_TAPCELL_ROW_114_1794 VSS VDD sky130_fd_sc_hd__tapvpwrvgnd_1
XTAP_TAPCELL_ROW_114_1795 VSS VDD sky130_fd_sc_hd__tapvpwrvgnd_1
XTAP_TAPCELL_ROW_114_1796 VSS VDD sky130_fd_sc_hd__tapvpwrvgnd_1
XTAP_TAPCELL_ROW_114_1797 VSS VDD sky130_fd_sc_hd__tapvpwrvgnd_1
XTAP_TAPCELL_ROW_115_1798 VSS VDD sky130_fd_sc_hd__tapvpwrvgnd_1
XTAP_TAPCELL_ROW_115_1799 VSS VDD sky130_fd_sc_hd__tapvpwrvgnd_1
XTAP_TAPCELL_ROW_115_1800 VSS VDD sky130_fd_sc_hd__tapvpwrvgnd_1
XTAP_TAPCELL_ROW_115_1801 VSS VDD sky130_fd_sc_hd__tapvpwrvgnd_1
XTAP_TAPCELL_ROW_115_1802 VSS VDD sky130_fd_sc_hd__tapvpwrvgnd_1
XTAP_TAPCELL_ROW_115_1803 VSS VDD sky130_fd_sc_hd__tapvpwrvgnd_1
XTAP_TAPCELL_ROW_115_1804 VSS VDD sky130_fd_sc_hd__tapvpwrvgnd_1
XTAP_TAPCELL_ROW_115_1805 VSS VDD sky130_fd_sc_hd__tapvpwrvgnd_1
XTAP_TAPCELL_ROW_115_1806 VSS VDD sky130_fd_sc_hd__tapvpwrvgnd_1
XTAP_TAPCELL_ROW_115_1807 VSS VDD sky130_fd_sc_hd__tapvpwrvgnd_1
XTAP_TAPCELL_ROW_115_1808 VSS VDD sky130_fd_sc_hd__tapvpwrvgnd_1
XTAP_TAPCELL_ROW_115_1809 VSS VDD sky130_fd_sc_hd__tapvpwrvgnd_1
XTAP_TAPCELL_ROW_115_1810 VSS VDD sky130_fd_sc_hd__tapvpwrvgnd_1
XTAP_TAPCELL_ROW_115_1811 VSS VDD sky130_fd_sc_hd__tapvpwrvgnd_1
XTAP_TAPCELL_ROW_115_1812 VSS VDD sky130_fd_sc_hd__tapvpwrvgnd_1
XTAP_TAPCELL_ROW_116_1813 VSS VDD sky130_fd_sc_hd__tapvpwrvgnd_1
XTAP_TAPCELL_ROW_116_1814 VSS VDD sky130_fd_sc_hd__tapvpwrvgnd_1
XTAP_TAPCELL_ROW_116_1815 VSS VDD sky130_fd_sc_hd__tapvpwrvgnd_1
XTAP_TAPCELL_ROW_116_1816 VSS VDD sky130_fd_sc_hd__tapvpwrvgnd_1
XTAP_TAPCELL_ROW_116_1817 VSS VDD sky130_fd_sc_hd__tapvpwrvgnd_1
XTAP_TAPCELL_ROW_116_1818 VSS VDD sky130_fd_sc_hd__tapvpwrvgnd_1
XTAP_TAPCELL_ROW_116_1819 VSS VDD sky130_fd_sc_hd__tapvpwrvgnd_1
XTAP_TAPCELL_ROW_116_1820 VSS VDD sky130_fd_sc_hd__tapvpwrvgnd_1
XTAP_TAPCELL_ROW_116_1821 VSS VDD sky130_fd_sc_hd__tapvpwrvgnd_1
XTAP_TAPCELL_ROW_116_1822 VSS VDD sky130_fd_sc_hd__tapvpwrvgnd_1
XTAP_TAPCELL_ROW_116_1823 VSS VDD sky130_fd_sc_hd__tapvpwrvgnd_1
XTAP_TAPCELL_ROW_116_1824 VSS VDD sky130_fd_sc_hd__tapvpwrvgnd_1
XTAP_TAPCELL_ROW_116_1825 VSS VDD sky130_fd_sc_hd__tapvpwrvgnd_1
XTAP_TAPCELL_ROW_116_1826 VSS VDD sky130_fd_sc_hd__tapvpwrvgnd_1
XTAP_TAPCELL_ROW_116_1827 VSS VDD sky130_fd_sc_hd__tapvpwrvgnd_1
XTAP_TAPCELL_ROW_116_1828 VSS VDD sky130_fd_sc_hd__tapvpwrvgnd_1
XTAP_TAPCELL_ROW_117_1829 VSS VDD sky130_fd_sc_hd__tapvpwrvgnd_1
XTAP_TAPCELL_ROW_117_1830 VSS VDD sky130_fd_sc_hd__tapvpwrvgnd_1
XTAP_TAPCELL_ROW_117_1831 VSS VDD sky130_fd_sc_hd__tapvpwrvgnd_1
XTAP_TAPCELL_ROW_117_1832 VSS VDD sky130_fd_sc_hd__tapvpwrvgnd_1
XTAP_TAPCELL_ROW_117_1833 VSS VDD sky130_fd_sc_hd__tapvpwrvgnd_1
XTAP_TAPCELL_ROW_117_1834 VSS VDD sky130_fd_sc_hd__tapvpwrvgnd_1
XTAP_TAPCELL_ROW_117_1835 VSS VDD sky130_fd_sc_hd__tapvpwrvgnd_1
XTAP_TAPCELL_ROW_117_1836 VSS VDD sky130_fd_sc_hd__tapvpwrvgnd_1
XTAP_TAPCELL_ROW_117_1837 VSS VDD sky130_fd_sc_hd__tapvpwrvgnd_1
XTAP_TAPCELL_ROW_117_1838 VSS VDD sky130_fd_sc_hd__tapvpwrvgnd_1
XTAP_TAPCELL_ROW_117_1839 VSS VDD sky130_fd_sc_hd__tapvpwrvgnd_1
XTAP_TAPCELL_ROW_117_1840 VSS VDD sky130_fd_sc_hd__tapvpwrvgnd_1
XTAP_TAPCELL_ROW_117_1841 VSS VDD sky130_fd_sc_hd__tapvpwrvgnd_1
XTAP_TAPCELL_ROW_117_1842 VSS VDD sky130_fd_sc_hd__tapvpwrvgnd_1
XTAP_TAPCELL_ROW_117_1843 VSS VDD sky130_fd_sc_hd__tapvpwrvgnd_1
XTAP_TAPCELL_ROW_118_1844 VSS VDD sky130_fd_sc_hd__tapvpwrvgnd_1
XTAP_TAPCELL_ROW_118_1845 VSS VDD sky130_fd_sc_hd__tapvpwrvgnd_1
XTAP_TAPCELL_ROW_118_1846 VSS VDD sky130_fd_sc_hd__tapvpwrvgnd_1
XTAP_TAPCELL_ROW_118_1847 VSS VDD sky130_fd_sc_hd__tapvpwrvgnd_1
XTAP_TAPCELL_ROW_118_1848 VSS VDD sky130_fd_sc_hd__tapvpwrvgnd_1
XTAP_TAPCELL_ROW_118_1849 VSS VDD sky130_fd_sc_hd__tapvpwrvgnd_1
XTAP_TAPCELL_ROW_118_1850 VSS VDD sky130_fd_sc_hd__tapvpwrvgnd_1
XTAP_TAPCELL_ROW_118_1851 VSS VDD sky130_fd_sc_hd__tapvpwrvgnd_1
XTAP_TAPCELL_ROW_118_1852 VSS VDD sky130_fd_sc_hd__tapvpwrvgnd_1
XTAP_TAPCELL_ROW_118_1853 VSS VDD sky130_fd_sc_hd__tapvpwrvgnd_1
XTAP_TAPCELL_ROW_118_1854 VSS VDD sky130_fd_sc_hd__tapvpwrvgnd_1
XTAP_TAPCELL_ROW_118_1855 VSS VDD sky130_fd_sc_hd__tapvpwrvgnd_1
XTAP_TAPCELL_ROW_118_1856 VSS VDD sky130_fd_sc_hd__tapvpwrvgnd_1
XTAP_TAPCELL_ROW_118_1857 VSS VDD sky130_fd_sc_hd__tapvpwrvgnd_1
XTAP_TAPCELL_ROW_118_1858 VSS VDD sky130_fd_sc_hd__tapvpwrvgnd_1
XTAP_TAPCELL_ROW_118_1859 VSS VDD sky130_fd_sc_hd__tapvpwrvgnd_1
XTAP_TAPCELL_ROW_119_1860 VSS VDD sky130_fd_sc_hd__tapvpwrvgnd_1
XTAP_TAPCELL_ROW_119_1861 VSS VDD sky130_fd_sc_hd__tapvpwrvgnd_1
XTAP_TAPCELL_ROW_119_1862 VSS VDD sky130_fd_sc_hd__tapvpwrvgnd_1
XTAP_TAPCELL_ROW_119_1863 VSS VDD sky130_fd_sc_hd__tapvpwrvgnd_1
XTAP_TAPCELL_ROW_119_1864 VSS VDD sky130_fd_sc_hd__tapvpwrvgnd_1
XTAP_TAPCELL_ROW_119_1865 VSS VDD sky130_fd_sc_hd__tapvpwrvgnd_1
XTAP_TAPCELL_ROW_119_1866 VSS VDD sky130_fd_sc_hd__tapvpwrvgnd_1
XTAP_TAPCELL_ROW_119_1867 VSS VDD sky130_fd_sc_hd__tapvpwrvgnd_1
XTAP_TAPCELL_ROW_119_1868 VSS VDD sky130_fd_sc_hd__tapvpwrvgnd_1
XTAP_TAPCELL_ROW_119_1869 VSS VDD sky130_fd_sc_hd__tapvpwrvgnd_1
XTAP_TAPCELL_ROW_119_1870 VSS VDD sky130_fd_sc_hd__tapvpwrvgnd_1
XTAP_TAPCELL_ROW_119_1871 VSS VDD sky130_fd_sc_hd__tapvpwrvgnd_1
XTAP_TAPCELL_ROW_119_1872 VSS VDD sky130_fd_sc_hd__tapvpwrvgnd_1
XTAP_TAPCELL_ROW_119_1873 VSS VDD sky130_fd_sc_hd__tapvpwrvgnd_1
XTAP_TAPCELL_ROW_119_1874 VSS VDD sky130_fd_sc_hd__tapvpwrvgnd_1
XTAP_TAPCELL_ROW_120_1875 VSS VDD sky130_fd_sc_hd__tapvpwrvgnd_1
XTAP_TAPCELL_ROW_120_1876 VSS VDD sky130_fd_sc_hd__tapvpwrvgnd_1
XTAP_TAPCELL_ROW_120_1877 VSS VDD sky130_fd_sc_hd__tapvpwrvgnd_1
XTAP_TAPCELL_ROW_120_1878 VSS VDD sky130_fd_sc_hd__tapvpwrvgnd_1
XTAP_TAPCELL_ROW_120_1879 VSS VDD sky130_fd_sc_hd__tapvpwrvgnd_1
XTAP_TAPCELL_ROW_120_1880 VSS VDD sky130_fd_sc_hd__tapvpwrvgnd_1
XTAP_TAPCELL_ROW_120_1881 VSS VDD sky130_fd_sc_hd__tapvpwrvgnd_1
XTAP_TAPCELL_ROW_120_1882 VSS VDD sky130_fd_sc_hd__tapvpwrvgnd_1
XTAP_TAPCELL_ROW_120_1883 VSS VDD sky130_fd_sc_hd__tapvpwrvgnd_1
XTAP_TAPCELL_ROW_120_1884 VSS VDD sky130_fd_sc_hd__tapvpwrvgnd_1
XTAP_TAPCELL_ROW_120_1885 VSS VDD sky130_fd_sc_hd__tapvpwrvgnd_1
XTAP_TAPCELL_ROW_120_1886 VSS VDD sky130_fd_sc_hd__tapvpwrvgnd_1
XTAP_TAPCELL_ROW_120_1887 VSS VDD sky130_fd_sc_hd__tapvpwrvgnd_1
XTAP_TAPCELL_ROW_120_1888 VSS VDD sky130_fd_sc_hd__tapvpwrvgnd_1
XTAP_TAPCELL_ROW_120_1889 VSS VDD sky130_fd_sc_hd__tapvpwrvgnd_1
XTAP_TAPCELL_ROW_120_1890 VSS VDD sky130_fd_sc_hd__tapvpwrvgnd_1
XTAP_TAPCELL_ROW_121_1891 VSS VDD sky130_fd_sc_hd__tapvpwrvgnd_1
XTAP_TAPCELL_ROW_121_1892 VSS VDD sky130_fd_sc_hd__tapvpwrvgnd_1
XTAP_TAPCELL_ROW_121_1893 VSS VDD sky130_fd_sc_hd__tapvpwrvgnd_1
XTAP_TAPCELL_ROW_121_1894 VSS VDD sky130_fd_sc_hd__tapvpwrvgnd_1
XTAP_TAPCELL_ROW_121_1895 VSS VDD sky130_fd_sc_hd__tapvpwrvgnd_1
XTAP_TAPCELL_ROW_121_1896 VSS VDD sky130_fd_sc_hd__tapvpwrvgnd_1
XTAP_TAPCELL_ROW_121_1897 VSS VDD sky130_fd_sc_hd__tapvpwrvgnd_1
XTAP_TAPCELL_ROW_121_1898 VSS VDD sky130_fd_sc_hd__tapvpwrvgnd_1
XTAP_TAPCELL_ROW_121_1899 VSS VDD sky130_fd_sc_hd__tapvpwrvgnd_1
XTAP_TAPCELL_ROW_121_1900 VSS VDD sky130_fd_sc_hd__tapvpwrvgnd_1
XTAP_TAPCELL_ROW_121_1901 VSS VDD sky130_fd_sc_hd__tapvpwrvgnd_1
XTAP_TAPCELL_ROW_121_1902 VSS VDD sky130_fd_sc_hd__tapvpwrvgnd_1
XTAP_TAPCELL_ROW_121_1903 VSS VDD sky130_fd_sc_hd__tapvpwrvgnd_1
XTAP_TAPCELL_ROW_121_1904 VSS VDD sky130_fd_sc_hd__tapvpwrvgnd_1
XTAP_TAPCELL_ROW_121_1905 VSS VDD sky130_fd_sc_hd__tapvpwrvgnd_1
XTAP_TAPCELL_ROW_122_1906 VSS VDD sky130_fd_sc_hd__tapvpwrvgnd_1
XTAP_TAPCELL_ROW_122_1907 VSS VDD sky130_fd_sc_hd__tapvpwrvgnd_1
XTAP_TAPCELL_ROW_122_1908 VSS VDD sky130_fd_sc_hd__tapvpwrvgnd_1
XTAP_TAPCELL_ROW_122_1909 VSS VDD sky130_fd_sc_hd__tapvpwrvgnd_1
XTAP_TAPCELL_ROW_122_1910 VSS VDD sky130_fd_sc_hd__tapvpwrvgnd_1
XTAP_TAPCELL_ROW_122_1911 VSS VDD sky130_fd_sc_hd__tapvpwrvgnd_1
XTAP_TAPCELL_ROW_122_1912 VSS VDD sky130_fd_sc_hd__tapvpwrvgnd_1
XTAP_TAPCELL_ROW_122_1913 VSS VDD sky130_fd_sc_hd__tapvpwrvgnd_1
XTAP_TAPCELL_ROW_122_1914 VSS VDD sky130_fd_sc_hd__tapvpwrvgnd_1
XTAP_TAPCELL_ROW_122_1915 VSS VDD sky130_fd_sc_hd__tapvpwrvgnd_1
XTAP_TAPCELL_ROW_122_1916 VSS VDD sky130_fd_sc_hd__tapvpwrvgnd_1
XTAP_TAPCELL_ROW_122_1917 VSS VDD sky130_fd_sc_hd__tapvpwrvgnd_1
XTAP_TAPCELL_ROW_122_1918 VSS VDD sky130_fd_sc_hd__tapvpwrvgnd_1
XTAP_TAPCELL_ROW_122_1919 VSS VDD sky130_fd_sc_hd__tapvpwrvgnd_1
XTAP_TAPCELL_ROW_122_1920 VSS VDD sky130_fd_sc_hd__tapvpwrvgnd_1
XTAP_TAPCELL_ROW_122_1921 VSS VDD sky130_fd_sc_hd__tapvpwrvgnd_1
XTAP_TAPCELL_ROW_123_1922 VSS VDD sky130_fd_sc_hd__tapvpwrvgnd_1
XTAP_TAPCELL_ROW_123_1923 VSS VDD sky130_fd_sc_hd__tapvpwrvgnd_1
XTAP_TAPCELL_ROW_123_1924 VSS VDD sky130_fd_sc_hd__tapvpwrvgnd_1
XTAP_TAPCELL_ROW_123_1925 VSS VDD sky130_fd_sc_hd__tapvpwrvgnd_1
XTAP_TAPCELL_ROW_123_1926 VSS VDD sky130_fd_sc_hd__tapvpwrvgnd_1
XTAP_TAPCELL_ROW_123_1927 VSS VDD sky130_fd_sc_hd__tapvpwrvgnd_1
XTAP_TAPCELL_ROW_123_1928 VSS VDD sky130_fd_sc_hd__tapvpwrvgnd_1
XTAP_TAPCELL_ROW_123_1929 VSS VDD sky130_fd_sc_hd__tapvpwrvgnd_1
XTAP_TAPCELL_ROW_123_1930 VSS VDD sky130_fd_sc_hd__tapvpwrvgnd_1
XTAP_TAPCELL_ROW_123_1931 VSS VDD sky130_fd_sc_hd__tapvpwrvgnd_1
XTAP_TAPCELL_ROW_123_1932 VSS VDD sky130_fd_sc_hd__tapvpwrvgnd_1
XTAP_TAPCELL_ROW_123_1933 VSS VDD sky130_fd_sc_hd__tapvpwrvgnd_1
XTAP_TAPCELL_ROW_123_1934 VSS VDD sky130_fd_sc_hd__tapvpwrvgnd_1
XTAP_TAPCELL_ROW_123_1935 VSS VDD sky130_fd_sc_hd__tapvpwrvgnd_1
XTAP_TAPCELL_ROW_123_1936 VSS VDD sky130_fd_sc_hd__tapvpwrvgnd_1
XTAP_TAPCELL_ROW_124_1937 VSS VDD sky130_fd_sc_hd__tapvpwrvgnd_1
XTAP_TAPCELL_ROW_124_1938 VSS VDD sky130_fd_sc_hd__tapvpwrvgnd_1
XTAP_TAPCELL_ROW_124_1939 VSS VDD sky130_fd_sc_hd__tapvpwrvgnd_1
XTAP_TAPCELL_ROW_124_1940 VSS VDD sky130_fd_sc_hd__tapvpwrvgnd_1
XTAP_TAPCELL_ROW_124_1941 VSS VDD sky130_fd_sc_hd__tapvpwrvgnd_1
XTAP_TAPCELL_ROW_124_1942 VSS VDD sky130_fd_sc_hd__tapvpwrvgnd_1
XTAP_TAPCELL_ROW_124_1943 VSS VDD sky130_fd_sc_hd__tapvpwrvgnd_1
XTAP_TAPCELL_ROW_124_1944 VSS VDD sky130_fd_sc_hd__tapvpwrvgnd_1
XTAP_TAPCELL_ROW_124_1945 VSS VDD sky130_fd_sc_hd__tapvpwrvgnd_1
XTAP_TAPCELL_ROW_124_1946 VSS VDD sky130_fd_sc_hd__tapvpwrvgnd_1
XTAP_TAPCELL_ROW_124_1947 VSS VDD sky130_fd_sc_hd__tapvpwrvgnd_1
XTAP_TAPCELL_ROW_124_1948 VSS VDD sky130_fd_sc_hd__tapvpwrvgnd_1
XTAP_TAPCELL_ROW_124_1949 VSS VDD sky130_fd_sc_hd__tapvpwrvgnd_1
XTAP_TAPCELL_ROW_124_1950 VSS VDD sky130_fd_sc_hd__tapvpwrvgnd_1
XTAP_TAPCELL_ROW_124_1951 VSS VDD sky130_fd_sc_hd__tapvpwrvgnd_1
XTAP_TAPCELL_ROW_124_1952 VSS VDD sky130_fd_sc_hd__tapvpwrvgnd_1
XTAP_TAPCELL_ROW_125_1953 VSS VDD sky130_fd_sc_hd__tapvpwrvgnd_1
XTAP_TAPCELL_ROW_125_1954 VSS VDD sky130_fd_sc_hd__tapvpwrvgnd_1
XTAP_TAPCELL_ROW_125_1955 VSS VDD sky130_fd_sc_hd__tapvpwrvgnd_1
XTAP_TAPCELL_ROW_125_1956 VSS VDD sky130_fd_sc_hd__tapvpwrvgnd_1
XTAP_TAPCELL_ROW_125_1957 VSS VDD sky130_fd_sc_hd__tapvpwrvgnd_1
XTAP_TAPCELL_ROW_125_1958 VSS VDD sky130_fd_sc_hd__tapvpwrvgnd_1
XTAP_TAPCELL_ROW_125_1959 VSS VDD sky130_fd_sc_hd__tapvpwrvgnd_1
XTAP_TAPCELL_ROW_125_1960 VSS VDD sky130_fd_sc_hd__tapvpwrvgnd_1
XTAP_TAPCELL_ROW_125_1961 VSS VDD sky130_fd_sc_hd__tapvpwrvgnd_1
XTAP_TAPCELL_ROW_125_1962 VSS VDD sky130_fd_sc_hd__tapvpwrvgnd_1
XTAP_TAPCELL_ROW_125_1963 VSS VDD sky130_fd_sc_hd__tapvpwrvgnd_1
XTAP_TAPCELL_ROW_125_1964 VSS VDD sky130_fd_sc_hd__tapvpwrvgnd_1
XTAP_TAPCELL_ROW_125_1965 VSS VDD sky130_fd_sc_hd__tapvpwrvgnd_1
XTAP_TAPCELL_ROW_125_1966 VSS VDD sky130_fd_sc_hd__tapvpwrvgnd_1
XTAP_TAPCELL_ROW_125_1967 VSS VDD sky130_fd_sc_hd__tapvpwrvgnd_1
XTAP_TAPCELL_ROW_126_1968 VSS VDD sky130_fd_sc_hd__tapvpwrvgnd_1
XTAP_TAPCELL_ROW_126_1969 VSS VDD sky130_fd_sc_hd__tapvpwrvgnd_1
XTAP_TAPCELL_ROW_126_1970 VSS VDD sky130_fd_sc_hd__tapvpwrvgnd_1
XTAP_TAPCELL_ROW_126_1971 VSS VDD sky130_fd_sc_hd__tapvpwrvgnd_1
XTAP_TAPCELL_ROW_126_1972 VSS VDD sky130_fd_sc_hd__tapvpwrvgnd_1
XTAP_TAPCELL_ROW_126_1973 VSS VDD sky130_fd_sc_hd__tapvpwrvgnd_1
XTAP_TAPCELL_ROW_126_1974 VSS VDD sky130_fd_sc_hd__tapvpwrvgnd_1
XTAP_TAPCELL_ROW_126_1975 VSS VDD sky130_fd_sc_hd__tapvpwrvgnd_1
XTAP_TAPCELL_ROW_126_1976 VSS VDD sky130_fd_sc_hd__tapvpwrvgnd_1
XTAP_TAPCELL_ROW_126_1977 VSS VDD sky130_fd_sc_hd__tapvpwrvgnd_1
XTAP_TAPCELL_ROW_126_1978 VSS VDD sky130_fd_sc_hd__tapvpwrvgnd_1
XTAP_TAPCELL_ROW_126_1979 VSS VDD sky130_fd_sc_hd__tapvpwrvgnd_1
XTAP_TAPCELL_ROW_126_1980 VSS VDD sky130_fd_sc_hd__tapvpwrvgnd_1
XTAP_TAPCELL_ROW_126_1981 VSS VDD sky130_fd_sc_hd__tapvpwrvgnd_1
XTAP_TAPCELL_ROW_126_1982 VSS VDD sky130_fd_sc_hd__tapvpwrvgnd_1
XTAP_TAPCELL_ROW_126_1983 VSS VDD sky130_fd_sc_hd__tapvpwrvgnd_1
XTAP_TAPCELL_ROW_127_1984 VSS VDD sky130_fd_sc_hd__tapvpwrvgnd_1
XTAP_TAPCELL_ROW_127_1985 VSS VDD sky130_fd_sc_hd__tapvpwrvgnd_1
XTAP_TAPCELL_ROW_127_1986 VSS VDD sky130_fd_sc_hd__tapvpwrvgnd_1
XTAP_TAPCELL_ROW_127_1987 VSS VDD sky130_fd_sc_hd__tapvpwrvgnd_1
XTAP_TAPCELL_ROW_127_1988 VSS VDD sky130_fd_sc_hd__tapvpwrvgnd_1
XTAP_TAPCELL_ROW_127_1989 VSS VDD sky130_fd_sc_hd__tapvpwrvgnd_1
XTAP_TAPCELL_ROW_127_1990 VSS VDD sky130_fd_sc_hd__tapvpwrvgnd_1
XTAP_TAPCELL_ROW_127_1991 VSS VDD sky130_fd_sc_hd__tapvpwrvgnd_1
XTAP_TAPCELL_ROW_127_1992 VSS VDD sky130_fd_sc_hd__tapvpwrvgnd_1
XTAP_TAPCELL_ROW_127_1993 VSS VDD sky130_fd_sc_hd__tapvpwrvgnd_1
XTAP_TAPCELL_ROW_127_1994 VSS VDD sky130_fd_sc_hd__tapvpwrvgnd_1
XTAP_TAPCELL_ROW_127_1995 VSS VDD sky130_fd_sc_hd__tapvpwrvgnd_1
XTAP_TAPCELL_ROW_127_1996 VSS VDD sky130_fd_sc_hd__tapvpwrvgnd_1
XTAP_TAPCELL_ROW_127_1997 VSS VDD sky130_fd_sc_hd__tapvpwrvgnd_1
XTAP_TAPCELL_ROW_127_1998 VSS VDD sky130_fd_sc_hd__tapvpwrvgnd_1
XTAP_TAPCELL_ROW_128_1999 VSS VDD sky130_fd_sc_hd__tapvpwrvgnd_1
XTAP_TAPCELL_ROW_128_2000 VSS VDD sky130_fd_sc_hd__tapvpwrvgnd_1
XTAP_TAPCELL_ROW_128_2001 VSS VDD sky130_fd_sc_hd__tapvpwrvgnd_1
XTAP_TAPCELL_ROW_128_2002 VSS VDD sky130_fd_sc_hd__tapvpwrvgnd_1
XTAP_TAPCELL_ROW_128_2003 VSS VDD sky130_fd_sc_hd__tapvpwrvgnd_1
XTAP_TAPCELL_ROW_128_2004 VSS VDD sky130_fd_sc_hd__tapvpwrvgnd_1
XTAP_TAPCELL_ROW_128_2005 VSS VDD sky130_fd_sc_hd__tapvpwrvgnd_1
XTAP_TAPCELL_ROW_128_2006 VSS VDD sky130_fd_sc_hd__tapvpwrvgnd_1
XTAP_TAPCELL_ROW_128_2007 VSS VDD sky130_fd_sc_hd__tapvpwrvgnd_1
XTAP_TAPCELL_ROW_128_2008 VSS VDD sky130_fd_sc_hd__tapvpwrvgnd_1
XTAP_TAPCELL_ROW_128_2009 VSS VDD sky130_fd_sc_hd__tapvpwrvgnd_1
XTAP_TAPCELL_ROW_128_2010 VSS VDD sky130_fd_sc_hd__tapvpwrvgnd_1
XTAP_TAPCELL_ROW_128_2011 VSS VDD sky130_fd_sc_hd__tapvpwrvgnd_1
XTAP_TAPCELL_ROW_128_2012 VSS VDD sky130_fd_sc_hd__tapvpwrvgnd_1
XTAP_TAPCELL_ROW_128_2013 VSS VDD sky130_fd_sc_hd__tapvpwrvgnd_1
XTAP_TAPCELL_ROW_128_2014 VSS VDD sky130_fd_sc_hd__tapvpwrvgnd_1
XTAP_TAPCELL_ROW_129_2015 VSS VDD sky130_fd_sc_hd__tapvpwrvgnd_1
XTAP_TAPCELL_ROW_129_2016 VSS VDD sky130_fd_sc_hd__tapvpwrvgnd_1
XTAP_TAPCELL_ROW_129_2017 VSS VDD sky130_fd_sc_hd__tapvpwrvgnd_1
XTAP_TAPCELL_ROW_129_2018 VSS VDD sky130_fd_sc_hd__tapvpwrvgnd_1
XTAP_TAPCELL_ROW_129_2019 VSS VDD sky130_fd_sc_hd__tapvpwrvgnd_1
XTAP_TAPCELL_ROW_129_2020 VSS VDD sky130_fd_sc_hd__tapvpwrvgnd_1
XTAP_TAPCELL_ROW_129_2021 VSS VDD sky130_fd_sc_hd__tapvpwrvgnd_1
XTAP_TAPCELL_ROW_129_2022 VSS VDD sky130_fd_sc_hd__tapvpwrvgnd_1
XTAP_TAPCELL_ROW_129_2023 VSS VDD sky130_fd_sc_hd__tapvpwrvgnd_1
XTAP_TAPCELL_ROW_129_2024 VSS VDD sky130_fd_sc_hd__tapvpwrvgnd_1
XTAP_TAPCELL_ROW_129_2025 VSS VDD sky130_fd_sc_hd__tapvpwrvgnd_1
XTAP_TAPCELL_ROW_129_2026 VSS VDD sky130_fd_sc_hd__tapvpwrvgnd_1
XTAP_TAPCELL_ROW_129_2027 VSS VDD sky130_fd_sc_hd__tapvpwrvgnd_1
XTAP_TAPCELL_ROW_129_2028 VSS VDD sky130_fd_sc_hd__tapvpwrvgnd_1
XTAP_TAPCELL_ROW_129_2029 VSS VDD sky130_fd_sc_hd__tapvpwrvgnd_1
XTAP_TAPCELL_ROW_130_2030 VSS VDD sky130_fd_sc_hd__tapvpwrvgnd_1
XTAP_TAPCELL_ROW_130_2031 VSS VDD sky130_fd_sc_hd__tapvpwrvgnd_1
XTAP_TAPCELL_ROW_130_2032 VSS VDD sky130_fd_sc_hd__tapvpwrvgnd_1
XTAP_TAPCELL_ROW_130_2033 VSS VDD sky130_fd_sc_hd__tapvpwrvgnd_1
XTAP_TAPCELL_ROW_130_2034 VSS VDD sky130_fd_sc_hd__tapvpwrvgnd_1
XTAP_TAPCELL_ROW_130_2035 VSS VDD sky130_fd_sc_hd__tapvpwrvgnd_1
XTAP_TAPCELL_ROW_130_2036 VSS VDD sky130_fd_sc_hd__tapvpwrvgnd_1
XTAP_TAPCELL_ROW_130_2037 VSS VDD sky130_fd_sc_hd__tapvpwrvgnd_1
XTAP_TAPCELL_ROW_130_2038 VSS VDD sky130_fd_sc_hd__tapvpwrvgnd_1
XTAP_TAPCELL_ROW_130_2039 VSS VDD sky130_fd_sc_hd__tapvpwrvgnd_1
XTAP_TAPCELL_ROW_130_2040 VSS VDD sky130_fd_sc_hd__tapvpwrvgnd_1
XTAP_TAPCELL_ROW_130_2041 VSS VDD sky130_fd_sc_hd__tapvpwrvgnd_1
XTAP_TAPCELL_ROW_130_2042 VSS VDD sky130_fd_sc_hd__tapvpwrvgnd_1
XTAP_TAPCELL_ROW_130_2043 VSS VDD sky130_fd_sc_hd__tapvpwrvgnd_1
XTAP_TAPCELL_ROW_130_2044 VSS VDD sky130_fd_sc_hd__tapvpwrvgnd_1
XTAP_TAPCELL_ROW_130_2045 VSS VDD sky130_fd_sc_hd__tapvpwrvgnd_1
XTAP_TAPCELL_ROW_131_2046 VSS VDD sky130_fd_sc_hd__tapvpwrvgnd_1
XTAP_TAPCELL_ROW_131_2047 VSS VDD sky130_fd_sc_hd__tapvpwrvgnd_1
XTAP_TAPCELL_ROW_131_2048 VSS VDD sky130_fd_sc_hd__tapvpwrvgnd_1
XTAP_TAPCELL_ROW_131_2049 VSS VDD sky130_fd_sc_hd__tapvpwrvgnd_1
XTAP_TAPCELL_ROW_131_2050 VSS VDD sky130_fd_sc_hd__tapvpwrvgnd_1
XTAP_TAPCELL_ROW_131_2051 VSS VDD sky130_fd_sc_hd__tapvpwrvgnd_1
XTAP_TAPCELL_ROW_131_2052 VSS VDD sky130_fd_sc_hd__tapvpwrvgnd_1
XTAP_TAPCELL_ROW_131_2053 VSS VDD sky130_fd_sc_hd__tapvpwrvgnd_1
XTAP_TAPCELL_ROW_131_2054 VSS VDD sky130_fd_sc_hd__tapvpwrvgnd_1
XTAP_TAPCELL_ROW_131_2055 VSS VDD sky130_fd_sc_hd__tapvpwrvgnd_1
XTAP_TAPCELL_ROW_131_2056 VSS VDD sky130_fd_sc_hd__tapvpwrvgnd_1
XTAP_TAPCELL_ROW_131_2057 VSS VDD sky130_fd_sc_hd__tapvpwrvgnd_1
XTAP_TAPCELL_ROW_131_2058 VSS VDD sky130_fd_sc_hd__tapvpwrvgnd_1
XTAP_TAPCELL_ROW_131_2059 VSS VDD sky130_fd_sc_hd__tapvpwrvgnd_1
XTAP_TAPCELL_ROW_131_2060 VSS VDD sky130_fd_sc_hd__tapvpwrvgnd_1
XTAP_TAPCELL_ROW_132_2061 VSS VDD sky130_fd_sc_hd__tapvpwrvgnd_1
XTAP_TAPCELL_ROW_132_2062 VSS VDD sky130_fd_sc_hd__tapvpwrvgnd_1
XTAP_TAPCELL_ROW_132_2063 VSS VDD sky130_fd_sc_hd__tapvpwrvgnd_1
XTAP_TAPCELL_ROW_132_2064 VSS VDD sky130_fd_sc_hd__tapvpwrvgnd_1
XTAP_TAPCELL_ROW_132_2065 VSS VDD sky130_fd_sc_hd__tapvpwrvgnd_1
XTAP_TAPCELL_ROW_132_2066 VSS VDD sky130_fd_sc_hd__tapvpwrvgnd_1
XTAP_TAPCELL_ROW_132_2067 VSS VDD sky130_fd_sc_hd__tapvpwrvgnd_1
XTAP_TAPCELL_ROW_132_2068 VSS VDD sky130_fd_sc_hd__tapvpwrvgnd_1
XTAP_TAPCELL_ROW_132_2069 VSS VDD sky130_fd_sc_hd__tapvpwrvgnd_1
XTAP_TAPCELL_ROW_132_2070 VSS VDD sky130_fd_sc_hd__tapvpwrvgnd_1
XTAP_TAPCELL_ROW_132_2071 VSS VDD sky130_fd_sc_hd__tapvpwrvgnd_1
XTAP_TAPCELL_ROW_132_2072 VSS VDD sky130_fd_sc_hd__tapvpwrvgnd_1
XTAP_TAPCELL_ROW_132_2073 VSS VDD sky130_fd_sc_hd__tapvpwrvgnd_1
XTAP_TAPCELL_ROW_132_2074 VSS VDD sky130_fd_sc_hd__tapvpwrvgnd_1
XTAP_TAPCELL_ROW_132_2075 VSS VDD sky130_fd_sc_hd__tapvpwrvgnd_1
XTAP_TAPCELL_ROW_132_2076 VSS VDD sky130_fd_sc_hd__tapvpwrvgnd_1
XTAP_TAPCELL_ROW_133_2077 VSS VDD sky130_fd_sc_hd__tapvpwrvgnd_1
XTAP_TAPCELL_ROW_133_2078 VSS VDD sky130_fd_sc_hd__tapvpwrvgnd_1
XTAP_TAPCELL_ROW_133_2079 VSS VDD sky130_fd_sc_hd__tapvpwrvgnd_1
XTAP_TAPCELL_ROW_133_2080 VSS VDD sky130_fd_sc_hd__tapvpwrvgnd_1
XTAP_TAPCELL_ROW_133_2081 VSS VDD sky130_fd_sc_hd__tapvpwrvgnd_1
XTAP_TAPCELL_ROW_133_2082 VSS VDD sky130_fd_sc_hd__tapvpwrvgnd_1
XTAP_TAPCELL_ROW_133_2083 VSS VDD sky130_fd_sc_hd__tapvpwrvgnd_1
XTAP_TAPCELL_ROW_133_2084 VSS VDD sky130_fd_sc_hd__tapvpwrvgnd_1
XTAP_TAPCELL_ROW_133_2085 VSS VDD sky130_fd_sc_hd__tapvpwrvgnd_1
XTAP_TAPCELL_ROW_133_2086 VSS VDD sky130_fd_sc_hd__tapvpwrvgnd_1
XTAP_TAPCELL_ROW_133_2087 VSS VDD sky130_fd_sc_hd__tapvpwrvgnd_1
XTAP_TAPCELL_ROW_133_2088 VSS VDD sky130_fd_sc_hd__tapvpwrvgnd_1
XTAP_TAPCELL_ROW_133_2089 VSS VDD sky130_fd_sc_hd__tapvpwrvgnd_1
XTAP_TAPCELL_ROW_133_2090 VSS VDD sky130_fd_sc_hd__tapvpwrvgnd_1
XTAP_TAPCELL_ROW_133_2091 VSS VDD sky130_fd_sc_hd__tapvpwrvgnd_1
XTAP_TAPCELL_ROW_134_2092 VSS VDD sky130_fd_sc_hd__tapvpwrvgnd_1
XTAP_TAPCELL_ROW_134_2093 VSS VDD sky130_fd_sc_hd__tapvpwrvgnd_1
XTAP_TAPCELL_ROW_134_2094 VSS VDD sky130_fd_sc_hd__tapvpwrvgnd_1
XTAP_TAPCELL_ROW_134_2095 VSS VDD sky130_fd_sc_hd__tapvpwrvgnd_1
XTAP_TAPCELL_ROW_134_2096 VSS VDD sky130_fd_sc_hd__tapvpwrvgnd_1
XTAP_TAPCELL_ROW_134_2097 VSS VDD sky130_fd_sc_hd__tapvpwrvgnd_1
XTAP_TAPCELL_ROW_134_2098 VSS VDD sky130_fd_sc_hd__tapvpwrvgnd_1
XTAP_TAPCELL_ROW_134_2099 VSS VDD sky130_fd_sc_hd__tapvpwrvgnd_1
XTAP_TAPCELL_ROW_134_2100 VSS VDD sky130_fd_sc_hd__tapvpwrvgnd_1
XTAP_TAPCELL_ROW_134_2101 VSS VDD sky130_fd_sc_hd__tapvpwrvgnd_1
XTAP_TAPCELL_ROW_134_2102 VSS VDD sky130_fd_sc_hd__tapvpwrvgnd_1
XTAP_TAPCELL_ROW_134_2103 VSS VDD sky130_fd_sc_hd__tapvpwrvgnd_1
XTAP_TAPCELL_ROW_134_2104 VSS VDD sky130_fd_sc_hd__tapvpwrvgnd_1
XTAP_TAPCELL_ROW_134_2105 VSS VDD sky130_fd_sc_hd__tapvpwrvgnd_1
XTAP_TAPCELL_ROW_134_2106 VSS VDD sky130_fd_sc_hd__tapvpwrvgnd_1
XTAP_TAPCELL_ROW_134_2107 VSS VDD sky130_fd_sc_hd__tapvpwrvgnd_1
XTAP_TAPCELL_ROW_135_2108 VSS VDD sky130_fd_sc_hd__tapvpwrvgnd_1
XTAP_TAPCELL_ROW_135_2109 VSS VDD sky130_fd_sc_hd__tapvpwrvgnd_1
XTAP_TAPCELL_ROW_135_2110 VSS VDD sky130_fd_sc_hd__tapvpwrvgnd_1
XTAP_TAPCELL_ROW_135_2111 VSS VDD sky130_fd_sc_hd__tapvpwrvgnd_1
XTAP_TAPCELL_ROW_135_2112 VSS VDD sky130_fd_sc_hd__tapvpwrvgnd_1
XTAP_TAPCELL_ROW_135_2113 VSS VDD sky130_fd_sc_hd__tapvpwrvgnd_1
XTAP_TAPCELL_ROW_135_2114 VSS VDD sky130_fd_sc_hd__tapvpwrvgnd_1
XTAP_TAPCELL_ROW_135_2115 VSS VDD sky130_fd_sc_hd__tapvpwrvgnd_1
XTAP_TAPCELL_ROW_135_2116 VSS VDD sky130_fd_sc_hd__tapvpwrvgnd_1
XTAP_TAPCELL_ROW_135_2117 VSS VDD sky130_fd_sc_hd__tapvpwrvgnd_1
XTAP_TAPCELL_ROW_135_2118 VSS VDD sky130_fd_sc_hd__tapvpwrvgnd_1
XTAP_TAPCELL_ROW_135_2119 VSS VDD sky130_fd_sc_hd__tapvpwrvgnd_1
XTAP_TAPCELL_ROW_135_2120 VSS VDD sky130_fd_sc_hd__tapvpwrvgnd_1
XTAP_TAPCELL_ROW_135_2121 VSS VDD sky130_fd_sc_hd__tapvpwrvgnd_1
XTAP_TAPCELL_ROW_135_2122 VSS VDD sky130_fd_sc_hd__tapvpwrvgnd_1
XTAP_TAPCELL_ROW_136_2123 VSS VDD sky130_fd_sc_hd__tapvpwrvgnd_1
XTAP_TAPCELL_ROW_136_2124 VSS VDD sky130_fd_sc_hd__tapvpwrvgnd_1
XTAP_TAPCELL_ROW_136_2125 VSS VDD sky130_fd_sc_hd__tapvpwrvgnd_1
XTAP_TAPCELL_ROW_136_2126 VSS VDD sky130_fd_sc_hd__tapvpwrvgnd_1
XTAP_TAPCELL_ROW_136_2127 VSS VDD sky130_fd_sc_hd__tapvpwrvgnd_1
XTAP_TAPCELL_ROW_136_2128 VSS VDD sky130_fd_sc_hd__tapvpwrvgnd_1
XTAP_TAPCELL_ROW_136_2129 VSS VDD sky130_fd_sc_hd__tapvpwrvgnd_1
XTAP_TAPCELL_ROW_136_2130 VSS VDD sky130_fd_sc_hd__tapvpwrvgnd_1
XTAP_TAPCELL_ROW_136_2131 VSS VDD sky130_fd_sc_hd__tapvpwrvgnd_1
XTAP_TAPCELL_ROW_136_2132 VSS VDD sky130_fd_sc_hd__tapvpwrvgnd_1
XTAP_TAPCELL_ROW_136_2133 VSS VDD sky130_fd_sc_hd__tapvpwrvgnd_1
XTAP_TAPCELL_ROW_136_2134 VSS VDD sky130_fd_sc_hd__tapvpwrvgnd_1
XTAP_TAPCELL_ROW_136_2135 VSS VDD sky130_fd_sc_hd__tapvpwrvgnd_1
XTAP_TAPCELL_ROW_136_2136 VSS VDD sky130_fd_sc_hd__tapvpwrvgnd_1
XTAP_TAPCELL_ROW_136_2137 VSS VDD sky130_fd_sc_hd__tapvpwrvgnd_1
XTAP_TAPCELL_ROW_136_2138 VSS VDD sky130_fd_sc_hd__tapvpwrvgnd_1
XTAP_TAPCELL_ROW_137_2139 VSS VDD sky130_fd_sc_hd__tapvpwrvgnd_1
XTAP_TAPCELL_ROW_137_2140 VSS VDD sky130_fd_sc_hd__tapvpwrvgnd_1
XTAP_TAPCELL_ROW_137_2141 VSS VDD sky130_fd_sc_hd__tapvpwrvgnd_1
XTAP_TAPCELL_ROW_137_2142 VSS VDD sky130_fd_sc_hd__tapvpwrvgnd_1
XTAP_TAPCELL_ROW_137_2143 VSS VDD sky130_fd_sc_hd__tapvpwrvgnd_1
XTAP_TAPCELL_ROW_137_2144 VSS VDD sky130_fd_sc_hd__tapvpwrvgnd_1
XTAP_TAPCELL_ROW_137_2145 VSS VDD sky130_fd_sc_hd__tapvpwrvgnd_1
XTAP_TAPCELL_ROW_137_2146 VSS VDD sky130_fd_sc_hd__tapvpwrvgnd_1
XTAP_TAPCELL_ROW_137_2147 VSS VDD sky130_fd_sc_hd__tapvpwrvgnd_1
XTAP_TAPCELL_ROW_137_2148 VSS VDD sky130_fd_sc_hd__tapvpwrvgnd_1
XTAP_TAPCELL_ROW_137_2149 VSS VDD sky130_fd_sc_hd__tapvpwrvgnd_1
XTAP_TAPCELL_ROW_137_2150 VSS VDD sky130_fd_sc_hd__tapvpwrvgnd_1
XTAP_TAPCELL_ROW_137_2151 VSS VDD sky130_fd_sc_hd__tapvpwrvgnd_1
XTAP_TAPCELL_ROW_137_2152 VSS VDD sky130_fd_sc_hd__tapvpwrvgnd_1
XTAP_TAPCELL_ROW_137_2153 VSS VDD sky130_fd_sc_hd__tapvpwrvgnd_1
XTAP_TAPCELL_ROW_138_2154 VSS VDD sky130_fd_sc_hd__tapvpwrvgnd_1
XTAP_TAPCELL_ROW_138_2155 VSS VDD sky130_fd_sc_hd__tapvpwrvgnd_1
XTAP_TAPCELL_ROW_138_2156 VSS VDD sky130_fd_sc_hd__tapvpwrvgnd_1
XTAP_TAPCELL_ROW_138_2157 VSS VDD sky130_fd_sc_hd__tapvpwrvgnd_1
XTAP_TAPCELL_ROW_138_2158 VSS VDD sky130_fd_sc_hd__tapvpwrvgnd_1
XTAP_TAPCELL_ROW_138_2159 VSS VDD sky130_fd_sc_hd__tapvpwrvgnd_1
XTAP_TAPCELL_ROW_138_2160 VSS VDD sky130_fd_sc_hd__tapvpwrvgnd_1
XTAP_TAPCELL_ROW_138_2161 VSS VDD sky130_fd_sc_hd__tapvpwrvgnd_1
XTAP_TAPCELL_ROW_138_2162 VSS VDD sky130_fd_sc_hd__tapvpwrvgnd_1
XTAP_TAPCELL_ROW_138_2163 VSS VDD sky130_fd_sc_hd__tapvpwrvgnd_1
XTAP_TAPCELL_ROW_138_2164 VSS VDD sky130_fd_sc_hd__tapvpwrvgnd_1
XTAP_TAPCELL_ROW_138_2165 VSS VDD sky130_fd_sc_hd__tapvpwrvgnd_1
XTAP_TAPCELL_ROW_138_2166 VSS VDD sky130_fd_sc_hd__tapvpwrvgnd_1
XTAP_TAPCELL_ROW_138_2167 VSS VDD sky130_fd_sc_hd__tapvpwrvgnd_1
XTAP_TAPCELL_ROW_138_2168 VSS VDD sky130_fd_sc_hd__tapvpwrvgnd_1
XTAP_TAPCELL_ROW_138_2169 VSS VDD sky130_fd_sc_hd__tapvpwrvgnd_1
XTAP_TAPCELL_ROW_139_2170 VSS VDD sky130_fd_sc_hd__tapvpwrvgnd_1
XTAP_TAPCELL_ROW_139_2171 VSS VDD sky130_fd_sc_hd__tapvpwrvgnd_1
XTAP_TAPCELL_ROW_139_2172 VSS VDD sky130_fd_sc_hd__tapvpwrvgnd_1
XTAP_TAPCELL_ROW_139_2173 VSS VDD sky130_fd_sc_hd__tapvpwrvgnd_1
XTAP_TAPCELL_ROW_139_2174 VSS VDD sky130_fd_sc_hd__tapvpwrvgnd_1
XTAP_TAPCELL_ROW_139_2175 VSS VDD sky130_fd_sc_hd__tapvpwrvgnd_1
XTAP_TAPCELL_ROW_139_2176 VSS VDD sky130_fd_sc_hd__tapvpwrvgnd_1
XTAP_TAPCELL_ROW_139_2177 VSS VDD sky130_fd_sc_hd__tapvpwrvgnd_1
XTAP_TAPCELL_ROW_139_2178 VSS VDD sky130_fd_sc_hd__tapvpwrvgnd_1
XTAP_TAPCELL_ROW_139_2179 VSS VDD sky130_fd_sc_hd__tapvpwrvgnd_1
XTAP_TAPCELL_ROW_139_2180 VSS VDD sky130_fd_sc_hd__tapvpwrvgnd_1
XTAP_TAPCELL_ROW_139_2181 VSS VDD sky130_fd_sc_hd__tapvpwrvgnd_1
XTAP_TAPCELL_ROW_139_2182 VSS VDD sky130_fd_sc_hd__tapvpwrvgnd_1
XTAP_TAPCELL_ROW_139_2183 VSS VDD sky130_fd_sc_hd__tapvpwrvgnd_1
XTAP_TAPCELL_ROW_139_2184 VSS VDD sky130_fd_sc_hd__tapvpwrvgnd_1
XTAP_TAPCELL_ROW_140_2185 VSS VDD sky130_fd_sc_hd__tapvpwrvgnd_1
XTAP_TAPCELL_ROW_140_2186 VSS VDD sky130_fd_sc_hd__tapvpwrvgnd_1
XTAP_TAPCELL_ROW_140_2187 VSS VDD sky130_fd_sc_hd__tapvpwrvgnd_1
XTAP_TAPCELL_ROW_140_2188 VSS VDD sky130_fd_sc_hd__tapvpwrvgnd_1
XTAP_TAPCELL_ROW_140_2189 VSS VDD sky130_fd_sc_hd__tapvpwrvgnd_1
XTAP_TAPCELL_ROW_140_2190 VSS VDD sky130_fd_sc_hd__tapvpwrvgnd_1
XTAP_TAPCELL_ROW_140_2191 VSS VDD sky130_fd_sc_hd__tapvpwrvgnd_1
XTAP_TAPCELL_ROW_140_2192 VSS VDD sky130_fd_sc_hd__tapvpwrvgnd_1
XTAP_TAPCELL_ROW_140_2193 VSS VDD sky130_fd_sc_hd__tapvpwrvgnd_1
XTAP_TAPCELL_ROW_140_2194 VSS VDD sky130_fd_sc_hd__tapvpwrvgnd_1
XTAP_TAPCELL_ROW_140_2195 VSS VDD sky130_fd_sc_hd__tapvpwrvgnd_1
XTAP_TAPCELL_ROW_140_2196 VSS VDD sky130_fd_sc_hd__tapvpwrvgnd_1
XTAP_TAPCELL_ROW_140_2197 VSS VDD sky130_fd_sc_hd__tapvpwrvgnd_1
XTAP_TAPCELL_ROW_140_2198 VSS VDD sky130_fd_sc_hd__tapvpwrvgnd_1
XTAP_TAPCELL_ROW_140_2199 VSS VDD sky130_fd_sc_hd__tapvpwrvgnd_1
XTAP_TAPCELL_ROW_140_2200 VSS VDD sky130_fd_sc_hd__tapvpwrvgnd_1
XTAP_TAPCELL_ROW_141_2201 VSS VDD sky130_fd_sc_hd__tapvpwrvgnd_1
XTAP_TAPCELL_ROW_141_2202 VSS VDD sky130_fd_sc_hd__tapvpwrvgnd_1
XTAP_TAPCELL_ROW_141_2203 VSS VDD sky130_fd_sc_hd__tapvpwrvgnd_1
XTAP_TAPCELL_ROW_141_2204 VSS VDD sky130_fd_sc_hd__tapvpwrvgnd_1
XTAP_TAPCELL_ROW_141_2205 VSS VDD sky130_fd_sc_hd__tapvpwrvgnd_1
XTAP_TAPCELL_ROW_141_2206 VSS VDD sky130_fd_sc_hd__tapvpwrvgnd_1
XTAP_TAPCELL_ROW_141_2207 VSS VDD sky130_fd_sc_hd__tapvpwrvgnd_1
XTAP_TAPCELL_ROW_141_2208 VSS VDD sky130_fd_sc_hd__tapvpwrvgnd_1
XTAP_TAPCELL_ROW_141_2209 VSS VDD sky130_fd_sc_hd__tapvpwrvgnd_1
XTAP_TAPCELL_ROW_141_2210 VSS VDD sky130_fd_sc_hd__tapvpwrvgnd_1
XTAP_TAPCELL_ROW_141_2211 VSS VDD sky130_fd_sc_hd__tapvpwrvgnd_1
XTAP_TAPCELL_ROW_141_2212 VSS VDD sky130_fd_sc_hd__tapvpwrvgnd_1
XTAP_TAPCELL_ROW_141_2213 VSS VDD sky130_fd_sc_hd__tapvpwrvgnd_1
XTAP_TAPCELL_ROW_141_2214 VSS VDD sky130_fd_sc_hd__tapvpwrvgnd_1
XTAP_TAPCELL_ROW_141_2215 VSS VDD sky130_fd_sc_hd__tapvpwrvgnd_1
XTAP_TAPCELL_ROW_142_2216 VSS VDD sky130_fd_sc_hd__tapvpwrvgnd_1
XTAP_TAPCELL_ROW_142_2217 VSS VDD sky130_fd_sc_hd__tapvpwrvgnd_1
XTAP_TAPCELL_ROW_142_2218 VSS VDD sky130_fd_sc_hd__tapvpwrvgnd_1
XTAP_TAPCELL_ROW_142_2219 VSS VDD sky130_fd_sc_hd__tapvpwrvgnd_1
XTAP_TAPCELL_ROW_142_2220 VSS VDD sky130_fd_sc_hd__tapvpwrvgnd_1
XTAP_TAPCELL_ROW_142_2221 VSS VDD sky130_fd_sc_hd__tapvpwrvgnd_1
XTAP_TAPCELL_ROW_142_2222 VSS VDD sky130_fd_sc_hd__tapvpwrvgnd_1
XTAP_TAPCELL_ROW_142_2223 VSS VDD sky130_fd_sc_hd__tapvpwrvgnd_1
XTAP_TAPCELL_ROW_142_2224 VSS VDD sky130_fd_sc_hd__tapvpwrvgnd_1
XTAP_TAPCELL_ROW_142_2225 VSS VDD sky130_fd_sc_hd__tapvpwrvgnd_1
XTAP_TAPCELL_ROW_142_2226 VSS VDD sky130_fd_sc_hd__tapvpwrvgnd_1
XTAP_TAPCELL_ROW_142_2227 VSS VDD sky130_fd_sc_hd__tapvpwrvgnd_1
XTAP_TAPCELL_ROW_142_2228 VSS VDD sky130_fd_sc_hd__tapvpwrvgnd_1
XTAP_TAPCELL_ROW_142_2229 VSS VDD sky130_fd_sc_hd__tapvpwrvgnd_1
XTAP_TAPCELL_ROW_142_2230 VSS VDD sky130_fd_sc_hd__tapvpwrvgnd_1
XTAP_TAPCELL_ROW_142_2231 VSS VDD sky130_fd_sc_hd__tapvpwrvgnd_1
XTAP_TAPCELL_ROW_143_2232 VSS VDD sky130_fd_sc_hd__tapvpwrvgnd_1
XTAP_TAPCELL_ROW_143_2233 VSS VDD sky130_fd_sc_hd__tapvpwrvgnd_1
XTAP_TAPCELL_ROW_143_2234 VSS VDD sky130_fd_sc_hd__tapvpwrvgnd_1
XTAP_TAPCELL_ROW_143_2235 VSS VDD sky130_fd_sc_hd__tapvpwrvgnd_1
XTAP_TAPCELL_ROW_143_2236 VSS VDD sky130_fd_sc_hd__tapvpwrvgnd_1
XTAP_TAPCELL_ROW_143_2237 VSS VDD sky130_fd_sc_hd__tapvpwrvgnd_1
XTAP_TAPCELL_ROW_143_2238 VSS VDD sky130_fd_sc_hd__tapvpwrvgnd_1
XTAP_TAPCELL_ROW_143_2239 VSS VDD sky130_fd_sc_hd__tapvpwrvgnd_1
XTAP_TAPCELL_ROW_143_2240 VSS VDD sky130_fd_sc_hd__tapvpwrvgnd_1
XTAP_TAPCELL_ROW_143_2241 VSS VDD sky130_fd_sc_hd__tapvpwrvgnd_1
XTAP_TAPCELL_ROW_143_2242 VSS VDD sky130_fd_sc_hd__tapvpwrvgnd_1
XTAP_TAPCELL_ROW_143_2243 VSS VDD sky130_fd_sc_hd__tapvpwrvgnd_1
XTAP_TAPCELL_ROW_143_2244 VSS VDD sky130_fd_sc_hd__tapvpwrvgnd_1
XTAP_TAPCELL_ROW_143_2245 VSS VDD sky130_fd_sc_hd__tapvpwrvgnd_1
XTAP_TAPCELL_ROW_143_2246 VSS VDD sky130_fd_sc_hd__tapvpwrvgnd_1
XTAP_TAPCELL_ROW_144_2247 VSS VDD sky130_fd_sc_hd__tapvpwrvgnd_1
XTAP_TAPCELL_ROW_144_2248 VSS VDD sky130_fd_sc_hd__tapvpwrvgnd_1
XTAP_TAPCELL_ROW_144_2249 VSS VDD sky130_fd_sc_hd__tapvpwrvgnd_1
XTAP_TAPCELL_ROW_144_2250 VSS VDD sky130_fd_sc_hd__tapvpwrvgnd_1
XTAP_TAPCELL_ROW_144_2251 VSS VDD sky130_fd_sc_hd__tapvpwrvgnd_1
XTAP_TAPCELL_ROW_144_2252 VSS VDD sky130_fd_sc_hd__tapvpwrvgnd_1
XTAP_TAPCELL_ROW_144_2253 VSS VDD sky130_fd_sc_hd__tapvpwrvgnd_1
XTAP_TAPCELL_ROW_144_2254 VSS VDD sky130_fd_sc_hd__tapvpwrvgnd_1
XTAP_TAPCELL_ROW_144_2255 VSS VDD sky130_fd_sc_hd__tapvpwrvgnd_1
XTAP_TAPCELL_ROW_144_2256 VSS VDD sky130_fd_sc_hd__tapvpwrvgnd_1
XTAP_TAPCELL_ROW_144_2257 VSS VDD sky130_fd_sc_hd__tapvpwrvgnd_1
XTAP_TAPCELL_ROW_144_2258 VSS VDD sky130_fd_sc_hd__tapvpwrvgnd_1
XTAP_TAPCELL_ROW_144_2259 VSS VDD sky130_fd_sc_hd__tapvpwrvgnd_1
XTAP_TAPCELL_ROW_144_2260 VSS VDD sky130_fd_sc_hd__tapvpwrvgnd_1
XTAP_TAPCELL_ROW_144_2261 VSS VDD sky130_fd_sc_hd__tapvpwrvgnd_1
XTAP_TAPCELL_ROW_144_2262 VSS VDD sky130_fd_sc_hd__tapvpwrvgnd_1
XTAP_TAPCELL_ROW_145_2263 VSS VDD sky130_fd_sc_hd__tapvpwrvgnd_1
XTAP_TAPCELL_ROW_145_2264 VSS VDD sky130_fd_sc_hd__tapvpwrvgnd_1
XTAP_TAPCELL_ROW_145_2265 VSS VDD sky130_fd_sc_hd__tapvpwrvgnd_1
XTAP_TAPCELL_ROW_145_2266 VSS VDD sky130_fd_sc_hd__tapvpwrvgnd_1
XTAP_TAPCELL_ROW_145_2267 VSS VDD sky130_fd_sc_hd__tapvpwrvgnd_1
XTAP_TAPCELL_ROW_145_2268 VSS VDD sky130_fd_sc_hd__tapvpwrvgnd_1
XTAP_TAPCELL_ROW_145_2269 VSS VDD sky130_fd_sc_hd__tapvpwrvgnd_1
XTAP_TAPCELL_ROW_145_2270 VSS VDD sky130_fd_sc_hd__tapvpwrvgnd_1
XTAP_TAPCELL_ROW_145_2271 VSS VDD sky130_fd_sc_hd__tapvpwrvgnd_1
XTAP_TAPCELL_ROW_145_2272 VSS VDD sky130_fd_sc_hd__tapvpwrvgnd_1
XTAP_TAPCELL_ROW_145_2273 VSS VDD sky130_fd_sc_hd__tapvpwrvgnd_1
XTAP_TAPCELL_ROW_145_2274 VSS VDD sky130_fd_sc_hd__tapvpwrvgnd_1
XTAP_TAPCELL_ROW_145_2275 VSS VDD sky130_fd_sc_hd__tapvpwrvgnd_1
XTAP_TAPCELL_ROW_145_2276 VSS VDD sky130_fd_sc_hd__tapvpwrvgnd_1
XTAP_TAPCELL_ROW_145_2277 VSS VDD sky130_fd_sc_hd__tapvpwrvgnd_1
XTAP_TAPCELL_ROW_146_2278 VSS VDD sky130_fd_sc_hd__tapvpwrvgnd_1
XTAP_TAPCELL_ROW_146_2279 VSS VDD sky130_fd_sc_hd__tapvpwrvgnd_1
XTAP_TAPCELL_ROW_146_2280 VSS VDD sky130_fd_sc_hd__tapvpwrvgnd_1
XTAP_TAPCELL_ROW_146_2281 VSS VDD sky130_fd_sc_hd__tapvpwrvgnd_1
XTAP_TAPCELL_ROW_146_2282 VSS VDD sky130_fd_sc_hd__tapvpwrvgnd_1
XTAP_TAPCELL_ROW_146_2283 VSS VDD sky130_fd_sc_hd__tapvpwrvgnd_1
XTAP_TAPCELL_ROW_146_2284 VSS VDD sky130_fd_sc_hd__tapvpwrvgnd_1
XTAP_TAPCELL_ROW_146_2285 VSS VDD sky130_fd_sc_hd__tapvpwrvgnd_1
XTAP_TAPCELL_ROW_146_2286 VSS VDD sky130_fd_sc_hd__tapvpwrvgnd_1
XTAP_TAPCELL_ROW_146_2287 VSS VDD sky130_fd_sc_hd__tapvpwrvgnd_1
XTAP_TAPCELL_ROW_146_2288 VSS VDD sky130_fd_sc_hd__tapvpwrvgnd_1
XTAP_TAPCELL_ROW_146_2289 VSS VDD sky130_fd_sc_hd__tapvpwrvgnd_1
XTAP_TAPCELL_ROW_146_2290 VSS VDD sky130_fd_sc_hd__tapvpwrvgnd_1
XTAP_TAPCELL_ROW_146_2291 VSS VDD sky130_fd_sc_hd__tapvpwrvgnd_1
XTAP_TAPCELL_ROW_146_2292 VSS VDD sky130_fd_sc_hd__tapvpwrvgnd_1
XTAP_TAPCELL_ROW_146_2293 VSS VDD sky130_fd_sc_hd__tapvpwrvgnd_1
XTAP_TAPCELL_ROW_147_2294 VSS VDD sky130_fd_sc_hd__tapvpwrvgnd_1
XTAP_TAPCELL_ROW_147_2295 VSS VDD sky130_fd_sc_hd__tapvpwrvgnd_1
XTAP_TAPCELL_ROW_147_2296 VSS VDD sky130_fd_sc_hd__tapvpwrvgnd_1
XTAP_TAPCELL_ROW_147_2297 VSS VDD sky130_fd_sc_hd__tapvpwrvgnd_1
XTAP_TAPCELL_ROW_147_2298 VSS VDD sky130_fd_sc_hd__tapvpwrvgnd_1
XTAP_TAPCELL_ROW_147_2299 VSS VDD sky130_fd_sc_hd__tapvpwrvgnd_1
XTAP_TAPCELL_ROW_147_2300 VSS VDD sky130_fd_sc_hd__tapvpwrvgnd_1
XTAP_TAPCELL_ROW_147_2301 VSS VDD sky130_fd_sc_hd__tapvpwrvgnd_1
XTAP_TAPCELL_ROW_147_2302 VSS VDD sky130_fd_sc_hd__tapvpwrvgnd_1
XTAP_TAPCELL_ROW_147_2303 VSS VDD sky130_fd_sc_hd__tapvpwrvgnd_1
XTAP_TAPCELL_ROW_147_2304 VSS VDD sky130_fd_sc_hd__tapvpwrvgnd_1
XTAP_TAPCELL_ROW_147_2305 VSS VDD sky130_fd_sc_hd__tapvpwrvgnd_1
XTAP_TAPCELL_ROW_147_2306 VSS VDD sky130_fd_sc_hd__tapvpwrvgnd_1
XTAP_TAPCELL_ROW_147_2307 VSS VDD sky130_fd_sc_hd__tapvpwrvgnd_1
XTAP_TAPCELL_ROW_147_2308 VSS VDD sky130_fd_sc_hd__tapvpwrvgnd_1
XTAP_TAPCELL_ROW_148_2309 VSS VDD sky130_fd_sc_hd__tapvpwrvgnd_1
XTAP_TAPCELL_ROW_148_2310 VSS VDD sky130_fd_sc_hd__tapvpwrvgnd_1
XTAP_TAPCELL_ROW_148_2311 VSS VDD sky130_fd_sc_hd__tapvpwrvgnd_1
XTAP_TAPCELL_ROW_148_2312 VSS VDD sky130_fd_sc_hd__tapvpwrvgnd_1
XTAP_TAPCELL_ROW_148_2313 VSS VDD sky130_fd_sc_hd__tapvpwrvgnd_1
XTAP_TAPCELL_ROW_148_2314 VSS VDD sky130_fd_sc_hd__tapvpwrvgnd_1
XTAP_TAPCELL_ROW_148_2315 VSS VDD sky130_fd_sc_hd__tapvpwrvgnd_1
XTAP_TAPCELL_ROW_148_2316 VSS VDD sky130_fd_sc_hd__tapvpwrvgnd_1
XTAP_TAPCELL_ROW_148_2317 VSS VDD sky130_fd_sc_hd__tapvpwrvgnd_1
XTAP_TAPCELL_ROW_148_2318 VSS VDD sky130_fd_sc_hd__tapvpwrvgnd_1
XTAP_TAPCELL_ROW_148_2319 VSS VDD sky130_fd_sc_hd__tapvpwrvgnd_1
XTAP_TAPCELL_ROW_148_2320 VSS VDD sky130_fd_sc_hd__tapvpwrvgnd_1
XTAP_TAPCELL_ROW_148_2321 VSS VDD sky130_fd_sc_hd__tapvpwrvgnd_1
XTAP_TAPCELL_ROW_148_2322 VSS VDD sky130_fd_sc_hd__tapvpwrvgnd_1
XTAP_TAPCELL_ROW_148_2323 VSS VDD sky130_fd_sc_hd__tapvpwrvgnd_1
XTAP_TAPCELL_ROW_148_2324 VSS VDD sky130_fd_sc_hd__tapvpwrvgnd_1
XTAP_TAPCELL_ROW_149_2325 VSS VDD sky130_fd_sc_hd__tapvpwrvgnd_1
XTAP_TAPCELL_ROW_149_2326 VSS VDD sky130_fd_sc_hd__tapvpwrvgnd_1
XTAP_TAPCELL_ROW_149_2327 VSS VDD sky130_fd_sc_hd__tapvpwrvgnd_1
XTAP_TAPCELL_ROW_149_2328 VSS VDD sky130_fd_sc_hd__tapvpwrvgnd_1
XTAP_TAPCELL_ROW_149_2329 VSS VDD sky130_fd_sc_hd__tapvpwrvgnd_1
XTAP_TAPCELL_ROW_149_2330 VSS VDD sky130_fd_sc_hd__tapvpwrvgnd_1
XTAP_TAPCELL_ROW_149_2331 VSS VDD sky130_fd_sc_hd__tapvpwrvgnd_1
XTAP_TAPCELL_ROW_149_2332 VSS VDD sky130_fd_sc_hd__tapvpwrvgnd_1
XTAP_TAPCELL_ROW_149_2333 VSS VDD sky130_fd_sc_hd__tapvpwrvgnd_1
XTAP_TAPCELL_ROW_149_2334 VSS VDD sky130_fd_sc_hd__tapvpwrvgnd_1
XTAP_TAPCELL_ROW_149_2335 VSS VDD sky130_fd_sc_hd__tapvpwrvgnd_1
XTAP_TAPCELL_ROW_149_2336 VSS VDD sky130_fd_sc_hd__tapvpwrvgnd_1
XTAP_TAPCELL_ROW_149_2337 VSS VDD sky130_fd_sc_hd__tapvpwrvgnd_1
XTAP_TAPCELL_ROW_149_2338 VSS VDD sky130_fd_sc_hd__tapvpwrvgnd_1
XTAP_TAPCELL_ROW_149_2339 VSS VDD sky130_fd_sc_hd__tapvpwrvgnd_1
XTAP_TAPCELL_ROW_150_2340 VSS VDD sky130_fd_sc_hd__tapvpwrvgnd_1
XTAP_TAPCELL_ROW_150_2341 VSS VDD sky130_fd_sc_hd__tapvpwrvgnd_1
XTAP_TAPCELL_ROW_150_2342 VSS VDD sky130_fd_sc_hd__tapvpwrvgnd_1
XTAP_TAPCELL_ROW_150_2343 VSS VDD sky130_fd_sc_hd__tapvpwrvgnd_1
XTAP_TAPCELL_ROW_150_2344 VSS VDD sky130_fd_sc_hd__tapvpwrvgnd_1
XTAP_TAPCELL_ROW_150_2345 VSS VDD sky130_fd_sc_hd__tapvpwrvgnd_1
XTAP_TAPCELL_ROW_150_2346 VSS VDD sky130_fd_sc_hd__tapvpwrvgnd_1
XTAP_TAPCELL_ROW_150_2347 VSS VDD sky130_fd_sc_hd__tapvpwrvgnd_1
XTAP_TAPCELL_ROW_150_2348 VSS VDD sky130_fd_sc_hd__tapvpwrvgnd_1
XTAP_TAPCELL_ROW_150_2349 VSS VDD sky130_fd_sc_hd__tapvpwrvgnd_1
XTAP_TAPCELL_ROW_150_2350 VSS VDD sky130_fd_sc_hd__tapvpwrvgnd_1
XTAP_TAPCELL_ROW_150_2351 VSS VDD sky130_fd_sc_hd__tapvpwrvgnd_1
XTAP_TAPCELL_ROW_150_2352 VSS VDD sky130_fd_sc_hd__tapvpwrvgnd_1
XTAP_TAPCELL_ROW_150_2353 VSS VDD sky130_fd_sc_hd__tapvpwrvgnd_1
XTAP_TAPCELL_ROW_150_2354 VSS VDD sky130_fd_sc_hd__tapvpwrvgnd_1
XTAP_TAPCELL_ROW_150_2355 VSS VDD sky130_fd_sc_hd__tapvpwrvgnd_1
XTAP_TAPCELL_ROW_151_2356 VSS VDD sky130_fd_sc_hd__tapvpwrvgnd_1
XTAP_TAPCELL_ROW_151_2357 VSS VDD sky130_fd_sc_hd__tapvpwrvgnd_1
XTAP_TAPCELL_ROW_151_2358 VSS VDD sky130_fd_sc_hd__tapvpwrvgnd_1
XTAP_TAPCELL_ROW_151_2359 VSS VDD sky130_fd_sc_hd__tapvpwrvgnd_1
XTAP_TAPCELL_ROW_151_2360 VSS VDD sky130_fd_sc_hd__tapvpwrvgnd_1
XTAP_TAPCELL_ROW_151_2361 VSS VDD sky130_fd_sc_hd__tapvpwrvgnd_1
XTAP_TAPCELL_ROW_151_2362 VSS VDD sky130_fd_sc_hd__tapvpwrvgnd_1
XTAP_TAPCELL_ROW_151_2363 VSS VDD sky130_fd_sc_hd__tapvpwrvgnd_1
XTAP_TAPCELL_ROW_151_2364 VSS VDD sky130_fd_sc_hd__tapvpwrvgnd_1
XTAP_TAPCELL_ROW_151_2365 VSS VDD sky130_fd_sc_hd__tapvpwrvgnd_1
XTAP_TAPCELL_ROW_151_2366 VSS VDD sky130_fd_sc_hd__tapvpwrvgnd_1
XTAP_TAPCELL_ROW_151_2367 VSS VDD sky130_fd_sc_hd__tapvpwrvgnd_1
XTAP_TAPCELL_ROW_151_2368 VSS VDD sky130_fd_sc_hd__tapvpwrvgnd_1
XTAP_TAPCELL_ROW_151_2369 VSS VDD sky130_fd_sc_hd__tapvpwrvgnd_1
XTAP_TAPCELL_ROW_151_2370 VSS VDD sky130_fd_sc_hd__tapvpwrvgnd_1
XTAP_TAPCELL_ROW_152_2371 VSS VDD sky130_fd_sc_hd__tapvpwrvgnd_1
XTAP_TAPCELL_ROW_152_2372 VSS VDD sky130_fd_sc_hd__tapvpwrvgnd_1
XTAP_TAPCELL_ROW_152_2373 VSS VDD sky130_fd_sc_hd__tapvpwrvgnd_1
XTAP_TAPCELL_ROW_152_2374 VSS VDD sky130_fd_sc_hd__tapvpwrvgnd_1
XTAP_TAPCELL_ROW_152_2375 VSS VDD sky130_fd_sc_hd__tapvpwrvgnd_1
XTAP_TAPCELL_ROW_152_2376 VSS VDD sky130_fd_sc_hd__tapvpwrvgnd_1
XTAP_TAPCELL_ROW_152_2377 VSS VDD sky130_fd_sc_hd__tapvpwrvgnd_1
XTAP_TAPCELL_ROW_152_2378 VSS VDD sky130_fd_sc_hd__tapvpwrvgnd_1
XTAP_TAPCELL_ROW_152_2379 VSS VDD sky130_fd_sc_hd__tapvpwrvgnd_1
XTAP_TAPCELL_ROW_152_2380 VSS VDD sky130_fd_sc_hd__tapvpwrvgnd_1
XTAP_TAPCELL_ROW_152_2381 VSS VDD sky130_fd_sc_hd__tapvpwrvgnd_1
XTAP_TAPCELL_ROW_152_2382 VSS VDD sky130_fd_sc_hd__tapvpwrvgnd_1
XTAP_TAPCELL_ROW_152_2383 VSS VDD sky130_fd_sc_hd__tapvpwrvgnd_1
XTAP_TAPCELL_ROW_152_2384 VSS VDD sky130_fd_sc_hd__tapvpwrvgnd_1
XTAP_TAPCELL_ROW_152_2385 VSS VDD sky130_fd_sc_hd__tapvpwrvgnd_1
XTAP_TAPCELL_ROW_152_2386 VSS VDD sky130_fd_sc_hd__tapvpwrvgnd_1
XTAP_TAPCELL_ROW_153_2387 VSS VDD sky130_fd_sc_hd__tapvpwrvgnd_1
XTAP_TAPCELL_ROW_153_2388 VSS VDD sky130_fd_sc_hd__tapvpwrvgnd_1
XTAP_TAPCELL_ROW_153_2389 VSS VDD sky130_fd_sc_hd__tapvpwrvgnd_1
XTAP_TAPCELL_ROW_153_2390 VSS VDD sky130_fd_sc_hd__tapvpwrvgnd_1
XTAP_TAPCELL_ROW_153_2391 VSS VDD sky130_fd_sc_hd__tapvpwrvgnd_1
XTAP_TAPCELL_ROW_153_2392 VSS VDD sky130_fd_sc_hd__tapvpwrvgnd_1
XTAP_TAPCELL_ROW_153_2393 VSS VDD sky130_fd_sc_hd__tapvpwrvgnd_1
XTAP_TAPCELL_ROW_153_2394 VSS VDD sky130_fd_sc_hd__tapvpwrvgnd_1
XTAP_TAPCELL_ROW_153_2395 VSS VDD sky130_fd_sc_hd__tapvpwrvgnd_1
XTAP_TAPCELL_ROW_153_2396 VSS VDD sky130_fd_sc_hd__tapvpwrvgnd_1
XTAP_TAPCELL_ROW_153_2397 VSS VDD sky130_fd_sc_hd__tapvpwrvgnd_1
XTAP_TAPCELL_ROW_153_2398 VSS VDD sky130_fd_sc_hd__tapvpwrvgnd_1
XTAP_TAPCELL_ROW_153_2399 VSS VDD sky130_fd_sc_hd__tapvpwrvgnd_1
XTAP_TAPCELL_ROW_153_2400 VSS VDD sky130_fd_sc_hd__tapvpwrvgnd_1
XTAP_TAPCELL_ROW_153_2401 VSS VDD sky130_fd_sc_hd__tapvpwrvgnd_1
XTAP_TAPCELL_ROW_154_2402 VSS VDD sky130_fd_sc_hd__tapvpwrvgnd_1
XTAP_TAPCELL_ROW_154_2403 VSS VDD sky130_fd_sc_hd__tapvpwrvgnd_1
XTAP_TAPCELL_ROW_154_2404 VSS VDD sky130_fd_sc_hd__tapvpwrvgnd_1
XTAP_TAPCELL_ROW_154_2405 VSS VDD sky130_fd_sc_hd__tapvpwrvgnd_1
XTAP_TAPCELL_ROW_154_2406 VSS VDD sky130_fd_sc_hd__tapvpwrvgnd_1
XTAP_TAPCELL_ROW_154_2407 VSS VDD sky130_fd_sc_hd__tapvpwrvgnd_1
XTAP_TAPCELL_ROW_154_2408 VSS VDD sky130_fd_sc_hd__tapvpwrvgnd_1
XTAP_TAPCELL_ROW_154_2409 VSS VDD sky130_fd_sc_hd__tapvpwrvgnd_1
XTAP_TAPCELL_ROW_154_2410 VSS VDD sky130_fd_sc_hd__tapvpwrvgnd_1
XTAP_TAPCELL_ROW_154_2411 VSS VDD sky130_fd_sc_hd__tapvpwrvgnd_1
XTAP_TAPCELL_ROW_154_2412 VSS VDD sky130_fd_sc_hd__tapvpwrvgnd_1
XTAP_TAPCELL_ROW_154_2413 VSS VDD sky130_fd_sc_hd__tapvpwrvgnd_1
XTAP_TAPCELL_ROW_154_2414 VSS VDD sky130_fd_sc_hd__tapvpwrvgnd_1
XTAP_TAPCELL_ROW_154_2415 VSS VDD sky130_fd_sc_hd__tapvpwrvgnd_1
XTAP_TAPCELL_ROW_154_2416 VSS VDD sky130_fd_sc_hd__tapvpwrvgnd_1
XTAP_TAPCELL_ROW_154_2417 VSS VDD sky130_fd_sc_hd__tapvpwrvgnd_1
XTAP_TAPCELL_ROW_155_2418 VSS VDD sky130_fd_sc_hd__tapvpwrvgnd_1
XTAP_TAPCELL_ROW_155_2419 VSS VDD sky130_fd_sc_hd__tapvpwrvgnd_1
XTAP_TAPCELL_ROW_155_2420 VSS VDD sky130_fd_sc_hd__tapvpwrvgnd_1
XTAP_TAPCELL_ROW_155_2421 VSS VDD sky130_fd_sc_hd__tapvpwrvgnd_1
XTAP_TAPCELL_ROW_155_2422 VSS VDD sky130_fd_sc_hd__tapvpwrvgnd_1
XTAP_TAPCELL_ROW_155_2423 VSS VDD sky130_fd_sc_hd__tapvpwrvgnd_1
XTAP_TAPCELL_ROW_155_2424 VSS VDD sky130_fd_sc_hd__tapvpwrvgnd_1
XTAP_TAPCELL_ROW_155_2425 VSS VDD sky130_fd_sc_hd__tapvpwrvgnd_1
XTAP_TAPCELL_ROW_155_2426 VSS VDD sky130_fd_sc_hd__tapvpwrvgnd_1
XTAP_TAPCELL_ROW_155_2427 VSS VDD sky130_fd_sc_hd__tapvpwrvgnd_1
XTAP_TAPCELL_ROW_155_2428 VSS VDD sky130_fd_sc_hd__tapvpwrvgnd_1
XTAP_TAPCELL_ROW_155_2429 VSS VDD sky130_fd_sc_hd__tapvpwrvgnd_1
XTAP_TAPCELL_ROW_155_2430 VSS VDD sky130_fd_sc_hd__tapvpwrvgnd_1
XTAP_TAPCELL_ROW_155_2431 VSS VDD sky130_fd_sc_hd__tapvpwrvgnd_1
XTAP_TAPCELL_ROW_155_2432 VSS VDD sky130_fd_sc_hd__tapvpwrvgnd_1
XTAP_TAPCELL_ROW_156_2433 VSS VDD sky130_fd_sc_hd__tapvpwrvgnd_1
XTAP_TAPCELL_ROW_156_2434 VSS VDD sky130_fd_sc_hd__tapvpwrvgnd_1
XTAP_TAPCELL_ROW_156_2435 VSS VDD sky130_fd_sc_hd__tapvpwrvgnd_1
XTAP_TAPCELL_ROW_156_2436 VSS VDD sky130_fd_sc_hd__tapvpwrvgnd_1
XTAP_TAPCELL_ROW_156_2437 VSS VDD sky130_fd_sc_hd__tapvpwrvgnd_1
XTAP_TAPCELL_ROW_156_2438 VSS VDD sky130_fd_sc_hd__tapvpwrvgnd_1
XTAP_TAPCELL_ROW_156_2439 VSS VDD sky130_fd_sc_hd__tapvpwrvgnd_1
XTAP_TAPCELL_ROW_156_2440 VSS VDD sky130_fd_sc_hd__tapvpwrvgnd_1
XTAP_TAPCELL_ROW_156_2441 VSS VDD sky130_fd_sc_hd__tapvpwrvgnd_1
XTAP_TAPCELL_ROW_156_2442 VSS VDD sky130_fd_sc_hd__tapvpwrvgnd_1
XTAP_TAPCELL_ROW_156_2443 VSS VDD sky130_fd_sc_hd__tapvpwrvgnd_1
XTAP_TAPCELL_ROW_156_2444 VSS VDD sky130_fd_sc_hd__tapvpwrvgnd_1
XTAP_TAPCELL_ROW_156_2445 VSS VDD sky130_fd_sc_hd__tapvpwrvgnd_1
XTAP_TAPCELL_ROW_156_2446 VSS VDD sky130_fd_sc_hd__tapvpwrvgnd_1
XTAP_TAPCELL_ROW_156_2447 VSS VDD sky130_fd_sc_hd__tapvpwrvgnd_1
XTAP_TAPCELL_ROW_156_2448 VSS VDD sky130_fd_sc_hd__tapvpwrvgnd_1
XTAP_TAPCELL_ROW_157_2449 VSS VDD sky130_fd_sc_hd__tapvpwrvgnd_1
XTAP_TAPCELL_ROW_157_2450 VSS VDD sky130_fd_sc_hd__tapvpwrvgnd_1
XTAP_TAPCELL_ROW_157_2451 VSS VDD sky130_fd_sc_hd__tapvpwrvgnd_1
XTAP_TAPCELL_ROW_157_2452 VSS VDD sky130_fd_sc_hd__tapvpwrvgnd_1
XTAP_TAPCELL_ROW_157_2453 VSS VDD sky130_fd_sc_hd__tapvpwrvgnd_1
XTAP_TAPCELL_ROW_157_2454 VSS VDD sky130_fd_sc_hd__tapvpwrvgnd_1
XTAP_TAPCELL_ROW_157_2455 VSS VDD sky130_fd_sc_hd__tapvpwrvgnd_1
XTAP_TAPCELL_ROW_157_2456 VSS VDD sky130_fd_sc_hd__tapvpwrvgnd_1
XTAP_TAPCELL_ROW_157_2457 VSS VDD sky130_fd_sc_hd__tapvpwrvgnd_1
XTAP_TAPCELL_ROW_157_2458 VSS VDD sky130_fd_sc_hd__tapvpwrvgnd_1
XTAP_TAPCELL_ROW_157_2459 VSS VDD sky130_fd_sc_hd__tapvpwrvgnd_1
XTAP_TAPCELL_ROW_157_2460 VSS VDD sky130_fd_sc_hd__tapvpwrvgnd_1
XTAP_TAPCELL_ROW_157_2461 VSS VDD sky130_fd_sc_hd__tapvpwrvgnd_1
XTAP_TAPCELL_ROW_157_2462 VSS VDD sky130_fd_sc_hd__tapvpwrvgnd_1
XTAP_TAPCELL_ROW_157_2463 VSS VDD sky130_fd_sc_hd__tapvpwrvgnd_1
XTAP_TAPCELL_ROW_158_2464 VSS VDD sky130_fd_sc_hd__tapvpwrvgnd_1
XTAP_TAPCELL_ROW_158_2465 VSS VDD sky130_fd_sc_hd__tapvpwrvgnd_1
XTAP_TAPCELL_ROW_158_2466 VSS VDD sky130_fd_sc_hd__tapvpwrvgnd_1
XTAP_TAPCELL_ROW_158_2467 VSS VDD sky130_fd_sc_hd__tapvpwrvgnd_1
XTAP_TAPCELL_ROW_158_2468 VSS VDD sky130_fd_sc_hd__tapvpwrvgnd_1
XTAP_TAPCELL_ROW_158_2469 VSS VDD sky130_fd_sc_hd__tapvpwrvgnd_1
XTAP_TAPCELL_ROW_158_2470 VSS VDD sky130_fd_sc_hd__tapvpwrvgnd_1
XTAP_TAPCELL_ROW_158_2471 VSS VDD sky130_fd_sc_hd__tapvpwrvgnd_1
XTAP_TAPCELL_ROW_158_2472 VSS VDD sky130_fd_sc_hd__tapvpwrvgnd_1
XTAP_TAPCELL_ROW_158_2473 VSS VDD sky130_fd_sc_hd__tapvpwrvgnd_1
XTAP_TAPCELL_ROW_158_2474 VSS VDD sky130_fd_sc_hd__tapvpwrvgnd_1
XTAP_TAPCELL_ROW_158_2475 VSS VDD sky130_fd_sc_hd__tapvpwrvgnd_1
XTAP_TAPCELL_ROW_158_2476 VSS VDD sky130_fd_sc_hd__tapvpwrvgnd_1
XTAP_TAPCELL_ROW_158_2477 VSS VDD sky130_fd_sc_hd__tapvpwrvgnd_1
XTAP_TAPCELL_ROW_158_2478 VSS VDD sky130_fd_sc_hd__tapvpwrvgnd_1
XTAP_TAPCELL_ROW_158_2479 VSS VDD sky130_fd_sc_hd__tapvpwrvgnd_1
XTAP_TAPCELL_ROW_158_2480 VSS VDD sky130_fd_sc_hd__tapvpwrvgnd_1
XTAP_TAPCELL_ROW_158_2481 VSS VDD sky130_fd_sc_hd__tapvpwrvgnd_1
XTAP_TAPCELL_ROW_158_2482 VSS VDD sky130_fd_sc_hd__tapvpwrvgnd_1
XTAP_TAPCELL_ROW_158_2483 VSS VDD sky130_fd_sc_hd__tapvpwrvgnd_1
XTAP_TAPCELL_ROW_158_2484 VSS VDD sky130_fd_sc_hd__tapvpwrvgnd_1
XTAP_TAPCELL_ROW_158_2485 VSS VDD sky130_fd_sc_hd__tapvpwrvgnd_1
XTAP_TAPCELL_ROW_158_2486 VSS VDD sky130_fd_sc_hd__tapvpwrvgnd_1
XTAP_TAPCELL_ROW_158_2487 VSS VDD sky130_fd_sc_hd__tapvpwrvgnd_1
XTAP_TAPCELL_ROW_158_2488 VSS VDD sky130_fd_sc_hd__tapvpwrvgnd_1
XTAP_TAPCELL_ROW_158_2489 VSS VDD sky130_fd_sc_hd__tapvpwrvgnd_1
XTAP_TAPCELL_ROW_158_2490 VSS VDD sky130_fd_sc_hd__tapvpwrvgnd_1
XTAP_TAPCELL_ROW_158_2491 VSS VDD sky130_fd_sc_hd__tapvpwrvgnd_1
XTAP_TAPCELL_ROW_158_2492 VSS VDD sky130_fd_sc_hd__tapvpwrvgnd_1
XTAP_TAPCELL_ROW_158_2493 VSS VDD sky130_fd_sc_hd__tapvpwrvgnd_1
XTAP_TAPCELL_ROW_158_2494 VSS VDD sky130_fd_sc_hd__tapvpwrvgnd_1
Xclkbuf_leaf_89_clk clknet_4_15_0_clk VSS VSS VDD VDD clknet_leaf_89_clk
+ sky130_fd_sc_hd__clkbuf_16
Xclkbuf_leaf_90_clk clknet_4_15_0_clk VSS VSS VDD VDD clknet_leaf_90_clk
+ sky130_fd_sc_hd__clkbuf_16
Xclkbuf_leaf_91_clk clknet_4_15_0_clk VSS VSS VDD VDD clknet_leaf_91_clk
+ sky130_fd_sc_hd__clkbuf_16
Xclkbuf_leaf_92_clk clknet_4_15_0_clk VSS VSS VDD VDD clknet_leaf_92_clk
+ sky130_fd_sc_hd__clkbuf_16
Xclkbuf_leaf_93_clk clknet_4_15_0_clk VSS VSS VDD VDD clknet_leaf_93_clk
+ sky130_fd_sc_hd__clkbuf_16
Xclkbuf_leaf_94_clk clknet_4_15_0_clk VSS VSS VDD VDD clknet_leaf_94_clk
+ sky130_fd_sc_hd__clkbuf_16
Xclkbuf_leaf_95_clk clknet_4_14_0_clk VSS VSS VDD VDD clknet_leaf_95_clk
+ sky130_fd_sc_hd__clkbuf_16
Xclkbuf_leaf_96_clk clknet_4_14_0_clk VSS VSS VDD VDD clknet_leaf_96_clk
+ sky130_fd_sc_hd__clkbuf_16
Xclkbuf_leaf_97_clk clknet_4_14_0_clk VSS VSS VDD VDD clknet_leaf_97_clk
+ sky130_fd_sc_hd__clkbuf_16
Xclkbuf_leaf_98_clk clknet_4_14_0_clk VSS VSS VDD VDD clknet_leaf_98_clk
+ sky130_fd_sc_hd__clkbuf_16
Xclkbuf_leaf_99_clk clknet_4_13_0_clk VSS VSS VDD VDD clknet_leaf_99_clk
+ sky130_fd_sc_hd__clkbuf_16
Xclkbuf_leaf_100_clk clknet_4_12_0_clk VSS VSS VDD VDD clknet_leaf_100_clk
+ sky130_fd_sc_hd__clkbuf_16
Xclkbuf_leaf_101_clk clknet_4_12_0_clk VSS VSS VDD VDD clknet_leaf_101_clk
+ sky130_fd_sc_hd__clkbuf_16
Xclkbuf_leaf_102_clk clknet_4_12_0_clk VSS VSS VDD VDD clknet_leaf_102_clk
+ sky130_fd_sc_hd__clkbuf_16
Xclkbuf_leaf_103_clk clknet_4_12_0_clk VSS VSS VDD VDD clknet_leaf_103_clk
+ sky130_fd_sc_hd__clkbuf_16
Xclkbuf_leaf_104_clk clknet_4_9_0_clk VSS VSS VDD VDD clknet_leaf_104_clk
+ sky130_fd_sc_hd__clkbuf_16
Xclkbuf_leaf_105_clk clknet_4_12_0_clk VSS VSS VDD VDD clknet_leaf_105_clk
+ sky130_fd_sc_hd__clkbuf_16
Xclkbuf_leaf_106_clk clknet_4_9_0_clk VSS VSS VDD VDD clknet_leaf_106_clk
+ sky130_fd_sc_hd__clkbuf_16
Xclkbuf_leaf_107_clk clknet_4_11_0_clk VSS VSS VDD VDD clknet_leaf_107_clk
+ sky130_fd_sc_hd__clkbuf_16
Xclkbuf_leaf_108_clk clknet_4_14_0_clk VSS VSS VDD VDD clknet_leaf_108_clk
+ sky130_fd_sc_hd__clkbuf_16
Xclkbuf_leaf_109_clk clknet_4_14_0_clk VSS VSS VDD VDD clknet_leaf_109_clk
+ sky130_fd_sc_hd__clkbuf_16
Xclkbuf_leaf_110_clk clknet_4_14_0_clk VSS VSS VDD VDD clknet_leaf_110_clk
+ sky130_fd_sc_hd__clkbuf_16
Xclkbuf_leaf_111_clk clknet_4_14_0_clk VSS VSS VDD VDD clknet_leaf_111_clk
+ sky130_fd_sc_hd__clkbuf_16
Xclkbuf_leaf_112_clk clknet_4_14_0_clk VSS VSS VDD VDD clknet_leaf_112_clk
+ sky130_fd_sc_hd__clkbuf_16
Xclkbuf_leaf_113_clk clknet_4_14_0_clk VSS VSS VDD VDD clknet_leaf_113_clk
+ sky130_fd_sc_hd__clkbuf_16
Xclkbuf_leaf_114_clk clknet_4_11_0_clk VSS VSS VDD VDD clknet_leaf_114_clk
+ sky130_fd_sc_hd__clkbuf_16
Xclkbuf_leaf_115_clk clknet_4_11_0_clk VSS VSS VDD VDD clknet_leaf_115_clk
+ sky130_fd_sc_hd__clkbuf_16
Xclkbuf_leaf_116_clk clknet_4_11_0_clk VSS VSS VDD VDD clknet_leaf_116_clk
+ sky130_fd_sc_hd__clkbuf_16
Xclkbuf_leaf_117_clk clknet_4_11_0_clk VSS VSS VDD VDD clknet_leaf_117_clk
+ sky130_fd_sc_hd__clkbuf_16
Xclkbuf_leaf_118_clk clknet_4_11_0_clk VSS VSS VDD VDD clknet_leaf_118_clk
+ sky130_fd_sc_hd__clkbuf_16
Xclkbuf_leaf_119_clk clknet_4_11_0_clk VSS VSS VDD VDD clknet_leaf_119_clk
+ sky130_fd_sc_hd__clkbuf_16
Xclkbuf_leaf_120_clk clknet_4_11_0_clk VSS VSS VDD VDD clknet_leaf_120_clk
+ sky130_fd_sc_hd__clkbuf_16
Xclkbuf_leaf_121_clk clknet_4_10_0_clk VSS VSS VDD VDD clknet_leaf_121_clk
+ sky130_fd_sc_hd__clkbuf_16
Xclkbuf_leaf_122_clk clknet_4_10_0_clk VSS VSS VDD VDD clknet_leaf_122_clk
+ sky130_fd_sc_hd__clkbuf_16
Xclkbuf_leaf_123_clk clknet_4_10_0_clk VSS VSS VDD VDD clknet_leaf_123_clk
+ sky130_fd_sc_hd__clkbuf_16
Xclkbuf_leaf_124_clk clknet_4_10_0_clk VSS VSS VDD VDD clknet_leaf_124_clk
+ sky130_fd_sc_hd__clkbuf_16
Xclkbuf_leaf_125_clk clknet_4_10_0_clk VSS VSS VDD VDD clknet_leaf_125_clk
+ sky130_fd_sc_hd__clkbuf_16
Xclkbuf_leaf_126_clk clknet_4_10_0_clk VSS VSS VDD VDD clknet_leaf_126_clk
+ sky130_fd_sc_hd__clkbuf_16
Xclkbuf_leaf_127_clk clknet_4_11_0_clk VSS VSS VDD VDD clknet_leaf_127_clk
+ sky130_fd_sc_hd__clkbuf_16
Xclkbuf_leaf_128_clk clknet_4_10_0_clk VSS VSS VDD VDD clknet_leaf_128_clk
+ sky130_fd_sc_hd__clkbuf_16
Xclkbuf_leaf_129_clk clknet_4_10_0_clk VSS VSS VDD VDD clknet_leaf_129_clk
+ sky130_fd_sc_hd__clkbuf_16
Xclkbuf_leaf_130_clk clknet_4_8_0_clk VSS VSS VDD VDD clknet_leaf_130_clk
+ sky130_fd_sc_hd__clkbuf_16
Xclkbuf_leaf_131_clk clknet_4_8_0_clk VSS VSS VDD VDD clknet_leaf_131_clk
+ sky130_fd_sc_hd__clkbuf_16
Xclkbuf_leaf_132_clk clknet_4_8_0_clk VSS VSS VDD VDD clknet_leaf_132_clk
+ sky130_fd_sc_hd__clkbuf_16
Xclkbuf_leaf_133_clk clknet_4_8_0_clk VSS VSS VDD VDD clknet_leaf_133_clk
+ sky130_fd_sc_hd__clkbuf_16
Xclkbuf_leaf_134_clk clknet_4_8_0_clk VSS VSS VDD VDD clknet_leaf_134_clk
+ sky130_fd_sc_hd__clkbuf_16
Xclkbuf_leaf_135_clk clknet_4_8_0_clk VSS VSS VDD VDD clknet_leaf_135_clk
+ sky130_fd_sc_hd__clkbuf_16
Xclkbuf_leaf_136_clk clknet_4_8_0_clk VSS VSS VDD VDD clknet_leaf_136_clk
+ sky130_fd_sc_hd__clkbuf_16
Xclkbuf_leaf_137_clk clknet_4_9_0_clk VSS VSS VDD VDD clknet_leaf_137_clk
+ sky130_fd_sc_hd__clkbuf_16
Xclkbuf_leaf_138_clk clknet_4_9_0_clk VSS VSS VDD VDD clknet_leaf_138_clk
+ sky130_fd_sc_hd__clkbuf_16
Xclkbuf_leaf_139_clk clknet_4_9_0_clk VSS VSS VDD VDD clknet_leaf_139_clk
+ sky130_fd_sc_hd__clkbuf_16
Xclkbuf_leaf_140_clk clknet_4_9_0_clk VSS VSS VDD VDD clknet_leaf_140_clk
+ sky130_fd_sc_hd__clkbuf_16
Xclkbuf_leaf_141_clk clknet_4_9_0_clk VSS VSS VDD VDD clknet_leaf_141_clk
+ sky130_fd_sc_hd__clkbuf_16
Xclkbuf_leaf_142_clk clknet_4_9_0_clk VSS VSS VDD VDD clknet_leaf_142_clk
+ sky130_fd_sc_hd__clkbuf_16
Xclkbuf_leaf_143_clk clknet_4_3_0_clk VSS VSS VDD VDD clknet_leaf_143_clk
+ sky130_fd_sc_hd__clkbuf_16
Xclkbuf_leaf_144_clk clknet_4_3_0_clk VSS VSS VDD VDD clknet_leaf_144_clk
+ sky130_fd_sc_hd__clkbuf_16
Xclkbuf_leaf_145_clk clknet_4_2_0_clk VSS VSS VDD VDD clknet_leaf_145_clk
+ sky130_fd_sc_hd__clkbuf_16
Xclkbuf_leaf_146_clk clknet_4_2_0_clk VSS VSS VDD VDD clknet_leaf_146_clk
+ sky130_fd_sc_hd__clkbuf_16
Xclkbuf_leaf_147_clk clknet_4_2_0_clk VSS VSS VDD VDD clknet_leaf_147_clk
+ sky130_fd_sc_hd__clkbuf_16
Xclkbuf_leaf_148_clk clknet_4_8_0_clk VSS VSS VDD VDD clknet_leaf_148_clk
+ sky130_fd_sc_hd__clkbuf_16
Xclkbuf_leaf_149_clk clknet_4_8_0_clk VSS VSS VDD VDD clknet_leaf_149_clk
+ sky130_fd_sc_hd__clkbuf_16
Xclkbuf_leaf_150_clk clknet_4_8_0_clk VSS VSS VDD VDD clknet_leaf_150_clk
+ sky130_fd_sc_hd__clkbuf_16
Xclkbuf_leaf_151_clk clknet_4_2_0_clk VSS VSS VDD VDD clknet_leaf_151_clk
+ sky130_fd_sc_hd__clkbuf_16
Xclkbuf_leaf_152_clk clknet_4_2_0_clk VSS VSS VDD VDD clknet_leaf_152_clk
+ sky130_fd_sc_hd__clkbuf_16
Xclkbuf_leaf_153_clk clknet_4_2_0_clk VSS VSS VDD VDD clknet_leaf_153_clk
+ sky130_fd_sc_hd__clkbuf_16
Xclkbuf_leaf_154_clk clknet_4_2_0_clk VSS VSS VDD VDD clknet_leaf_154_clk
+ sky130_fd_sc_hd__clkbuf_16
Xclkbuf_leaf_155_clk clknet_4_2_0_clk VSS VSS VDD VDD clknet_leaf_155_clk
+ sky130_fd_sc_hd__clkbuf_16
Xclkbuf_leaf_156_clk clknet_4_2_0_clk VSS VSS VDD VDD clknet_leaf_156_clk
+ sky130_fd_sc_hd__clkbuf_16
Xclkbuf_leaf_157_clk clknet_4_2_0_clk VSS VSS VDD VDD clknet_leaf_157_clk
+ sky130_fd_sc_hd__clkbuf_16
Xclkbuf_leaf_158_clk clknet_4_2_0_clk VSS VSS VDD VDD clknet_leaf_158_clk
+ sky130_fd_sc_hd__clkbuf_16
Xclkbuf_leaf_159_clk clknet_4_0_0_clk VSS VSS VDD VDD clknet_leaf_159_clk
+ sky130_fd_sc_hd__clkbuf_16
Xclkbuf_leaf_160_clk clknet_4_0_0_clk VSS VSS VDD VDD clknet_leaf_160_clk
+ sky130_fd_sc_hd__clkbuf_16
Xclkbuf_0_clk clk VSS VSS VDD VDD clknet_0_clk sky130_fd_sc_hd__clkbuf_16
Xclkbuf_4_0_0_clk clknet_0_clk VSS VSS VDD VDD clknet_4_0_0_clk
+ sky130_fd_sc_hd__clkbuf_16
Xclkbuf_4_1_0_clk clknet_0_clk VSS VSS VDD VDD clknet_4_1_0_clk
+ sky130_fd_sc_hd__clkbuf_16
Xclkbuf_4_2_0_clk clknet_0_clk VSS VSS VDD VDD clknet_4_2_0_clk
+ sky130_fd_sc_hd__clkbuf_16
Xclkbuf_4_3_0_clk clknet_0_clk VSS VSS VDD VDD clknet_4_3_0_clk
+ sky130_fd_sc_hd__clkbuf_16
Xclkbuf_4_4_0_clk clknet_0_clk VSS VSS VDD VDD clknet_4_4_0_clk
+ sky130_fd_sc_hd__clkbuf_16
Xclkbuf_4_5_0_clk clknet_0_clk VSS VSS VDD VDD clknet_4_5_0_clk
+ sky130_fd_sc_hd__clkbuf_16
Xclkbuf_4_6_0_clk clknet_0_clk VSS VSS VDD VDD clknet_4_6_0_clk
+ sky130_fd_sc_hd__clkbuf_16
Xclkbuf_4_7_0_clk clknet_0_clk VSS VSS VDD VDD clknet_4_7_0_clk
+ sky130_fd_sc_hd__clkbuf_16
Xclkbuf_4_8_0_clk clknet_0_clk VSS VSS VDD VDD clknet_4_8_0_clk
+ sky130_fd_sc_hd__clkbuf_16
Xclkbuf_4_9_0_clk clknet_0_clk VSS VSS VDD VDD clknet_4_9_0_clk
+ sky130_fd_sc_hd__clkbuf_16
Xclkbuf_4_10_0_clk clknet_0_clk VSS VSS VDD VDD clknet_4_10_0_clk
+ sky130_fd_sc_hd__clkbuf_16
Xclkbuf_4_11_0_clk clknet_0_clk VSS VSS VDD VDD clknet_4_11_0_clk
+ sky130_fd_sc_hd__clkbuf_16
Xclkbuf_4_12_0_clk clknet_0_clk VSS VSS VDD VDD clknet_4_12_0_clk
+ sky130_fd_sc_hd__clkbuf_16
Xclkbuf_4_13_0_clk clknet_0_clk VSS VSS VDD VDD clknet_4_13_0_clk
+ sky130_fd_sc_hd__clkbuf_16
Xclkbuf_4_14_0_clk clknet_0_clk VSS VSS VDD VDD clknet_4_14_0_clk
+ sky130_fd_sc_hd__clkbuf_16
Xclkbuf_4_15_0_clk clknet_0_clk VSS VSS VDD VDD clknet_4_15_0_clk
+ sky130_fd_sc_hd__clkbuf_16
Xclkload0 clknet_4_0_0_clk VSS VSS VDD VDD _unconnected_138
+ sky130_fd_sc_hd__clkinv_8
Xclkload1 clknet_4_1_0_clk VSS VSS VDD VDD _unconnected_139
+ sky130_fd_sc_hd__clkbuf_16
Xclkload2 clknet_4_3_0_clk VSS VSS VDD VDD _unconnected_140
+ sky130_fd_sc_hd__clkinv_8
Xclkload3 clknet_4_4_0_clk VSS VSS VDD VDD _unconnected_141
+ sky130_fd_sc_hd__inv_16
Xclkload4 clknet_4_5_0_clk VSS VSS VDD VDD _unconnected_142
+ sky130_fd_sc_hd__clkinv_8
Xclkload5 clknet_4_6_0_clk VSS VSS VDD VDD _unconnected_143
+ sky130_fd_sc_hd__inv_6
Xclkload6 clknet_4_7_0_clk VSS VSS VDD VDD _unconnected_144
+ sky130_fd_sc_hd__clkbuf_16
Xclkload7 clknet_4_8_0_clk VSS VSS VDD VDD _unconnected_145
+ sky130_fd_sc_hd__inv_16
Xclkload8 clknet_4_9_0_clk VSS VSS VDD VDD _unconnected_146
+ sky130_fd_sc_hd__clkinv_16
Xclkload9 clknet_4_10_0_clk VSS VSS VDD VDD _unconnected_147
+ sky130_fd_sc_hd__clkinv_16
Xclkload10 clknet_4_11_0_clk VSS VSS VDD VDD _unconnected_148
+ sky130_fd_sc_hd__clkinv_16
Xclkload11 clknet_4_12_0_clk VSS VSS VDD VDD _unconnected_149
+ sky130_fd_sc_hd__clkinv_16
Xclkload12 clknet_4_13_0_clk VSS VSS VDD VDD _unconnected_150
+ sky130_fd_sc_hd__clkinv_16
Xclkload13 clknet_4_14_0_clk VSS VSS VDD VDD _unconnected_151
+ sky130_fd_sc_hd__inv_16
Xclkload14 clknet_4_15_0_clk VSS VSS VDD VDD _unconnected_152
+ sky130_fd_sc_hd__clkinv_16
Xclkload15 clknet_leaf_0_clk VSS VSS VDD VDD _unconnected_153
+ sky130_fd_sc_hd__clkinvlp_4
Xclkload16 clknet_leaf_1_clk VSS VSS VDD VDD _unconnected_154
+ sky130_fd_sc_hd__clkinv_2
Xclkload17 clknet_leaf_3_clk VSS VSS VDD VDD _unconnected_155
+ sky130_fd_sc_hd__clkinv_1
Xclkload18 clknet_leaf_4_clk VSS VSS VDD VDD _unconnected_156
+ sky130_fd_sc_hd__clkinv_2
Xclkload19 clknet_leaf_5_clk VSS VSS VDD VDD _unconnected_157
+ sky130_fd_sc_hd__bufinv_16
Xclkload20 clknet_leaf_7_clk VSS VSS VDD VDD _unconnected_158
+ sky130_fd_sc_hd__clkbuf_1
Xclkload21 clknet_leaf_8_clk VSS VSS VDD VDD _unconnected_159
+ sky130_fd_sc_hd__clkinv_1
Xclkload22 clknet_leaf_15_clk VSS VSS VDD VDD _unconnected_160
+ sky130_fd_sc_hd__clkinv_1
Xclkload23 clknet_leaf_159_clk VSS VSS VDD VDD _unconnected_161
+ sky130_fd_sc_hd__clkinv_4
Xclkload24 clknet_leaf_160_clk VSS VSS VDD VDD _unconnected_162
+ sky130_fd_sc_hd__clkinv_2
Xclkload25 clknet_leaf_9_clk VSS VSS VDD VDD _unconnected_163
+ sky130_fd_sc_hd__clkinv_2
Xclkload26 clknet_leaf_10_clk VSS VSS VDD VDD _unconnected_164
+ sky130_fd_sc_hd__clkinvlp_4
Xclkload27 clknet_leaf_11_clk VSS VSS VDD VDD _unconnected_165
+ sky130_fd_sc_hd__clkinv_2
Xclkload28 clknet_leaf_12_clk VSS VSS VDD VDD _unconnected_166
+ sky130_fd_sc_hd__clkinv_2
Xclkload29 clknet_leaf_13_clk VSS VSS VDD VDD _unconnected_167
+ sky130_fd_sc_hd__bufinv_16
Xclkload30 clknet_leaf_14_clk VSS VSS VDD VDD _unconnected_168
+ sky130_fd_sc_hd__clkinv_2
Xclkload31 clknet_leaf_32_clk VSS VSS VDD VDD _unconnected_169
+ sky130_fd_sc_hd__clkinv_2
Xclkload32 clknet_leaf_33_clk VSS VSS VDD VDD _unconnected_170
+ sky130_fd_sc_hd__bufinv_16
Xclkload33 clknet_leaf_34_clk VSS VSS VDD VDD _unconnected_171
+ sky130_fd_sc_hd__clkinv_1
Xclkload34 clknet_leaf_35_clk VSS VSS VDD VDD _unconnected_172
+ sky130_fd_sc_hd__bufinv_16
Xclkload35 clknet_leaf_37_clk VSS VSS VDD VDD _unconnected_173
+ sky130_fd_sc_hd__bufinv_16
Xclkload36 clknet_leaf_38_clk VSS VSS VDD VDD _unconnected_174
+ sky130_fd_sc_hd__clkinv_1
Xclkload37 clknet_leaf_2_clk VSS VSS VDD VDD _unconnected_175
+ sky130_fd_sc_hd__bufinv_16
Xclkload38 clknet_leaf_16_clk VSS VSS VDD VDD _unconnected_176
+ sky130_fd_sc_hd__clkinv_1
Xclkload39 clknet_leaf_17_clk VSS VSS VDD VDD _unconnected_177
+ sky130_fd_sc_hd__clkinv_2
Xclkload40 clknet_leaf_145_clk VSS VSS VDD VDD _unconnected_178
+ sky130_fd_sc_hd__clkinv_1
Xclkload41 clknet_leaf_146_clk VSS VSS VDD VDD _unconnected_179
+ sky130_fd_sc_hd__clkinv_2
Xclkload42 clknet_leaf_147_clk VSS VSS VDD VDD _unconnected_180
+ sky130_fd_sc_hd__clkinv_2
Xclkload43 clknet_leaf_151_clk VSS VSS VDD VDD _unconnected_181
+ sky130_fd_sc_hd__clkinv_2
Xclkload44 clknet_leaf_152_clk VSS VSS VDD VDD _unconnected_182
+ sky130_fd_sc_hd__bufinv_16
Xclkload45 clknet_leaf_154_clk VSS VSS VDD VDD _unconnected_183
+ sky130_fd_sc_hd__clkinvlp_4
Xclkload46 clknet_leaf_155_clk VSS VSS VDD VDD _unconnected_184
+ sky130_fd_sc_hd__clkinv_1
Xclkload47 clknet_leaf_156_clk VSS VSS VDD VDD _unconnected_185
+ sky130_fd_sc_hd__clkinvlp_4
Xclkload48 clknet_leaf_157_clk VSS VSS VDD VDD _unconnected_186
+ sky130_fd_sc_hd__bufinv_16
Xclkload49 clknet_leaf_158_clk VSS VSS VDD VDD _unconnected_187
+ sky130_fd_sc_hd__clkinv_4
Xclkload50 clknet_leaf_18_clk VSS VSS VDD VDD _unconnected_188
+ sky130_fd_sc_hd__clkinv_1
Xclkload51 clknet_leaf_20_clk VSS VSS VDD VDD _unconnected_189
+ sky130_fd_sc_hd__clkinv_2
Xclkload52 clknet_leaf_21_clk VSS VSS VDD VDD _unconnected_190
+ sky130_fd_sc_hd__clkinv_1
Xclkload53 clknet_leaf_22_clk VSS VSS VDD VDD _unconnected_191
+ sky130_fd_sc_hd__clkinv_1
Xclkload54 clknet_leaf_23_clk VSS VSS VDD VDD _unconnected_192
+ sky130_fd_sc_hd__clkinv_2
Xclkload55 clknet_leaf_24_clk VSS VSS VDD VDD _unconnected_193
+ sky130_fd_sc_hd__clkinv_1
Xclkload56 clknet_leaf_26_clk VSS VSS VDD VDD _unconnected_194
+ sky130_fd_sc_hd__clkbuf_1
Xclkload57 clknet_leaf_27_clk VSS VSS VDD VDD _unconnected_195
+ sky130_fd_sc_hd__bufinv_16
Xclkload58 clknet_leaf_143_clk VSS VSS VDD VDD _unconnected_196
+ sky130_fd_sc_hd__clkinv_1
Xclkload59 clknet_leaf_144_clk VSS VSS VDD VDD _unconnected_197
+ sky130_fd_sc_hd__clkinv_1
Xclkload60 clknet_leaf_39_clk VSS VSS VDD VDD _unconnected_198
+ sky130_fd_sc_hd__clkbuf_1
Xclkload61 clknet_leaf_40_clk VSS VSS VDD VDD _unconnected_199
+ sky130_fd_sc_hd__clkbuf_1
Xclkload62 clknet_leaf_42_clk VSS VSS VDD VDD _unconnected_200
+ sky130_fd_sc_hd__clkinv_2
Xclkload63 clknet_leaf_43_clk VSS VSS VDD VDD _unconnected_201
+ sky130_fd_sc_hd__clkinv_1
Xclkload64 clknet_leaf_44_clk VSS VSS VDD VDD _unconnected_202
+ sky130_fd_sc_hd__clkinv_1
Xclkload65 clknet_leaf_45_clk VSS VSS VDD VDD _unconnected_203
+ sky130_fd_sc_hd__clkbuf_1
Xclkload66 clknet_leaf_48_clk VSS VSS VDD VDD _unconnected_204
+ sky130_fd_sc_hd__clkbuf_1
Xclkload67 clknet_leaf_46_clk VSS VSS VDD VDD _unconnected_205
+ sky130_fd_sc_hd__clkbuf_1
Xclkload68 clknet_leaf_47_clk VSS VSS VDD VDD _unconnected_206
+ sky130_fd_sc_hd__bufinv_16
Xclkload69 clknet_leaf_49_clk VSS VSS VDD VDD _unconnected_207
+ sky130_fd_sc_hd__clkinv_1
Xclkload70 clknet_leaf_50_clk VSS VSS VDD VDD _unconnected_208
+ sky130_fd_sc_hd__clkinvlp_4
Xclkload71 clknet_leaf_51_clk VSS VSS VDD VDD _unconnected_209
+ sky130_fd_sc_hd__bufinv_16
Xclkload72 clknet_leaf_53_clk VSS VSS VDD VDD _unconnected_210
+ sky130_fd_sc_hd__clkbuf_1
Xclkload73 clknet_leaf_54_clk VSS VSS VDD VDD _unconnected_211
+ sky130_fd_sc_hd__bufinv_16
Xclkload74 clknet_leaf_55_clk VSS VSS VDD VDD _unconnected_212
+ sky130_fd_sc_hd__clkinv_2
Xclkload75 clknet_leaf_56_clk VSS VSS VDD VDD _unconnected_213
+ sky130_fd_sc_hd__clkinv_1
Xclkload76 clknet_leaf_57_clk VSS VSS VDD VDD _unconnected_214
+ sky130_fd_sc_hd__clkinv_1
Xclkload77 clknet_leaf_25_clk VSS VSS VDD VDD _unconnected_215
+ sky130_fd_sc_hd__clkinv_2
Xclkload78 clknet_leaf_28_clk VSS VSS VDD VDD _unconnected_216
+ sky130_fd_sc_hd__bufinv_16
Xclkload79 clknet_leaf_29_clk VSS VSS VDD VDD _unconnected_217
+ sky130_fd_sc_hd__bufinv_16
Xclkload80 clknet_leaf_70_clk VSS VSS VDD VDD _unconnected_218
+ sky130_fd_sc_hd__clkinv_2
Xclkload81 clknet_leaf_71_clk VSS VSS VDD VDD _unconnected_219
+ sky130_fd_sc_hd__clkbuf_1
Xclkload82 clknet_leaf_72_clk VSS VSS VDD VDD _unconnected_220
+ sky130_fd_sc_hd__clkinv_1
Xclkload83 clknet_leaf_73_clk VSS VSS VDD VDD _unconnected_221
+ sky130_fd_sc_hd__clkinv_2
Xclkload84 clknet_leaf_74_clk VSS VSS VDD VDD _unconnected_222
+ sky130_fd_sc_hd__bufinv_16
Xclkload85 clknet_leaf_75_clk VSS VSS VDD VDD _unconnected_223
+ sky130_fd_sc_hd__clkinv_2
Xclkload86 clknet_leaf_76_clk VSS VSS VDD VDD _unconnected_224
+ sky130_fd_sc_hd__clkinv_2
Xclkload87 clknet_leaf_77_clk VSS VSS VDD VDD _unconnected_225
+ sky130_fd_sc_hd__clkinv_4
Xclkload88 clknet_leaf_58_clk VSS VSS VDD VDD _unconnected_226
+ sky130_fd_sc_hd__clkinv_2
Xclkload89 clknet_leaf_60_clk VSS VSS VDD VDD _unconnected_227
+ sky130_fd_sc_hd__clkinv_1
Xclkload90 clknet_leaf_61_clk VSS VSS VDD VDD _unconnected_228
+ sky130_fd_sc_hd__clkinv_1
Xclkload91 clknet_leaf_62_clk VSS VSS VDD VDD _unconnected_229
+ sky130_fd_sc_hd__bufinv_16
Xclkload92 clknet_leaf_63_clk VSS VSS VDD VDD _unconnected_230
+ sky130_fd_sc_hd__clkinv_1
Xclkload93 clknet_leaf_64_clk VSS VSS VDD VDD _unconnected_231
+ sky130_fd_sc_hd__clkinv_1
Xclkload94 clknet_leaf_65_clk VSS VSS VDD VDD _unconnected_232
+ sky130_fd_sc_hd__clkinv_1
Xclkload95 clknet_leaf_66_clk VSS VSS VDD VDD _unconnected_233
+ sky130_fd_sc_hd__clkinv_1
Xclkload96 clknet_leaf_67_clk VSS VSS VDD VDD _unconnected_234
+ sky130_fd_sc_hd__clkinv_1
Xclkload97 clknet_leaf_68_clk VSS VSS VDD VDD _unconnected_235
+ sky130_fd_sc_hd__clkinv_2
Xclkload98 clknet_leaf_82_clk VSS VSS VDD VDD _unconnected_236
+ sky130_fd_sc_hd__clkinvlp_4
Xclkload99 clknet_leaf_83_clk VSS VSS VDD VDD _unconnected_237
+ sky130_fd_sc_hd__bufinv_16
Xclkload100 clknet_leaf_130_clk VSS VSS VDD VDD _unconnected_238
+ sky130_fd_sc_hd__clkinv_1
Xclkload101 clknet_leaf_131_clk VSS VSS VDD VDD _unconnected_239
+ sky130_fd_sc_hd__clkinvlp_4
Xclkload102 clknet_leaf_132_clk VSS VSS VDD VDD _unconnected_240
+ sky130_fd_sc_hd__clkinv_2
Xclkload103 clknet_leaf_133_clk VSS VSS VDD VDD _unconnected_241
+ sky130_fd_sc_hd__clkinv_2
Xclkload104 clknet_leaf_135_clk VSS VSS VDD VDD _unconnected_242
+ sky130_fd_sc_hd__clkbuf_8
Xclkload105 clknet_leaf_136_clk VSS VSS VDD VDD _unconnected_243
+ sky130_fd_sc_hd__clkinv_4
Xclkload106 clknet_leaf_148_clk VSS VSS VDD VDD _unconnected_244
+ sky130_fd_sc_hd__clkinvlp_4
Xclkload107 clknet_leaf_149_clk VSS VSS VDD VDD _unconnected_245
+ sky130_fd_sc_hd__clkbuf_8
Xclkload108 clknet_leaf_150_clk VSS VSS VDD VDD _unconnected_246
+ sky130_fd_sc_hd__clkinv_2
Xclkload109 clknet_leaf_104_clk VSS VSS VDD VDD _unconnected_247
+ sky130_fd_sc_hd__clkinv_1
Xclkload110 clknet_leaf_106_clk VSS VSS VDD VDD _unconnected_248
+ sky130_fd_sc_hd__clkinv_2
Xclkload111 clknet_leaf_137_clk VSS VSS VDD VDD _unconnected_249
+ sky130_fd_sc_hd__clkbuf_1
Xclkload112 clknet_leaf_138_clk VSS VSS VDD VDD _unconnected_250
+ sky130_fd_sc_hd__clkbuf_1
Xclkload113 clknet_leaf_139_clk VSS VSS VDD VDD _unconnected_251
+ sky130_fd_sc_hd__clkbuf_1
Xclkload114 clknet_leaf_140_clk VSS VSS VDD VDD _unconnected_252
+ sky130_fd_sc_hd__clkinv_1
Xclkload115 clknet_leaf_141_clk VSS VSS VDD VDD _unconnected_253
+ sky130_fd_sc_hd__clkbuf_1
Xclkload116 clknet_leaf_121_clk VSS VSS VDD VDD _unconnected_254
+ sky130_fd_sc_hd__clkbuf_8
Xclkload117 clknet_leaf_122_clk VSS VSS VDD VDD _unconnected_255
+ sky130_fd_sc_hd__clkbuf_8
Xclkload118 clknet_leaf_123_clk VSS VSS VDD VDD _unconnected_256
+ sky130_fd_sc_hd__clkbuf_8
Xclkload119 clknet_leaf_125_clk VSS VSS VDD VDD _unconnected_257
+ sky130_fd_sc_hd__clkinv_2
Xclkload120 clknet_leaf_126_clk VSS VSS VDD VDD _unconnected_258
+ sky130_fd_sc_hd__clkbuf_1
Xclkload121 clknet_leaf_129_clk VSS VSS VDD VDD _unconnected_259
+ sky130_fd_sc_hd__clkbuf_1
Xclkload122 clknet_leaf_114_clk VSS VSS VDD VDD _unconnected_260
+ sky130_fd_sc_hd__clkbuf_8
Xclkload123 clknet_leaf_115_clk VSS VSS VDD VDD _unconnected_261
+ sky130_fd_sc_hd__clkinv_2
Xclkload124 clknet_leaf_116_clk VSS VSS VDD VDD _unconnected_262
+ sky130_fd_sc_hd__clkinv_2
Xclkload125 clknet_leaf_117_clk VSS VSS VDD VDD _unconnected_263
+ sky130_fd_sc_hd__clkbuf_8
Xclkload126 clknet_leaf_118_clk VSS VSS VDD VDD _unconnected_264
+ sky130_fd_sc_hd__clkbuf_1
Xclkload127 clknet_leaf_119_clk VSS VSS VDD VDD _unconnected_265
+ sky130_fd_sc_hd__clkbuf_1
Xclkload128 clknet_leaf_120_clk VSS VSS VDD VDD _unconnected_266
+ sky130_fd_sc_hd__clkbuf_1
Xclkload129 clknet_leaf_127_clk VSS VSS VDD VDD _unconnected_267
+ sky130_fd_sc_hd__clkbuf_1
Xclkload130 clknet_leaf_78_clk VSS VSS VDD VDD _unconnected_268
+ sky130_fd_sc_hd__clkinv_2
Xclkload131 clknet_leaf_100_clk VSS VSS VDD VDD _unconnected_269
+ sky130_fd_sc_hd__clkbuf_1
Xclkload132 clknet_leaf_102_clk VSS VSS VDD VDD _unconnected_270
+ sky130_fd_sc_hd__clkbuf_1
Xclkload133 clknet_leaf_103_clk VSS VSS VDD VDD _unconnected_271
+ sky130_fd_sc_hd__clkbuf_1
Xclkload134 clknet_leaf_105_clk VSS VSS VDD VDD _unconnected_272
+ sky130_fd_sc_hd__clkinv_2
Xclkload135 clknet_leaf_79_clk VSS VSS VDD VDD _unconnected_273
+ sky130_fd_sc_hd__clkinv_2
Xclkload136 clknet_leaf_80_clk VSS VSS VDD VDD _unconnected_274
+ sky130_fd_sc_hd__clkbuf_8
Xclkload137 clknet_leaf_81_clk VSS VSS VDD VDD _unconnected_275
+ sky130_fd_sc_hd__clkbuf_1
Xclkload138 clknet_leaf_84_clk VSS VSS VDD VDD _unconnected_276
+ sky130_fd_sc_hd__clkinv_4
Xclkload139 clknet_leaf_85_clk VSS VSS VDD VDD _unconnected_277
+ sky130_fd_sc_hd__clkbuf_8
Xclkload140 clknet_leaf_99_clk VSS VSS VDD VDD _unconnected_278
+ sky130_fd_sc_hd__clkinv_1
Xclkload141 clknet_leaf_95_clk VSS VSS VDD VDD _unconnected_279
+ sky130_fd_sc_hd__clkbuf_1
Xclkload142 clknet_leaf_96_clk VSS VSS VDD VDD _unconnected_280
+ sky130_fd_sc_hd__clkinv_1
Xclkload143 clknet_leaf_97_clk VSS VSS VDD VDD _unconnected_281
+ sky130_fd_sc_hd__clkbuf_8
Xclkload144 clknet_leaf_98_clk VSS VSS VDD VDD _unconnected_282
+ sky130_fd_sc_hd__bufinv_16
Xclkload145 clknet_leaf_108_clk VSS VSS VDD VDD _unconnected_283
+ sky130_fd_sc_hd__clkbuf_8
Xclkload146 clknet_leaf_109_clk VSS VSS VDD VDD _unconnected_284
+ sky130_fd_sc_hd__clkbuf_1
Xclkload147 clknet_leaf_110_clk VSS VSS VDD VDD _unconnected_285
+ sky130_fd_sc_hd__clkbuf_8
Xclkload148 clknet_leaf_112_clk VSS VSS VDD VDD _unconnected_286
+ sky130_fd_sc_hd__clkbuf_1
Xclkload149 clknet_leaf_113_clk VSS VSS VDD VDD _unconnected_287
+ sky130_fd_sc_hd__clkbuf_8
Xclkload150 clknet_leaf_87_clk VSS VSS VDD VDD _unconnected_288
+ sky130_fd_sc_hd__clkbuf_8
Xclkload151 clknet_leaf_88_clk VSS VSS VDD VDD _unconnected_289
+ sky130_fd_sc_hd__clkbuf_8
Xclkload152 clknet_leaf_89_clk VSS VSS VDD VDD _unconnected_290
+ sky130_fd_sc_hd__clkbuf_8
Xclkload153 clknet_leaf_90_clk VSS VSS VDD VDD _unconnected_291
+ sky130_fd_sc_hd__clkinv_2
Xclkload154 clknet_leaf_91_clk VSS VSS VDD VDD _unconnected_292
+ sky130_fd_sc_hd__clkinv_1
Xclkload155 clknet_leaf_92_clk VSS VSS VDD VDD _unconnected_293
+ sky130_fd_sc_hd__clkinv_1
Xclkload156 clknet_leaf_93_clk VSS VSS VDD VDD _unconnected_294
+ sky130_fd_sc_hd__clkbuf_1
Xhold786 resetn VSS VSS VDD VDD net777 sky130_fd_sc_hd__dlygate4sd3_1
Xhold787 mem_rdata[1] VSS VSS VDD VDD net778 sky130_fd_sc_hd__dlygate4sd3_1
Xhold788 mem_rdata[4] VSS VSS VDD VDD net779 sky130_fd_sc_hd__dlygate4sd3_1
Xhold789 mem_rdata[0] VSS VSS VDD VDD net780 sky130_fd_sc_hd__dlygate4sd3_1
Xhold790 mem_rdata[3] VSS VSS VDD VDD net781 sky130_fd_sc_hd__dlygate4sd3_1
Xhold791 mem_rdata[2] VSS VSS VDD VDD net782 sky130_fd_sc_hd__dlygate4sd3_1
Xhold792 mem_rdata[6] VSS VSS VDD VDD net783 sky130_fd_sc_hd__dlygate4sd3_1
Xhold793 mem_ready VSS VSS VDD VDD net784 sky130_fd_sc_hd__dlygate4sd3_1
Xhold794 mem_rdata[5] VSS VSS VDD VDD net785 sky130_fd_sc_hd__dlygate4sd3_1
Xhold795 mem_rdata[14] VSS VSS VDD VDD net786 sky130_fd_sc_hd__dlygate4sd3_1
Xhold796 mem_rdata[12] VSS VSS VDD VDD net787 sky130_fd_sc_hd__dlygate4sd3_1
Xhold797 mem_rdata[13] VSS VSS VDD VDD net788 sky130_fd_sc_hd__dlygate4sd3_1
Xhold798 mem_rdata[7] VSS VSS VDD VDD net789 sky130_fd_sc_hd__dlygate4sd3_1
XANTENNA_1 _2368_ VSS VSS VDD VDD sky130_fd_sc_hd__diode_2
XANTENNA_2 net728 VSS VSS VDD VDD sky130_fd_sc_hd__diode_2
XANTENNA_3 _3145_ VSS VSS VDD VDD sky130_fd_sc_hd__diode_2
XANTENNA_4 _4568_ VSS VSS VDD VDD sky130_fd_sc_hd__diode_2
XANTENNA_5 alu_out_q\[2\] VSS VSS VDD VDD sky130_fd_sc_hd__diode_2
XANTENNA_6 net148 VSS VSS VDD VDD sky130_fd_sc_hd__diode_2
.ENDS picorv32
* Copyright 2020 The SkyWater PDK Authors
*
* Licensed under the Apache License, Version 2.0 (the "License");
* you may not use this file except in compliance with the License.
* You may obtain a copy of the License at
*
*     https:  www.apache.org licenses LICENSE-2.0
*
* Unless required by applicable law or agreed to in writing, software
* distributed under the License is distributed on an "AS IS" BASIS,
* WITHOUT WARRANTIES OR CONDITIONS OF ANY KIND, either express or implied.
* See the License for the specific language governing permissions and
* limitations under the License.
*
* SPDX-License-Identifier: Apache-2.0

.SUBCKT sky130_fd_sc_hd__a2111o_1 A1 A2 B1 C1 D1 VGND VNB VNB net59 X
*.PININFO A1:I A2:I B1:I C1:I D1:I VGND:I VNB:I VNB:I net59:I X:O
MMPA0 pndA A1 net59 VNB sky130_fd_pr__pfet_01v8_hvt m=1 w=1.0u l=0.15u mult=1 sa=0.265
+ sb=0.265 sd=0.28 area=0.063 perim=1.14
MMPA1 pndA A2 net59 VNB sky130_fd_pr__pfet_01v8_hvt m=1 w=1.0u l=0.15u mult=1 sa=0.265
+ sb=0.265 sd=0.28 area=0.063 perim=1.14
MMPB0 pndB B1 pndA VNB sky130_fd_pr__pfet_01v8_hvt m=1 w=1.0u l=0.15u mult=1 sa=0.265
+ sb=0.265 sd=0.28 area=0.063 perim=1.14
MMPC0 pndC C1 pndB VNB sky130_fd_pr__pfet_01v8_hvt m=1 w=1.0u l=0.15u mult=1 sa=0.265
+ sb=0.265 sd=0.28 area=0.063 perim=1.14
MMPD0 y D1 pndC VNB sky130_fd_pr__pfet_01v8_hvt m=1 w=1.0u l=0.15u mult=1 sa=0.265
+ sb=0.265 sd=0.28 area=0.063 perim=1.14
MMIPX X y net59 VNB sky130_fd_pr__pfet_01v8_hvt m=1 w=1.0u l=0.15u mult=1 sa=0.265
+ sb=0.265 sd=0.28 area=0.063 perim=1.14
MMNA0 y A1 sndA1 VNB sky130_fd_pr__nfet_01v8 m=1 w=0.65u l=0.15u mult=1 sa=0.265
+ sb=0.265 sd=0.28 area=0.063 perim=1.14
MMNA1 sndA1 A2 VGND VNB sky130_fd_pr__nfet_01v8 m=1 w=0.65u l=0.15u mult=1 sa=0.265
+ sb=0.265 sd=0.28 area=0.063 perim=1.14
MMNB0 y B1 VGND VNB sky130_fd_pr__nfet_01v8 m=1 w=0.65u l=0.15u mult=1 sa=0.265
+ sb=0.265 sd=0.28 area=0.063 perim=1.14
MMNC0 y C1 VGND VNB sky130_fd_pr__nfet_01v8 m=1 w=0.65u l=0.15u mult=1 sa=0.265
+ sb=0.265 sd=0.28 area=0.063 perim=1.14
MMND0 y D1 VGND VNB sky130_fd_pr__nfet_01v8 m=1 w=0.65u l=0.15u mult=1 sa=0.265
+ sb=0.265 sd=0.28 area=0.063 perim=1.14
MMINX X y VGND VNB sky130_fd_pr__nfet_01v8 m=1 w=0.65u l=0.15u mult=1 sa=0.265
+ sb=0.265 sd=0.28 area=0.063 perim=1.14
.ENDS sky130_fd_sc_hd__a2111o_1
* Copyright 2020 The SkyWater PDK Authors
*
* Licensed under the Apache License, Version 2.0 (the "License");
* you may not use this file except in compliance with the License.
* You may obtain a copy of the License at
*
*     https:  www.apache.org licenses LICENSE-2.0
*
* Unless required by applicable law or agreed to in writing, software
* distributed under the License is distributed on an "AS IS" BASIS,
* WITHOUT WARRANTIES OR CONDITIONS OF ANY KIND, either express or implied.
* See the License for the specific language governing permissions and
* limitations under the License.
*
* SPDX-License-Identifier: Apache-2.0

.SUBCKT sky130_fd_sc_hd__a2111o_2 A1 A2 B1 C1 D1 VGND VNB VNB net59 X
*.PININFO A1:I A2:I B1:I C1:I D1:I VGND:I VNB:I VNB:I net59:I X:O
MMPA0 pndA A1 net59 VNB sky130_fd_pr__pfet_01v8_hvt m=1 w=1.0u l=0.15u mult=1 sa=0.265
+ sb=0.265 sd=0.28 area=0.063 perim=1.14
MMPA1 pndA A2 net59 VNB sky130_fd_pr__pfet_01v8_hvt m=1 w=1.0u l=0.15u mult=1 sa=0.265
+ sb=0.265 sd=0.28 area=0.063 perim=1.14
MMPB0 pndB B1 pndA VNB sky130_fd_pr__pfet_01v8_hvt m=1 w=1.0u l=0.15u mult=1 sa=0.265
+ sb=0.265 sd=0.28 area=0.063 perim=1.14
MMPC0 pndC C1 pndB VNB sky130_fd_pr__pfet_01v8_hvt m=1 w=1.0u l=0.15u mult=1 sa=0.265
+ sb=0.265 sd=0.28 area=0.063 perim=1.14
MMPD0 y D1 pndC VNB sky130_fd_pr__pfet_01v8_hvt m=1 w=1.0u l=0.15u mult=1 sa=0.265
+ sb=0.265 sd=0.28 area=0.063 perim=1.14
MMIPX X y net59 VNB sky130_fd_pr__pfet_01v8_hvt m=2 w=1.0u l=0.15u mult=1 sa=0.265
+ sb=0.265 sd=0.28 area=0.063 perim=1.14
MMNA0 y A1 sndA1 VNB sky130_fd_pr__nfet_01v8 m=1 w=0.65u l=0.15u mult=1 sa=0.265
+ sb=0.265 sd=0.28 area=0.063 perim=1.14
MMNA1 sndA1 A2 VGND VNB sky130_fd_pr__nfet_01v8 m=1 w=0.65u l=0.15u mult=1 sa=0.265
+ sb=0.265 sd=0.28 area=0.063 perim=1.14
MMNB0 y B1 VGND VNB sky130_fd_pr__nfet_01v8 m=1 w=0.65u l=0.15u mult=1 sa=0.265
+ sb=0.265 sd=0.28 area=0.063 perim=1.14
MMNC0 y C1 VGND VNB sky130_fd_pr__nfet_01v8 m=1 w=0.65u l=0.15u mult=1 sa=0.265
+ sb=0.265 sd=0.28 area=0.063 perim=1.14
MMND0 y D1 VGND VNB sky130_fd_pr__nfet_01v8 m=1 w=0.65u l=0.15u mult=1 sa=0.265
+ sb=0.265 sd=0.28 area=0.063 perim=1.14
MMINX X y VGND VNB sky130_fd_pr__nfet_01v8 m=2 w=0.65u l=0.15u mult=1 sa=0.265
+ sb=0.265 sd=0.28 area=0.063 perim=1.14
.ENDS sky130_fd_sc_hd__a2111o_2
* Copyright 2020 The SkyWater PDK Authors
*
* Licensed under the Apache License, Version 2.0 (the "License");
* you may not use this file except in compliance with the License.
* You may obtain a copy of the License at
*
*     https:  www.apache.org licenses LICENSE-2.0
*
* Unless required by applicable law or agreed to in writing, software
* distributed under the License is distributed on an "AS IS" BASIS,
* WITHOUT WARRANTIES OR CONDITIONS OF ANY KIND, either express or implied.
* See the License for the specific language governing permissions and
* limitations under the License.
*
* SPDX-License-Identifier: Apache-2.0

.SUBCKT sky130_fd_sc_hd__a2111o_4 A1 A2 B1 C1 D1 VGND VNB VNB net59 X
*.PININFO A1:I A2:I B1:I C1:I D1:I VGND:I VNB:I VNB:I net59:I X:O
MMPA0 pndA A1 net59 VNB sky130_fd_pr__pfet_01v8_hvt m=2 w=1.0u l=0.15u mult=1 sa=0.265
+ sb=0.265 sd=0.28 area=0.063 perim=1.14
MMPA1 pndA A2 net59 VNB sky130_fd_pr__pfet_01v8_hvt m=2 w=1.0u l=0.15u mult=1 sa=0.265
+ sb=0.265 sd=0.28 area=0.063 perim=1.14
MMPB0 pndB B1 pndA VNB sky130_fd_pr__pfet_01v8_hvt m=2 w=1.0u l=0.15u mult=1 sa=0.265
+ sb=0.265 sd=0.28 area=0.063 perim=1.14
MMPC0 pndC C1 pndB VNB sky130_fd_pr__pfet_01v8_hvt m=2 w=1.0u l=0.15u mult=1 sa=0.265
+ sb=0.265 sd=0.28 area=0.063 perim=1.14
MMPD0 y D1 pndC VNB sky130_fd_pr__pfet_01v8_hvt m=2 w=1.0u l=0.15u mult=1 sa=0.265
+ sb=0.265 sd=0.28 area=0.063 perim=1.14
MMIPX X y net59 VNB sky130_fd_pr__pfet_01v8_hvt m=4 w=1.0u l=0.15u mult=1 sa=0.265
+ sb=0.265 sd=0.28 area=0.063 perim=1.14
MMNA0 y A1 sndA1 VNB sky130_fd_pr__nfet_01v8 m=2 w=0.65u l=0.15u mult=1 sa=0.265
+ sb=0.265 sd=0.28 area=0.063 perim=1.14
MMNA1 sndA1 A2 VGND VNB sky130_fd_pr__nfet_01v8 m=2 w=0.65u l=0.15u mult=1 sa=0.265
+ sb=0.265 sd=0.28 area=0.063 perim=1.14
MMNB0 y B1 VGND VNB sky130_fd_pr__nfet_01v8 m=2 w=0.65u l=0.15u mult=1 sa=0.265
+ sb=0.265 sd=0.28 area=0.063 perim=1.14
MMNC0 y C1 VGND VNB sky130_fd_pr__nfet_01v8 m=2 w=0.65u l=0.15u mult=1 sa=0.265
+ sb=0.265 sd=0.28 area=0.063 perim=1.14
MMND0 y D1 VGND VNB sky130_fd_pr__nfet_01v8 m=2 w=0.65u l=0.15u mult=1 sa=0.265
+ sb=0.265 sd=0.28 area=0.063 perim=1.14
MMINX X y VGND VNB sky130_fd_pr__nfet_01v8 m=4 w=0.65u l=0.15u mult=1 sa=0.265
+ sb=0.265 sd=0.28 area=0.063 perim=1.14
.ENDS sky130_fd_sc_hd__a2111o_4
* Copyright 2020 The SkyWater PDK Authors
*
* Licensed under the Apache License, Version 2.0 (the "License");
* you may not use this file except in compliance with the License.
* You may obtain a copy of the License at
*
*     https:  www.apache.org licenses LICENSE-2.0
*
* Unless required by applicable law or agreed to in writing, software
* distributed under the License is distributed on an "AS IS" BASIS,
* WITHOUT WARRANTIES OR CONDITIONS OF ANY KIND, either express or implied.
* See the License for the specific language governing permissions and
* limitations under the License.
*
* SPDX-License-Identifier: Apache-2.0

.SUBCKT sky130_fd_sc_hd__a2111oi_0 A1 A2 B1 C1 D1 VGND VNB VNB net59 Y
*.PININFO A1:I A2:I B1:I C1:I D1:I VGND:I VNB:I VNB:I net59:I Y:O
MMPA0 pndA A1 net59 VNB sky130_fd_pr__pfet_01v8_hvt m=1 w=0.64u l=0.15u mult=1 sa=0.265
+ sb=0.265 sd=0.28 area=0.063 perim=1.14
MMPA1 pndA A2 net59 VNB sky130_fd_pr__pfet_01v8_hvt m=1 w=0.64u l=0.15u mult=1 sa=0.265
+ sb=0.265 sd=0.28 area=0.063 perim=1.14
MMPB0 pndB B1 pndA VNB sky130_fd_pr__pfet_01v8_hvt m=1 w=0.64u l=0.15u mult=1 sa=0.265
+ sb=0.265 sd=0.28 area=0.063 perim=1.14
MMPC0 pndC C1 pndB VNB sky130_fd_pr__pfet_01v8_hvt m=1 w=0.64u l=0.15u mult=1 sa=0.265
+ sb=0.265 sd=0.28 area=0.063 perim=1.14
MMPD0 Y D1 pndC VNB sky130_fd_pr__pfet_01v8_hvt m=1 w=0.64u l=0.15u mult=1 sa=0.265
+ sb=0.265 sd=0.28 area=0.063 perim=1.14
MMNA0 Y A1 sndA1 VNB sky130_fd_pr__nfet_01v8 m=1 w=0.42u l=0.15u mult=1 sa=0.265
+ sb=0.265 sd=0.28 area=0.063 perim=1.14
MMNA1 sndA1 A2 VGND VNB sky130_fd_pr__nfet_01v8 m=1 w=0.42u l=0.15u mult=1 sa=0.265
+ sb=0.265 sd=0.28 area=0.063 perim=1.14
MMNB0 Y B1 VGND VNB sky130_fd_pr__nfet_01v8 m=1 w=0.42u l=0.15u mult=1 sa=0.265
+ sb=0.265 sd=0.28 area=0.063 perim=1.14
MMNC0 Y C1 VGND VNB sky130_fd_pr__nfet_01v8 m=1 w=0.42u l=0.15u mult=1 sa=0.265
+ sb=0.265 sd=0.28 area=0.063 perim=1.14
MMND0 Y D1 VGND VNB sky130_fd_pr__nfet_01v8 m=1 w=0.42u l=0.15u mult=1 sa=0.265
+ sb=0.265 sd=0.28 area=0.063 perim=1.14
.ENDS sky130_fd_sc_hd__a2111oi_0
* Copyright 2020 The SkyWater PDK Authors
*
* Licensed under the Apache License, Version 2.0 (the "License");
* you may not use this file except in compliance with the License.
* You may obtain a copy of the License at
*
*     https:  www.apache.org licenses LICENSE-2.0
*
* Unless required by applicable law or agreed to in writing, software
* distributed under the License is distributed on an "AS IS" BASIS,
* WITHOUT WARRANTIES OR CONDITIONS OF ANY KIND, either express or implied.
* See the License for the specific language governing permissions and
* limitations under the License.
*
* SPDX-License-Identifier: Apache-2.0

.SUBCKT sky130_fd_sc_hd__a2111oi_1 A1 A2 B1 C1 D1 VGND VNB VNB net59 Y
*.PININFO A1:I A2:I B1:I C1:I D1:I VGND:I VNB:I VNB:I net59:I Y:O
MMPA0 pndA A1 net59 VNB sky130_fd_pr__pfet_01v8_hvt m=1 w=1.0u l=0.15u mult=1 sa=0.265
+ sb=0.265 sd=0.28 area=0.063 perim=1.14
MMPA1 pndA A2 net59 VNB sky130_fd_pr__pfet_01v8_hvt m=1 w=1.0u l=0.15u mult=1 sa=0.265
+ sb=0.265 sd=0.28 area=0.063 perim=1.14
MMPB0 pndB B1 pndA VNB sky130_fd_pr__pfet_01v8_hvt m=1 w=1.0u l=0.15u mult=1 sa=0.265
+ sb=0.265 sd=0.28 area=0.063 perim=1.14
MMPC0 pndC C1 pndB VNB sky130_fd_pr__pfet_01v8_hvt m=1 w=1.0u l=0.15u mult=1 sa=0.265
+ sb=0.265 sd=0.28 area=0.063 perim=1.14
MMPD0 Y D1 pndC VNB sky130_fd_pr__pfet_01v8_hvt m=1 w=1.0u l=0.15u mult=1 sa=0.265
+ sb=0.265 sd=0.28 area=0.063 perim=1.14
MMNA0 Y A1 sndA1 VNB sky130_fd_pr__nfet_01v8 m=1 w=0.65u l=0.15u mult=1 sa=0.265
+ sb=0.265 sd=0.28 area=0.063 perim=1.14
MMNA1 sndA1 A2 VGND VNB sky130_fd_pr__nfet_01v8 m=1 w=0.65u l=0.15u mult=1 sa=0.265
+ sb=0.265 sd=0.28 area=0.063 perim=1.14
MMNB0 Y B1 VGND VNB sky130_fd_pr__nfet_01v8 m=1 w=0.65u l=0.15u mult=1 sa=0.265
+ sb=0.265 sd=0.28 area=0.063 perim=1.14
MMNC0 Y C1 VGND VNB sky130_fd_pr__nfet_01v8 m=1 w=0.65u l=0.15u mult=1 sa=0.265
+ sb=0.265 sd=0.28 area=0.063 perim=1.14
MMND0 Y D1 VGND VNB sky130_fd_pr__nfet_01v8 m=1 w=0.65u l=0.15u mult=1 sa=0.265
+ sb=0.265 sd=0.28 area=0.063 perim=1.14
.ENDS sky130_fd_sc_hd__a2111oi_1
* Copyright 2020 The SkyWater PDK Authors
*
* Licensed under the Apache License, Version 2.0 (the "License");
* you may not use this file except in compliance with the License.
* You may obtain a copy of the License at
*
*     https:  www.apache.org licenses LICENSE-2.0
*
* Unless required by applicable law or agreed to in writing, software
* distributed under the License is distributed on an "AS IS" BASIS,
* WITHOUT WARRANTIES OR CONDITIONS OF ANY KIND, either express or implied.
* See the License for the specific language governing permissions and
* limitations under the License.
*
* SPDX-License-Identifier: Apache-2.0

.SUBCKT sky130_fd_sc_hd__a2111oi_2 A1 A2 B1 C1 D1 VGND VNB VNB net59 Y
*.PININFO A1:I A2:I B1:I C1:I D1:I VGND:I VNB:I VNB:I net59:I Y:O
MMPA0 pndA A1 net59 VNB sky130_fd_pr__pfet_01v8_hvt m=2 w=1.0u l=0.15u mult=1 sa=0.265
+ sb=0.265 sd=0.28 area=0.063 perim=1.14
MMPA1 pndA A2 net59 VNB sky130_fd_pr__pfet_01v8_hvt m=2 w=1.0u l=0.15u mult=1 sa=0.265
+ sb=0.265 sd=0.28 area=0.063 perim=1.14
MMPB0 pndB B1 pndA VNB sky130_fd_pr__pfet_01v8_hvt m=2 w=1.0u l=0.15u mult=1 sa=0.265
+ sb=0.265 sd=0.28 area=0.063 perim=1.14
MMPC0 pndC C1 pndB VNB sky130_fd_pr__pfet_01v8_hvt m=2 w=1.0u l=0.15u mult=1 sa=0.265
+ sb=0.265 sd=0.28 area=0.063 perim=1.14
MMPD0 Y D1 pndC VNB sky130_fd_pr__pfet_01v8_hvt m=2 w=1.0u l=0.15u mult=1 sa=0.265
+ sb=0.265 sd=0.28 area=0.063 perim=1.14
MMNA0 Y A1 sndA1 VNB sky130_fd_pr__nfet_01v8 m=2 w=0.65u l=0.15u mult=1 sa=0.265
+ sb=0.265 sd=0.28 area=0.063 perim=1.14
MMNA1 sndA1 A2 VGND VNB sky130_fd_pr__nfet_01v8 m=2 w=0.65u l=0.15u mult=1 sa=0.265
+ sb=0.265 sd=0.28 area=0.063 perim=1.14
MMNB0 Y B1 VGND VNB sky130_fd_pr__nfet_01v8 m=2 w=0.65u l=0.15u mult=1 sa=0.265
+ sb=0.265 sd=0.28 area=0.063 perim=1.14
MMNC0 Y C1 VGND VNB sky130_fd_pr__nfet_01v8 m=2 w=0.65u l=0.15u mult=1 sa=0.265
+ sb=0.265 sd=0.28 area=0.063 perim=1.14
MMND0 Y D1 VGND VNB sky130_fd_pr__nfet_01v8 m=2 w=0.65u l=0.15u mult=1 sa=0.265
+ sb=0.265 sd=0.28 area=0.063 perim=1.14
.ENDS sky130_fd_sc_hd__a2111oi_2
* Copyright 2020 The SkyWater PDK Authors
*
* Licensed under the Apache License, Version 2.0 (the "License");
* you may not use this file except in compliance with the License.
* You may obtain a copy of the License at
*
*     https:  www.apache.org licenses LICENSE-2.0
*
* Unless required by applicable law or agreed to in writing, software
* distributed under the License is distributed on an "AS IS" BASIS,
* WITHOUT WARRANTIES OR CONDITIONS OF ANY KIND, either express or implied.
* See the License for the specific language governing permissions and
* limitations under the License.
*
* SPDX-License-Identifier: Apache-2.0

.SUBCKT sky130_fd_sc_hd__a2111oi_4 A1 A2 B1 C1 D1 VGND VNB VNB net59 Y
*.PININFO A1:I A2:I B1:I C1:I D1:I VGND:I VNB:I VNB:I net59:I Y:O
MMPA0 pndA A1 net59 VNB sky130_fd_pr__pfet_01v8_hvt m=4 w=1.0u l=0.15u mult=1 sa=0.265
+ sb=0.265 sd=0.28 area=0.063 perim=1.14
MMPA1 pndA A2 net59 VNB sky130_fd_pr__pfet_01v8_hvt m=4 w=1.0u l=0.15u mult=1 sa=0.265
+ sb=0.265 sd=0.28 area=0.063 perim=1.14
MMPB0 pndB B1 pndA VNB sky130_fd_pr__pfet_01v8_hvt m=4 w=1.0u l=0.15u mult=1 sa=0.265
+ sb=0.265 sd=0.28 area=0.063 perim=1.14
MMPC0 pndC C1 pndB VNB sky130_fd_pr__pfet_01v8_hvt m=4 w=1.0u l=0.15u mult=1 sa=0.265
+ sb=0.265 sd=0.28 area=0.063 perim=1.14
MMPD0 Y D1 pndC VNB sky130_fd_pr__pfet_01v8_hvt m=4 w=1.0u l=0.15u mult=1 sa=0.265
+ sb=0.265 sd=0.28 area=0.063 perim=1.14
MMNA0 Y A1 sndA1 VNB sky130_fd_pr__nfet_01v8 m=4 w=0.65u l=0.15u mult=1 sa=0.265
+ sb=0.265 sd=0.28 area=0.063 perim=1.14
MMNA1 sndA1 A2 VGND VNB sky130_fd_pr__nfet_01v8 m=4 w=0.65u l=0.15u mult=1 sa=0.265
+ sb=0.265 sd=0.28 area=0.063 perim=1.14
MMNB0 Y B1 VGND VNB sky130_fd_pr__nfet_01v8 m=4 w=0.65u l=0.15u mult=1 sa=0.265
+ sb=0.265 sd=0.28 area=0.063 perim=1.14
MMNC0 Y C1 VGND VNB sky130_fd_pr__nfet_01v8 m=4 w=0.65u l=0.15u mult=1 sa=0.265
+ sb=0.265 sd=0.28 area=0.063 perim=1.14
MMND0 Y D1 VGND VNB sky130_fd_pr__nfet_01v8 m=4 w=0.65u l=0.15u mult=1 sa=0.265
+ sb=0.265 sd=0.28 area=0.063 perim=1.14
.ENDS sky130_fd_sc_hd__a2111oi_4
* Copyright 2020 The SkyWater PDK Authors
*
* Licensed under the Apache License, Version 2.0 (the "License");
* you may not use this file except in compliance with the License.
* You may obtain a copy of the License at
*
*     https:  www.apache.org licenses LICENSE-2.0
*
* Unless required by applicable law or agreed to in writing, software
* distributed under the License is distributed on an "AS IS" BASIS,
* WITHOUT WARRANTIES OR CONDITIONS OF ANY KIND, either express or implied.
* See the License for the specific language governing permissions and
* limitations under the License.
*
* SPDX-License-Identifier: Apache-2.0

.SUBCKT sky130_fd_sc_hd__a211o_1 A1 A2 B1 C1 VGND VNB VNB net59 X
*.PININFO A1:I A2:I B1:I C1:I VGND:I VNB:I VNB:I net59:I X:O
MMPA0 pndA A1 net59 VNB sky130_fd_pr__pfet_01v8_hvt m=1 w=1.0u l=0.15u mult=1 sa=0.265
+ sb=0.265 sd=0.28 area=0.063 perim=1.14
MMPA1 pndA A2 net59 VNB sky130_fd_pr__pfet_01v8_hvt m=1 w=1.0u l=0.15u mult=1 sa=0.265
+ sb=0.265 sd=0.28 area=0.063 perim=1.14
MMPB0 pndB B1 pndA VNB sky130_fd_pr__pfet_01v8_hvt m=1 w=1.0u l=0.15u mult=1 sa=0.265
+ sb=0.265 sd=0.28 area=0.063 perim=1.14
MMPC0 y C1 pndB VNB sky130_fd_pr__pfet_01v8_hvt m=1 w=1.0u l=0.15u mult=1 sa=0.265
+ sb=0.265 sd=0.28 area=0.063 perim=1.14
MMIPX X y net59 VNB sky130_fd_pr__pfet_01v8_hvt m=1 w=1.0u l=0.15u mult=1 sa=0.265
+ sb=0.265 sd=0.28 area=0.063 perim=1.14
MMNA0 y A1 sndA1 VNB sky130_fd_pr__nfet_01v8 m=1 w=0.65u l=0.15u mult=1 sa=0.265
+ sb=0.265 sd=0.28 area=0.063 perim=1.14
MMNA1 sndA1 A2 VGND VNB sky130_fd_pr__nfet_01v8 m=1 w=0.65u l=0.15u mult=1 sa=0.265
+ sb=0.265 sd=0.28 area=0.063 perim=1.14
MMNB0 y B1 VGND VNB sky130_fd_pr__nfet_01v8 m=1 w=0.65u l=0.15u mult=1 sa=0.265
+ sb=0.265 sd=0.28 area=0.063 perim=1.14
MMNC0 y C1 VGND VNB sky130_fd_pr__nfet_01v8 m=1 w=0.65u l=0.15u mult=1 sa=0.265
+ sb=0.265 sd=0.28 area=0.063 perim=1.14
MMINX X y VGND VNB sky130_fd_pr__nfet_01v8 m=1 w=0.65u l=0.15u mult=1 sa=0.265
+ sb=0.265 sd=0.28 area=0.063 perim=1.14
.ENDS sky130_fd_sc_hd__a211o_1
* Copyright 2020 The SkyWater PDK Authors
*
* Licensed under the Apache License, Version 2.0 (the "License");
* you may not use this file except in compliance with the License.
* You may obtain a copy of the License at
*
*     https:  www.apache.org licenses LICENSE-2.0
*
* Unless required by applicable law or agreed to in writing, software
* distributed under the License is distributed on an "AS IS" BASIS,
* WITHOUT WARRANTIES OR CONDITIONS OF ANY KIND, either express or implied.
* See the License for the specific language governing permissions and
* limitations under the License.
*
* SPDX-License-Identifier: Apache-2.0

.SUBCKT sky130_fd_sc_hd__a211o_2 A1 A2 B1 C1 VGND VNB VNB net59 X
*.PININFO A1:I A2:I B1:I C1:I VGND:I VNB:I VNB:I net59:I X:O
MMPA0 pndA A1 net59 VNB sky130_fd_pr__pfet_01v8_hvt m=1 w=1.0u l=0.15u mult=1 sa=0.265
+ sb=0.265 sd=0.28 area=0.063 perim=1.14
MMPA1 pndA A2 net59 VNB sky130_fd_pr__pfet_01v8_hvt m=1 w=1.0u l=0.15u mult=1 sa=0.265
+ sb=0.265 sd=0.28 area=0.063 perim=1.14
MMPB0 pndB B1 pndA VNB sky130_fd_pr__pfet_01v8_hvt m=1 w=1.0u l=0.15u mult=1 sa=0.265
+ sb=0.265 sd=0.28 area=0.063 perim=1.14
MMPC0 y C1 pndB VNB sky130_fd_pr__pfet_01v8_hvt m=1 w=1.0u l=0.15u mult=1 sa=0.265
+ sb=0.265 sd=0.28 area=0.063 perim=1.14
MMIPX X y net59 VNB sky130_fd_pr__pfet_01v8_hvt m=2 w=1.0u l=0.15u mult=1 sa=0.265
+ sb=0.265 sd=0.28 area=0.063 perim=1.14
MMNA0 y A1 sndA1 VNB sky130_fd_pr__nfet_01v8 m=1 w=0.65u l=0.15u mult=1 sa=0.265
+ sb=0.265 sd=0.28 area=0.063 perim=1.14
MMNA1 sndA1 A2 VGND VNB sky130_fd_pr__nfet_01v8 m=1 w=0.65u l=0.15u mult=1 sa=0.265
+ sb=0.265 sd=0.28 area=0.063 perim=1.14
MMNB0 y B1 VGND VNB sky130_fd_pr__nfet_01v8 m=1 w=0.65u l=0.15u mult=1 sa=0.265
+ sb=0.265 sd=0.28 area=0.063 perim=1.14
MMNC0 y C1 VGND VNB sky130_fd_pr__nfet_01v8 m=1 w=0.65u l=0.15u mult=1 sa=0.265
+ sb=0.265 sd=0.28 area=0.063 perim=1.14
MMINX X y VGND VNB sky130_fd_pr__nfet_01v8 m=2 w=0.65u l=0.15u mult=1 sa=0.265
+ sb=0.265 sd=0.28 area=0.063 perim=1.14
.ENDS sky130_fd_sc_hd__a211o_2
* Copyright 2020 The SkyWater PDK Authors
*
* Licensed under the Apache License, Version 2.0 (the "License");
* you may not use this file except in compliance with the License.
* You may obtain a copy of the License at
*
*     https:  www.apache.org licenses LICENSE-2.0
*
* Unless required by applicable law or agreed to in writing, software
* distributed under the License is distributed on an "AS IS" BASIS,
* WITHOUT WARRANTIES OR CONDITIONS OF ANY KIND, either express or implied.
* See the License for the specific language governing permissions and
* limitations under the License.
*
* SPDX-License-Identifier: Apache-2.0

.SUBCKT sky130_fd_sc_hd__a211o_4 A1 A2 B1 C1 VGND VNB VNB net59 X
*.PININFO A1:I A2:I B1:I C1:I VGND:I VNB:I VNB:I net59:I X:O
MMPA0 pndA A1 net59 VNB sky130_fd_pr__pfet_01v8_hvt m=2 w=1.0u l=0.15u mult=1 sa=0.265
+ sb=0.265 sd=0.28 area=0.063 perim=1.14
MMPA1 pndA A2 net59 VNB sky130_fd_pr__pfet_01v8_hvt m=2 w=1.0u l=0.15u mult=1 sa=0.265
+ sb=0.265 sd=0.28 area=0.063 perim=1.14
MMPB0 pndB B1 pndA VNB sky130_fd_pr__pfet_01v8_hvt m=2 w=1.0u l=0.15u mult=1 sa=0.265
+ sb=0.265 sd=0.28 area=0.063 perim=1.14
MMPC0 y C1 pndB VNB sky130_fd_pr__pfet_01v8_hvt m=2 w=1.0u l=0.15u mult=1 sa=0.265
+ sb=0.265 sd=0.28 area=0.063 perim=1.14
MMIPX X y net59 VNB sky130_fd_pr__pfet_01v8_hvt m=4 w=1.0u l=0.15u mult=1 sa=0.265
+ sb=0.265 sd=0.28 area=0.063 perim=1.14
MMNA0 y A1 sndA1 VNB sky130_fd_pr__nfet_01v8 m=2 w=0.65u l=0.15u mult=1 sa=0.265
+ sb=0.265 sd=0.28 area=0.063 perim=1.14
MMNA1 sndA1 A2 VGND VNB sky130_fd_pr__nfet_01v8 m=2 w=0.65u l=0.15u mult=1 sa=0.265
+ sb=0.265 sd=0.28 area=0.063 perim=1.14
MMNB0 y B1 VGND VNB sky130_fd_pr__nfet_01v8 m=2 w=0.65u l=0.15u mult=1 sa=0.265
+ sb=0.265 sd=0.28 area=0.063 perim=1.14
MMNC0 y C1 VGND VNB sky130_fd_pr__nfet_01v8 m=2 w=0.65u l=0.15u mult=1 sa=0.265
+ sb=0.265 sd=0.28 area=0.063 perim=1.14
MMINX X y VGND VNB sky130_fd_pr__nfet_01v8 m=4 w=0.65u l=0.15u mult=1 sa=0.265
+ sb=0.265 sd=0.28 area=0.063 perim=1.14
.ENDS sky130_fd_sc_hd__a211o_4
* Copyright 2020 The SkyWater PDK Authors
*
* Licensed under the Apache License, Version 2.0 (the "License");
* you may not use this file except in compliance with the License.
* You may obtain a copy of the License at
*
*     https:  www.apache.org licenses LICENSE-2.0
*
* Unless required by applicable law or agreed to in writing, software
* distributed under the License is distributed on an "AS IS" BASIS,
* WITHOUT WARRANTIES OR CONDITIONS OF ANY KIND, either express or implied.
* See the License for the specific language governing permissions and
* limitations under the License.
*
* SPDX-License-Identifier: Apache-2.0

.SUBCKT sky130_fd_sc_hd__a211oi_1 A1 A2 B1 C1 VGND VNB VNB net59 Y
*.PININFO A1:I A2:I B1:I C1:I VGND:I VNB:I VNB:I net59:I Y:O
MMPA0 pndA A1 net59 VNB sky130_fd_pr__pfet_01v8_hvt m=1 w=1.0u l=0.15u mult=1 sa=0.265
+ sb=0.265 sd=0.28 area=0.063 perim=1.14
MMPA1 pndA A2 net59 VNB sky130_fd_pr__pfet_01v8_hvt m=1 w=1.0u l=0.15u mult=1 sa=0.265
+ sb=0.265 sd=0.28 area=0.063 perim=1.14
MMPB0 pndB B1 pndA VNB sky130_fd_pr__pfet_01v8_hvt m=1 w=1.0u l=0.15u mult=1 sa=0.265
+ sb=0.265 sd=0.28 area=0.063 perim=1.14
MMPC0 Y C1 pndB VNB sky130_fd_pr__pfet_01v8_hvt m=1 w=1.0u l=0.15u mult=1 sa=0.265
+ sb=0.265 sd=0.28 area=0.063 perim=1.14
MMNA0 Y A1 sndA1 VNB sky130_fd_pr__nfet_01v8 m=1 w=0.65u l=0.15u mult=1 sa=0.265
+ sb=0.265 sd=0.28 area=0.063 perim=1.14
MMNA1 sndA1 A2 VGND VNB sky130_fd_pr__nfet_01v8 m=1 w=0.65u l=0.15u mult=1 sa=0.265
+ sb=0.265 sd=0.28 area=0.063 perim=1.14
MMNB0 Y B1 VGND VNB sky130_fd_pr__nfet_01v8 m=1 w=0.65u l=0.15u mult=1 sa=0.265
+ sb=0.265 sd=0.28 area=0.063 perim=1.14
MMNC0 Y C1 VGND VNB sky130_fd_pr__nfet_01v8 m=1 w=0.65u l=0.15u mult=1 sa=0.265
+ sb=0.265 sd=0.28 area=0.063 perim=1.14
.ENDS sky130_fd_sc_hd__a211oi_1
* Copyright 2020 The SkyWater PDK Authors
*
* Licensed under the Apache License, Version 2.0 (the "License");
* you may not use this file except in compliance with the License.
* You may obtain a copy of the License at
*
*     https:  www.apache.org licenses LICENSE-2.0
*
* Unless required by applicable law or agreed to in writing, software
* distributed under the License is distributed on an "AS IS" BASIS,
* WITHOUT WARRANTIES OR CONDITIONS OF ANY KIND, either express or implied.
* See the License for the specific language governing permissions and
* limitations under the License.
*
* SPDX-License-Identifier: Apache-2.0

.SUBCKT sky130_fd_sc_hd__a211oi_2 A1 A2 B1 C1 VGND VNB VNB net59 Y
*.PININFO A1:I A2:I B1:I C1:I VGND:I VNB:I VNB:I net59:I Y:O
MMPA0 pndA A1 net59 VNB sky130_fd_pr__pfet_01v8_hvt m=2 w=1.0u l=0.15u mult=1 sa=0.265
+ sb=0.265 sd=0.28 area=0.063 perim=1.14
MMPA1 pndA A2 net59 VNB sky130_fd_pr__pfet_01v8_hvt m=2 w=1.0u l=0.15u mult=1 sa=0.265
+ sb=0.265 sd=0.28 area=0.063 perim=1.14
MMPB0 pndB B1 pndA VNB sky130_fd_pr__pfet_01v8_hvt m=2 w=1.0u l=0.15u mult=1 sa=0.265
+ sb=0.265 sd=0.28 area=0.063 perim=1.14
MMPC0 Y C1 pndB VNB sky130_fd_pr__pfet_01v8_hvt m=2 w=1.0u l=0.15u mult=1 sa=0.265
+ sb=0.265 sd=0.28 area=0.063 perim=1.14
MMNA0 Y A1 sndA1 VNB sky130_fd_pr__nfet_01v8 m=2 w=0.65u l=0.15u mult=1 sa=0.265
+ sb=0.265 sd=0.28 area=0.063 perim=1.14
MMNA1 sndA1 A2 VGND VNB sky130_fd_pr__nfet_01v8 m=2 w=0.65u l=0.15u mult=1 sa=0.265
+ sb=0.265 sd=0.28 area=0.063 perim=1.14
MMNB0 Y B1 VGND VNB sky130_fd_pr__nfet_01v8 m=2 w=0.65u l=0.15u mult=1 sa=0.265
+ sb=0.265 sd=0.28 area=0.063 perim=1.14
MMNC0 Y C1 VGND VNB sky130_fd_pr__nfet_01v8 m=2 w=0.65u l=0.15u mult=1 sa=0.265
+ sb=0.265 sd=0.28 area=0.063 perim=1.14
.ENDS sky130_fd_sc_hd__a211oi_2
* Copyright 2020 The SkyWater PDK Authors
*
* Licensed under the Apache License, Version 2.0 (the "License");
* you may not use this file except in compliance with the License.
* You may obtain a copy of the License at
*
*     https:  www.apache.org licenses LICENSE-2.0
*
* Unless required by applicable law or agreed to in writing, software
* distributed under the License is distributed on an "AS IS" BASIS,
* WITHOUT WARRANTIES OR CONDITIONS OF ANY KIND, either express or implied.
* See the License for the specific language governing permissions and
* limitations under the License.
*
* SPDX-License-Identifier: Apache-2.0

.SUBCKT sky130_fd_sc_hd__a211oi_4 A1 A2 B1 C1 VGND VNB VNB net59 Y
*.PININFO A1:I A2:I B1:I C1:I VGND:I VNB:I VNB:I net59:I Y:O
MMPA0 pndA A1 net59 VNB sky130_fd_pr__pfet_01v8_hvt m=4 w=1.0u l=0.15u mult=1 sa=0.265
+ sb=0.265 sd=0.28 area=0.063 perim=1.14
MMPA1 pndA A2 net59 VNB sky130_fd_pr__pfet_01v8_hvt m=4 w=1.0u l=0.15u mult=1 sa=0.265
+ sb=0.265 sd=0.28 area=0.063 perim=1.14
MMPB0 pndB B1 pndA VNB sky130_fd_pr__pfet_01v8_hvt m=4 w=1.0u l=0.15u mult=1 sa=0.265
+ sb=0.265 sd=0.28 area=0.063 perim=1.14
MMPC0 Y C1 pndB VNB sky130_fd_pr__pfet_01v8_hvt m=4 w=1.0u l=0.15u mult=1 sa=0.265
+ sb=0.265 sd=0.28 area=0.063 perim=1.14
MMNA0 Y A1 sndA1 VNB sky130_fd_pr__nfet_01v8 m=4 w=0.65u l=0.15u mult=1 sa=0.265
+ sb=0.265 sd=0.28 area=0.063 perim=1.14
MMNA1 sndA1 A2 VGND VNB sky130_fd_pr__nfet_01v8 m=4 w=0.65u l=0.15u mult=1 sa=0.265
+ sb=0.265 sd=0.28 area=0.063 perim=1.14
MMNB0 Y B1 VGND VNB sky130_fd_pr__nfet_01v8 m=4 w=0.65u l=0.15u mult=1 sa=0.265
+ sb=0.265 sd=0.28 area=0.063 perim=1.14
MMNC0 Y C1 VGND VNB sky130_fd_pr__nfet_01v8 m=4 w=0.65u l=0.15u mult=1 sa=0.265
+ sb=0.265 sd=0.28 area=0.063 perim=1.14
.ENDS sky130_fd_sc_hd__a211oi_4
* Copyright 2020 The SkyWater PDK Authors
*
* Licensed under the Apache License, Version 2.0 (the "License");
* you may not use this file except in compliance with the License.
* You may obtain a copy of the License at
*
*     https:  www.apache.org licenses LICENSE-2.0
*
* Unless required by applicable law or agreed to in writing, software
* distributed under the License is distributed on an "AS IS" BASIS,
* WITHOUT WARRANTIES OR CONDITIONS OF ANY KIND, either express or implied.
* See the License for the specific language governing permissions and
* limitations under the License.
*
* SPDX-License-Identifier: Apache-2.0

.SUBCKT sky130_fd_sc_hd__a21bo_1 A1 A2 B1_N VGND VNB VNB net59 X
*.PININFO A1:I A2:I B1_N:I VGND:I VNB:I VNB:I net59:I X:O
MMPA0 pndA A1 net59 VNB sky130_fd_pr__pfet_01v8_hvt m=1 w=1.0u l=0.15u mult=1 sa=0.265
+ sb=0.265 sd=0.28 area=0.063 perim=1.14
MMPA1 pndA A2 net59 VNB sky130_fd_pr__pfet_01v8_hvt m=1 w=1.0u l=0.15u mult=1 sa=0.265
+ sb=0.265 sd=0.28 area=0.063 perim=1.14
MMPB0 y B1 pndA VNB sky130_fd_pr__pfet_01v8_hvt m=1 w=1.0u l=0.15u mult=1 sa=0.265
+ sb=0.265 sd=0.28 area=0.063 perim=1.14
MMIPB1N B1 B1_N net59 VNB sky130_fd_pr__pfet_01v8_hvt m=1 w=0.42u l=0.15u mult=1
+ sa=0.265 sb=0.265 sd=0.28 area=0.063 perim=1.14
MMIPX X y net59 VNB sky130_fd_pr__pfet_01v8_hvt m=1 w=1.0u l=0.15u mult=1 sa=0.265
+ sb=0.265 sd=0.28 area=0.063 perim=1.14
MMNA0 y A1 sndA1 VNB sky130_fd_pr__nfet_01v8 m=1 w=0.65u l=0.15u mult=1 sa=0.265
+ sb=0.265 sd=0.28 area=0.063 perim=1.14
MMNA1 sndA1 A2 VGND VNB sky130_fd_pr__nfet_01v8 m=1 w=0.65u l=0.15u mult=1 sa=0.265
+ sb=0.265 sd=0.28 area=0.063 perim=1.14
MMNB0 y B1 VGND VNB sky130_fd_pr__nfet_01v8 m=1 w=0.65u l=0.15u mult=1 sa=0.265
+ sb=0.265 sd=0.28 area=0.063 perim=1.14
MMINB1N B1 B1_N VGND VNB sky130_fd_pr__nfet_01v8 m=1 w=0.42u l=0.15u mult=1 sa=0.265
+ sb=0.265 sd=0.28 area=0.063 perim=1.14
MMINX X y VGND VNB sky130_fd_pr__nfet_01v8 m=1 w=0.65u l=0.15u mult=1 sa=0.265
+ sb=0.265 sd=0.28 area=0.063 perim=1.14
.ENDS sky130_fd_sc_hd__a21bo_1
* Copyright 2020 The SkyWater PDK Authors
*
* Licensed under the Apache License, Version 2.0 (the "License");
* you may not use this file except in compliance with the License.
* You may obtain a copy of the License at
*
*     https:  www.apache.org licenses LICENSE-2.0
*
* Unless required by applicable law or agreed to in writing, software
* distributed under the License is distributed on an "AS IS" BASIS,
* WITHOUT WARRANTIES OR CONDITIONS OF ANY KIND, either express or implied.
* See the License for the specific language governing permissions and
* limitations under the License.
*
* SPDX-License-Identifier: Apache-2.0

.SUBCKT sky130_fd_sc_hd__a21bo_2 A1 A2 B1_N VGND VNB VNB net59 X
*.PININFO A1:I A2:I B1_N:I VGND:I VNB:I VNB:I net59:I X:O
MMPA0 pndA A1 net59 VNB sky130_fd_pr__pfet_01v8_hvt m=1 w=1.0u l=0.15u mult=1 sa=0.265
+ sb=0.265 sd=0.28 area=0.063 perim=1.14
MMPA1 pndA A2 net59 VNB sky130_fd_pr__pfet_01v8_hvt m=1 w=1.0u l=0.15u mult=1 sa=0.265
+ sb=0.265 sd=0.28 area=0.063 perim=1.14
MMPB0 y B1 pndA VNB sky130_fd_pr__pfet_01v8_hvt m=1 w=1.0u l=0.15u mult=1 sa=0.265
+ sb=0.265 sd=0.28 area=0.063 perim=1.14
MMIPB1N B1 B1_N net59 VNB sky130_fd_pr__pfet_01v8_hvt m=1 w=0.42u l=0.15u mult=1
+ sa=0.265 sb=0.265 sd=0.28 area=0.063 perim=1.14
MMIPX X y net59 VNB sky130_fd_pr__pfet_01v8_hvt m=2 w=1.0u l=0.15u mult=1 sa=0.265
+ sb=0.265 sd=0.28 area=0.063 perim=1.14
MMNA0 y A1 sndA1 VNB sky130_fd_pr__nfet_01v8 m=1 w=0.65u l=0.15u mult=1 sa=0.265
+ sb=0.265 sd=0.28 area=0.063 perim=1.14
MMNA1 sndA1 A2 VGND VNB sky130_fd_pr__nfet_01v8 m=1 w=0.65u l=0.15u mult=1 sa=0.265
+ sb=0.265 sd=0.28 area=0.063 perim=1.14
MMNB0 y B1 VGND VNB sky130_fd_pr__nfet_01v8 m=1 w=0.65u l=0.15u mult=1 sa=0.265
+ sb=0.265 sd=0.28 area=0.063 perim=1.14
MMINB1N B1 B1_N VGND VNB sky130_fd_pr__nfet_01v8 m=1 w=0.42u l=0.15u mult=1 sa=0.265
+ sb=0.265 sd=0.28 area=0.063 perim=1.14
MMINX X y VGND VNB sky130_fd_pr__nfet_01v8 m=2 w=0.65u l=0.15u mult=1 sa=0.265
+ sb=0.265 sd=0.28 area=0.063 perim=1.14
.ENDS sky130_fd_sc_hd__a21bo_2
* Copyright 2020 The SkyWater PDK Authors
*
* Licensed under the Apache License, Version 2.0 (the "License");
* you may not use this file except in compliance with the License.
* You may obtain a copy of the License at
*
*     https:  www.apache.org licenses LICENSE-2.0
*
* Unless required by applicable law or agreed to in writing, software
* distributed under the License is distributed on an "AS IS" BASIS,
* WITHOUT WARRANTIES OR CONDITIONS OF ANY KIND, either express or implied.
* See the License for the specific language governing permissions and
* limitations under the License.
*
* SPDX-License-Identifier: Apache-2.0

.SUBCKT sky130_fd_sc_hd__a21bo_4 A1 A2 B1_N VGND VNB VNB net59 X
*.PININFO A1:I A2:I B1_N:I VGND:I VNB:I VNB:I net59:I X:O
MMPA0 pndA A1 net59 VNB sky130_fd_pr__pfet_01v8_hvt m=2 w=1.0u l=0.15u mult=1 sa=0.265
+ sb=0.265 sd=0.28 area=0.063 perim=1.14
MMPA1 pndA A2 net59 VNB sky130_fd_pr__pfet_01v8_hvt m=2 w=1.0u l=0.15u mult=1 sa=0.265
+ sb=0.265 sd=0.28 area=0.063 perim=1.14
MMPB0 y B1 pndA VNB sky130_fd_pr__pfet_01v8_hvt m=2 w=1.0u l=0.15u mult=1 sa=0.265
+ sb=0.265 sd=0.28 area=0.063 perim=1.14
MMIPB1N B1 B1_N net59 VNB sky130_fd_pr__pfet_01v8_hvt m=1 w=1.0u l=0.15u mult=1
+ sa=0.265 sb=0.265 sd=0.28 area=0.063 perim=1.14
MMIPX X y net59 VNB sky130_fd_pr__pfet_01v8_hvt m=4 w=1.0u l=0.15u mult=1 sa=0.265
+ sb=0.265 sd=0.28 area=0.063 perim=1.14
MMNA0 y A1 sndA1 VNB sky130_fd_pr__nfet_01v8 m=2 w=0.65u l=0.15u mult=1 sa=0.265
+ sb=0.265 sd=0.28 area=0.063 perim=1.14
MMNA1 sndA1 A2 VGND VNB sky130_fd_pr__nfet_01v8 m=2 w=0.65u l=0.15u mult=1 sa=0.265
+ sb=0.265 sd=0.28 area=0.063 perim=1.14
MMNB0 y B1 VGND VNB sky130_fd_pr__nfet_01v8 m=2 w=0.65u l=0.15u mult=1 sa=0.265
+ sb=0.265 sd=0.28 area=0.063 perim=1.14
MMINB1N B1 B1_N VGND VNB sky130_fd_pr__nfet_01v8 m=1 w=0.65u l=0.15u mult=1 sa=0.265
+ sb=0.265 sd=0.28 area=0.063 perim=1.14
MMINX X y VGND VNB sky130_fd_pr__nfet_01v8 m=4 w=0.65u l=0.15u mult=1 sa=0.265
+ sb=0.265 sd=0.28 area=0.063 perim=1.14
.ENDS sky130_fd_sc_hd__a21bo_4
* Copyright 2020 The SkyWater PDK Authors
*
* Licensed under the Apache License, Version 2.0 (the "License");
* you may not use this file except in compliance with the License.
* You may obtain a copy of the License at
*
*     https:  www.apache.org licenses LICENSE-2.0
*
* Unless required by applicable law or agreed to in writing, software
* distributed under the License is distributed on an "AS IS" BASIS,
* WITHOUT WARRANTIES OR CONDITIONS OF ANY KIND, either express or implied.
* See the License for the specific language governing permissions and
* limitations under the License.
*
* SPDX-License-Identifier: Apache-2.0

.SUBCKT sky130_fd_sc_hd__a21boi_0 A1 A2 B1_N VGND VNB VNB net59 Y
*.PININFO A1:I A2:I B1_N:I VGND:I VNB:I VNB:I net59:I Y:O
MMPA0 net40 A1 net59 VNB sky130_fd_pr__pfet_01v8_hvt m=1 w=0.64u l=0.15u mult=1
+ sa=0.265 sb=0.265 sd=0.28 area=0.063 perim=1.14
MMPA1 net40 A2 net59 VNB sky130_fd_pr__pfet_01v8_hvt m=1 w=0.64u l=0.15u mult=1
+ sa=0.265 sb=0.265 sd=0.28 area=0.063 perim=1.14
MMPB0 Y B1 net40 VNB sky130_fd_pr__pfet_01v8_hvt m=1 w=0.64u l=0.15u mult=1 sa=0.265
+ sb=0.265 sd=0.28 area=0.063 perim=1.14
MMIPB1N B1 B1_N net59 VNB sky130_fd_pr__pfet_01v8_hvt m=1 w=0.42u l=0.15u mult=1
+ sa=0.265 sb=0.265 sd=0.28 area=0.063 perim=1.14
MMNA0 Y A1 sndA1 VNB sky130_fd_pr__nfet_01v8 m=1 w=0.42u l=0.15u mult=1 sa=0.265
+ sb=0.265 sd=0.28 area=0.063 perim=1.14
MMNA1 sndA1 A2 VGND VNB sky130_fd_pr__nfet_01v8 m=1 w=0.42u l=0.15u mult=1 sa=0.265
+ sb=0.265 sd=0.28 area=0.063 perim=1.14
MMNB0 Y B1 VGND VNB sky130_fd_pr__nfet_01v8 m=1 w=0.42u l=0.15u mult=1 sa=0.265
+ sb=0.265 sd=0.28 area=0.063 perim=1.14
MMINB1N B1 B1_N VGND VNB sky130_fd_pr__nfet_01v8 m=1 w=0.42u l=0.15u mult=1 sa=0.265
+ sb=0.265 sd=0.28 area=0.063 perim=1.14
.ENDS sky130_fd_sc_hd__a21boi_0
* Copyright 2020 The SkyWater PDK Authors
*
* Licensed under the Apache License, Version 2.0 (the "License");
* you may not use this file except in compliance with the License.
* You may obtain a copy of the License at
*
*     https:  www.apache.org licenses LICENSE-2.0
*
* Unless required by applicable law or agreed to in writing, software
* distributed under the License is distributed on an "AS IS" BASIS,
* WITHOUT WARRANTIES OR CONDITIONS OF ANY KIND, either express or implied.
* See the License for the specific language governing permissions and
* limitations under the License.
*
* SPDX-License-Identifier: Apache-2.0

.SUBCKT sky130_fd_sc_hd__a21boi_1 A1 A2 B1_N VGND VNB VNB net59 Y
*.PININFO A1:I A2:I B1_N:I VGND:I VNB:I VNB:I net59:I Y:O
MMPA0 net40 A1 net59 VNB sky130_fd_pr__pfet_01v8_hvt m=1 w=1.0u l=0.15u mult=1 sa=0.265
+ sb=0.265 sd=0.28 area=0.063 perim=1.14
MMPA1 net40 A2 net59 VNB sky130_fd_pr__pfet_01v8_hvt m=1 w=1.0u l=0.15u mult=1 sa=0.265
+ sb=0.265 sd=0.28 area=0.063 perim=1.14
MMPB0 Y B1 net40 VNB sky130_fd_pr__pfet_01v8_hvt m=1 w=1.0u l=0.15u mult=1 sa=0.265
+ sb=0.265 sd=0.28 area=0.063 perim=1.14
MMIPB1N B1 B1_N net59 VNB sky130_fd_pr__pfet_01v8_hvt m=1 w=0.42u l=0.15u mult=1
+ sa=0.265 sb=0.265 sd=0.28 area=0.063 perim=1.14
MMNA0 Y A1 sndA1 VNB sky130_fd_pr__nfet_01v8 m=1 w=0.65u l=0.15u mult=1 sa=0.265
+ sb=0.265 sd=0.28 area=0.063 perim=1.14
MMNA1 sndA1 A2 VGND VNB sky130_fd_pr__nfet_01v8 m=1 w=0.65u l=0.15u mult=1 sa=0.265
+ sb=0.265 sd=0.28 area=0.063 perim=1.14
MMNB0 Y B1 VGND VNB sky130_fd_pr__nfet_01v8 m=1 w=0.65u l=0.15u mult=1 sa=0.265
+ sb=0.265 sd=0.28 area=0.063 perim=1.14
MMINB1N B1 B1_N VGND VNB sky130_fd_pr__nfet_01v8 m=1 w=0.42u l=0.15u mult=1 sa=0.265
+ sb=0.265 sd=0.28 area=0.063 perim=1.14
.ENDS sky130_fd_sc_hd__a21boi_1
* Copyright 2020 The SkyWater PDK Authors
*
* Licensed under the Apache License, Version 2.0 (the "License");
* you may not use this file except in compliance with the License.
* You may obtain a copy of the License at
*
*     https:  www.apache.org licenses LICENSE-2.0
*
* Unless required by applicable law or agreed to in writing, software
* distributed under the License is distributed on an "AS IS" BASIS,
* WITHOUT WARRANTIES OR CONDITIONS OF ANY KIND, either express or implied.
* See the License for the specific language governing permissions and
* limitations under the License.
*
* SPDX-License-Identifier: Apache-2.0

.SUBCKT sky130_fd_sc_hd__a21boi_2 A1 A2 B1_N VGND VNB VNB net59 Y
*.PININFO A1:I A2:I B1_N:I VGND:I VNB:I VNB:I net59:I Y:O
MMPA0 net40 A1 net59 VNB sky130_fd_pr__pfet_01v8_hvt m=2 w=1.0u l=0.15u mult=1 sa=0.265
+ sb=0.265 sd=0.28 area=0.063 perim=1.14
MMPA1 net40 A2 net59 VNB sky130_fd_pr__pfet_01v8_hvt m=2 w=1.0u l=0.15u mult=1 sa=0.265
+ sb=0.265 sd=0.28 area=0.063 perim=1.14
MMPB0 Y B1 net40 VNB sky130_fd_pr__pfet_01v8_hvt m=2 w=1.0u l=0.15u mult=1 sa=0.265
+ sb=0.265 sd=0.28 area=0.063 perim=1.14
MMIPB1N B1 B1_N net59 VNB sky130_fd_pr__pfet_01v8_hvt m=1 w=0.42u l=0.15u mult=1
+ sa=0.265 sb=0.265 sd=0.28 area=0.063 perim=1.14
MMNA0 Y A1 sndA1 VNB sky130_fd_pr__nfet_01v8 m=2 w=0.65u l=0.15u mult=1 sa=0.265
+ sb=0.265 sd=0.28 area=0.063 perim=1.14
MMNA1 sndA1 A2 VGND VNB sky130_fd_pr__nfet_01v8 m=2 w=0.65u l=0.15u mult=1 sa=0.265
+ sb=0.265 sd=0.28 area=0.063 perim=1.14
MMNB0 Y B1 VGND VNB sky130_fd_pr__nfet_01v8 m=2 w=0.65u l=0.15u mult=1 sa=0.265
+ sb=0.265 sd=0.28 area=0.063 perim=1.14
MMINB1N B1 B1_N VGND VNB sky130_fd_pr__nfet_01v8 m=1 w=0.42u l=0.15u mult=1 sa=0.265
+ sb=0.265 sd=0.28 area=0.063 perim=1.14
.ENDS sky130_fd_sc_hd__a21boi_2
* Copyright 2020 The SkyWater PDK Authors
*
* Licensed under the Apache License, Version 2.0 (the "License");
* you may not use this file except in compliance with the License.
* You may obtain a copy of the License at
*
*     https:  www.apache.org licenses LICENSE-2.0
*
* Unless required by applicable law or agreed to in writing, software
* distributed under the License is distributed on an "AS IS" BASIS,
* WITHOUT WARRANTIES OR CONDITIONS OF ANY KIND, either express or implied.
* See the License for the specific language governing permissions and
* limitations under the License.
*
* SPDX-License-Identifier: Apache-2.0

.SUBCKT sky130_fd_sc_hd__a21boi_4 A1 A2 B1_N VGND VNB VNB net59 Y
*.PININFO A1:I A2:I B1_N:I VGND:I VNB:I VNB:I net59:I Y:O
MMPA0 net40 A1 net59 VNB sky130_fd_pr__pfet_01v8_hvt m=4 w=1.0u l=0.15u mult=1 sa=0.265
+ sb=0.265 sd=0.28 area=0.063 perim=1.14
MMPA1 net40 A2 net59 VNB sky130_fd_pr__pfet_01v8_hvt m=4 w=1.0u l=0.15u mult=1 sa=0.265
+ sb=0.265 sd=0.28 area=0.063 perim=1.14
MMPB0 Y B1 net40 VNB sky130_fd_pr__pfet_01v8_hvt m=4 w=1.0u l=0.15u mult=1 sa=0.265
+ sb=0.265 sd=0.28 area=0.063 perim=1.14
MMIPB1N B1 B1_N net59 VNB sky130_fd_pr__pfet_01v8_hvt m=1 w=1.0u l=0.15u mult=1
+ sa=0.265 sb=0.265 sd=0.28 area=0.063 perim=1.14
MMNA0 Y A1 sndA1 VNB sky130_fd_pr__nfet_01v8 m=4 w=0.65u l=0.15u mult=1 sa=0.265
+ sb=0.265 sd=0.28 area=0.063 perim=1.14
MMNA1 sndA1 A2 VGND VNB sky130_fd_pr__nfet_01v8 m=4 w=0.65u l=0.15u mult=1 sa=0.265
+ sb=0.265 sd=0.28 area=0.063 perim=1.14
MMNB0 Y B1 VGND VNB sky130_fd_pr__nfet_01v8 m=4 w=0.65u l=0.15u mult=1 sa=0.265
+ sb=0.265 sd=0.28 area=0.063 perim=1.14
MMINB1N B1 B1_N VGND VNB sky130_fd_pr__nfet_01v8 m=1 w=0.65u l=0.15u mult=1 sa=0.265
+ sb=0.265 sd=0.28 area=0.063 perim=1.14
.ENDS sky130_fd_sc_hd__a21boi_4
* Copyright 2020 The SkyWater PDK Authors
*
* Licensed under the Apache License, Version 2.0 (the "License");
* you may not use this file except in compliance with the License.
* You may obtain a copy of the License at
*
*     https:  www.apache.org licenses LICENSE-2.0
*
* Unless required by applicable law or agreed to in writing, software
* distributed under the License is distributed on an "AS IS" BASIS,
* WITHOUT WARRANTIES OR CONDITIONS OF ANY KIND, either express or implied.
* See the License for the specific language governing permissions and
* limitations under the License.
*
* SPDX-License-Identifier: Apache-2.0

.SUBCKT sky130_fd_sc_hd__a21o_1 A1 A2 B1 VGND VNB VNB net59 X
*.PININFO A1:I A2:I B1:I VGND:I VNB:I VNB:I net59:I X:O
MMPA0 pndA A1 net59 VNB sky130_fd_pr__pfet_01v8_hvt m=1 w=1.0u l=0.15u mult=1 sa=0.265
+ sb=0.265 sd=0.28 area=0.063 perim=1.14
MMPA1 pndA A2 net59 VNB sky130_fd_pr__pfet_01v8_hvt m=1 w=1.0u l=0.15u mult=1 sa=0.265
+ sb=0.265 sd=0.28 area=0.063 perim=1.14
MMPB0 y B1 pndA VNB sky130_fd_pr__pfet_01v8_hvt m=1 w=1.0u l=0.15u mult=1 sa=0.265
+ sb=0.265 sd=0.28 area=0.063 perim=1.14
MMIPX X y net59 VNB sky130_fd_pr__pfet_01v8_hvt m=1 w=1.0u l=0.15u mult=1 sa=0.265
+ sb=0.265 sd=0.28 area=0.063 perim=1.14
MMNA0 y A1 sndA1 VNB sky130_fd_pr__nfet_01v8 m=1 w=0.65u l=0.15u mult=1 sa=0.265
+ sb=0.265 sd=0.28 area=0.063 perim=1.14
MMNA1 sndA1 A2 VGND VNB sky130_fd_pr__nfet_01v8 m=1 w=0.65u l=0.15u mult=1 sa=0.265
+ sb=0.265 sd=0.28 area=0.063 perim=1.14
MMNB0 y B1 VGND VNB sky130_fd_pr__nfet_01v8 m=1 w=0.65u l=0.15u mult=1 sa=0.265
+ sb=0.265 sd=0.28 area=0.063 perim=1.14
MMINX X y VGND VNB sky130_fd_pr__nfet_01v8 m=1 w=0.65u l=0.15u mult=1 sa=0.265
+ sb=0.265 sd=0.28 area=0.063 perim=1.14
.ENDS sky130_fd_sc_hd__a21o_1
* Copyright 2020 The SkyWater PDK Authors
*
* Licensed under the Apache License, Version 2.0 (the "License");
* you may not use this file except in compliance with the License.
* You may obtain a copy of the License at
*
*     https:  www.apache.org licenses LICENSE-2.0
*
* Unless required by applicable law or agreed to in writing, software
* distributed under the License is distributed on an "AS IS" BASIS,
* WITHOUT WARRANTIES OR CONDITIONS OF ANY KIND, either express or implied.
* See the License for the specific language governing permissions and
* limitations under the License.
*
* SPDX-License-Identifier: Apache-2.0

.SUBCKT sky130_fd_sc_hd__a21o_2 A1 A2 B1 VGND VNB VNB net59 X
*.PININFO A1:I A2:I B1:I VGND:I VNB:I VNB:I net59:I X:O
MMPA0 pndA A1 net59 VNB sky130_fd_pr__pfet_01v8_hvt m=1 w=1.0u l=0.15u mult=1 sa=0.265
+ sb=0.265 sd=0.28 area=0.063 perim=1.14
MMPA1 pndA A2 net59 VNB sky130_fd_pr__pfet_01v8_hvt m=1 w=1.0u l=0.15u mult=1 sa=0.265
+ sb=0.265 sd=0.28 area=0.063 perim=1.14
MMPB0 y B1 pndA VNB sky130_fd_pr__pfet_01v8_hvt m=1 w=1.0u l=0.15u mult=1 sa=0.265
+ sb=0.265 sd=0.28 area=0.063 perim=1.14
MMIPX X y net59 VNB sky130_fd_pr__pfet_01v8_hvt m=2 w=1.0u l=0.15u mult=1 sa=0.265
+ sb=0.265 sd=0.28 area=0.063 perim=1.14
MMNA0 y A1 sndA1 VNB sky130_fd_pr__nfet_01v8 m=1 w=0.65u l=0.15u mult=1 sa=0.265
+ sb=0.265 sd=0.28 area=0.063 perim=1.14
MMNA1 sndA1 A2 VGND VNB sky130_fd_pr__nfet_01v8 m=1 w=0.65u l=0.15u mult=1 sa=0.265
+ sb=0.265 sd=0.28 area=0.063 perim=1.14
MMNB0 y B1 VGND VNB sky130_fd_pr__nfet_01v8 m=1 w=0.65u l=0.15u mult=1 sa=0.265
+ sb=0.265 sd=0.28 area=0.063 perim=1.14
MMINX X y VGND VNB sky130_fd_pr__nfet_01v8 m=2 w=0.65u l=0.15u mult=1 sa=0.265
+ sb=0.265 sd=0.28 area=0.063 perim=1.14
.ENDS sky130_fd_sc_hd__a21o_2
* Copyright 2020 The SkyWater PDK Authors
*
* Licensed under the Apache License, Version 2.0 (the "License");
* you may not use this file except in compliance with the License.
* You may obtain a copy of the License at
*
*     https:  www.apache.org licenses LICENSE-2.0
*
* Unless required by applicable law or agreed to in writing, software
* distributed under the License is distributed on an "AS IS" BASIS,
* WITHOUT WARRANTIES OR CONDITIONS OF ANY KIND, either express or implied.
* See the License for the specific language governing permissions and
* limitations under the License.
*
* SPDX-License-Identifier: Apache-2.0

.SUBCKT sky130_fd_sc_hd__a21o_4 A1 A2 B1 VGND VNB VNB net59 X
*.PININFO A1:I A2:I B1:I VGND:I VNB:I VNB:I net59:I X:O
MMPA0 pndA A1 net59 VNB sky130_fd_pr__pfet_01v8_hvt m=2 w=1.0u l=0.15u mult=1 sa=0.265
+ sb=0.265 sd=0.28 area=0.063 perim=1.14
MMPA1 pndA A2 net59 VNB sky130_fd_pr__pfet_01v8_hvt m=2 w=1.0u l=0.15u mult=1 sa=0.265
+ sb=0.265 sd=0.28 area=0.063 perim=1.14
MMPB0 y B1 pndA VNB sky130_fd_pr__pfet_01v8_hvt m=2 w=1.0u l=0.15u mult=1 sa=0.265
+ sb=0.265 sd=0.28 area=0.063 perim=1.14
MMIPX X y net59 VNB sky130_fd_pr__pfet_01v8_hvt m=4 w=1.0u l=0.15u mult=1 sa=0.265
+ sb=0.265 sd=0.28 area=0.063 perim=1.14
MMNA0 y A1 sndA1 VNB sky130_fd_pr__nfet_01v8 m=2 w=0.65u l=0.15u mult=1 sa=0.265
+ sb=0.265 sd=0.28 area=0.063 perim=1.14
MMNA1 sndA1 A2 VGND VNB sky130_fd_pr__nfet_01v8 m=2 w=0.65u l=0.15u mult=1 sa=0.265
+ sb=0.265 sd=0.28 area=0.063 perim=1.14
MMNB0 y B1 VGND VNB sky130_fd_pr__nfet_01v8 m=2 w=0.65u l=0.15u mult=1 sa=0.265
+ sb=0.265 sd=0.28 area=0.063 perim=1.14
MMINX X y VGND VNB sky130_fd_pr__nfet_01v8 m=4 w=0.65u l=0.15u mult=1 sa=0.265
+ sb=0.265 sd=0.28 area=0.063 perim=1.14
.ENDS sky130_fd_sc_hd__a21o_4
* Copyright 2020 The SkyWater PDK Authors
*
* Licensed under the Apache License, Version 2.0 (the "License");
* you may not use this file except in compliance with the License.
* You may obtain a copy of the License at
*
*     https:  www.apache.org licenses LICENSE-2.0
*
* Unless required by applicable law or agreed to in writing, software
* distributed under the License is distributed on an "AS IS" BASIS,
* WITHOUT WARRANTIES OR CONDITIONS OF ANY KIND, either express or implied.
* See the License for the specific language governing permissions and
* limitations under the License.
*
* SPDX-License-Identifier: Apache-2.0

.SUBCKT sky130_fd_sc_hd__a21oi_1 A1 A2 B1 VGND VNB VNB net59 Y
*.PININFO A1:I A2:I B1:I VGND:I VNB:I VNB:I net59:I Y:O
MMPA0 pndA A1 net59 VNB sky130_fd_pr__pfet_01v8_hvt m=1 w=1.0u l=0.15u mult=1 sa=0.265
+ sb=0.265 sd=0.28 area=0.063 perim=1.14
MMPA1 pndA A2 net59 VNB sky130_fd_pr__pfet_01v8_hvt m=1 w=1.0u l=0.15u mult=1 sa=0.265
+ sb=0.265 sd=0.28 area=0.063 perim=1.14
MMPB0 Y B1 pndA VNB sky130_fd_pr__pfet_01v8_hvt m=1 w=1.0u l=0.15u mult=1 sa=0.265
+ sb=0.265 sd=0.28 area=0.063 perim=1.14
MMNA0 Y A1 sndA1 VNB sky130_fd_pr__nfet_01v8 m=1 w=0.65u l=0.15u mult=1 sa=0.265
+ sb=0.265 sd=0.28 area=0.063 perim=1.14
MMNA1 sndA1 A2 VGND VNB sky130_fd_pr__nfet_01v8 m=1 w=0.65u l=0.15u mult=1 sa=0.265
+ sb=0.265 sd=0.28 area=0.063 perim=1.14
MMNB0 Y B1 VGND VNB sky130_fd_pr__nfet_01v8 m=1 w=0.65u l=0.15u mult=1 sa=0.265
+ sb=0.265 sd=0.28 area=0.063 perim=1.14
.ENDS sky130_fd_sc_hd__a21oi_1
* Copyright 2020 The SkyWater PDK Authors
*
* Licensed under the Apache License, Version 2.0 (the "License");
* you may not use this file except in compliance with the License.
* You may obtain a copy of the License at
*
*     https:  www.apache.org licenses LICENSE-2.0
*
* Unless required by applicable law or agreed to in writing, software
* distributed under the License is distributed on an "AS IS" BASIS,
* WITHOUT WARRANTIES OR CONDITIONS OF ANY KIND, either express or implied.
* See the License for the specific language governing permissions and
* limitations under the License.
*
* SPDX-License-Identifier: Apache-2.0

.SUBCKT sky130_fd_sc_hd__a21oi_2 A1 A2 B1 VGND VNB VNB net59 Y
*.PININFO A1:I A2:I B1:I VGND:I VNB:I VNB:I net59:I Y:O
MMPA0 pndA A1 net59 VNB sky130_fd_pr__pfet_01v8_hvt m=2 w=1.0u l=0.15u mult=1 sa=0.265
+ sb=0.265 sd=0.28 area=0.063 perim=1.14
MMPA1 pndA A2 net59 VNB sky130_fd_pr__pfet_01v8_hvt m=2 w=1.0u l=0.15u mult=1 sa=0.265
+ sb=0.265 sd=0.28 area=0.063 perim=1.14
MMPB0 Y B1 pndA VNB sky130_fd_pr__pfet_01v8_hvt m=2 w=1.0u l=0.15u mult=1 sa=0.265
+ sb=0.265 sd=0.28 area=0.063 perim=1.14
MMNA0 Y A1 sndA1 VNB sky130_fd_pr__nfet_01v8 m=2 w=0.65u l=0.15u mult=1 sa=0.265
+ sb=0.265 sd=0.28 area=0.063 perim=1.14
MMNA1 sndA1 A2 VGND VNB sky130_fd_pr__nfet_01v8 m=2 w=0.65u l=0.15u mult=1 sa=0.265
+ sb=0.265 sd=0.28 area=0.063 perim=1.14
MMNB0 Y B1 VGND VNB sky130_fd_pr__nfet_01v8 m=2 w=0.65u l=0.15u mult=1 sa=0.265
+ sb=0.265 sd=0.28 area=0.063 perim=1.14
.ENDS sky130_fd_sc_hd__a21oi_2
* Copyright 2020 The SkyWater PDK Authors
*
* Licensed under the Apache License, Version 2.0 (the "License");
* you may not use this file except in compliance with the License.
* You may obtain a copy of the License at
*
*     https:  www.apache.org licenses LICENSE-2.0
*
* Unless required by applicable law or agreed to in writing, software
* distributed under the License is distributed on an "AS IS" BASIS,
* WITHOUT WARRANTIES OR CONDITIONS OF ANY KIND, either express or implied.
* See the License for the specific language governing permissions and
* limitations under the License.
*
* SPDX-License-Identifier: Apache-2.0

.SUBCKT sky130_fd_sc_hd__a21oi_4 A1 A2 B1 VGND VNB VNB net59 Y
*.PININFO A1:I A2:I B1:I VGND:I VNB:I VNB:I net59:I Y:O
MMPA0 pndA A1 net59 VNB sky130_fd_pr__pfet_01v8_hvt m=4 w=1.0u l=0.15u mult=1 sa=0.265
+ sb=0.265 sd=0.28 area=0.063 perim=1.14
MMPA1 pndA A2 net59 VNB sky130_fd_pr__pfet_01v8_hvt m=4 w=1.0u l=0.15u mult=1 sa=0.265
+ sb=0.265 sd=0.28 area=0.063 perim=1.14
MMPB0 Y B1 pndA VNB sky130_fd_pr__pfet_01v8_hvt m=4 w=1.0u l=0.15u mult=1 sa=0.265
+ sb=0.265 sd=0.28 area=0.063 perim=1.14
MMNA0 Y A1 sndA1 VNB sky130_fd_pr__nfet_01v8 m=4 w=0.65u l=0.15u mult=1 sa=0.265
+ sb=0.265 sd=0.28 area=0.063 perim=1.14
MMNA1 sndA1 A2 VGND VNB sky130_fd_pr__nfet_01v8 m=4 w=0.65u l=0.15u mult=1 sa=0.265
+ sb=0.265 sd=0.28 area=0.063 perim=1.14
MMNB0 Y B1 VGND VNB sky130_fd_pr__nfet_01v8 m=4 w=0.65u l=0.15u mult=1 sa=0.265
+ sb=0.265 sd=0.28 area=0.063 perim=1.14
.ENDS sky130_fd_sc_hd__a21oi_4
* Copyright 2020 The SkyWater PDK Authors
*
* Licensed under the Apache License, Version 2.0 (the "License");
* you may not use this file except in compliance with the License.
* You may obtain a copy of the License at
*
*     https:  www.apache.org licenses LICENSE-2.0
*
* Unless required by applicable law or agreed to in writing, software
* distributed under the License is distributed on an "AS IS" BASIS,
* WITHOUT WARRANTIES OR CONDITIONS OF ANY KIND, either express or implied.
* See the License for the specific language governing permissions and
* limitations under the License.
*
* SPDX-License-Identifier: Apache-2.0

.SUBCKT sky130_fd_sc_hd__a221o_1 A1 A2 B1 B2 C1 VGND VNB VNB net59 X
*.PININFO A1:I A2:I B1:I B2:I C1:I VGND:I VNB:I VNB:I net59:I X:O
MMPA0 pndA A1 net59 VNB sky130_fd_pr__pfet_01v8_hvt m=1 w=1.0u l=0.15u mult=1 sa=0.265
+ sb=0.265 sd=0.28 area=0.063 perim=1.14
MMPA1 pndA A2 net59 VNB sky130_fd_pr__pfet_01v8_hvt m=1 w=1.0u l=0.15u mult=1 sa=0.265
+ sb=0.265 sd=0.28 area=0.063 perim=1.14
MMPB0 pndB B1 pndA VNB sky130_fd_pr__pfet_01v8_hvt m=1 w=1.0u l=0.15u mult=1 sa=0.265
+ sb=0.265 sd=0.28 area=0.063 perim=1.14
MMPB1 pndB B2 pndA VNB sky130_fd_pr__pfet_01v8_hvt m=1 w=1.0u l=0.15u mult=1 sa=0.265
+ sb=0.265 sd=0.28 area=0.063 perim=1.14
MMPC0 y C1 pndB VNB sky130_fd_pr__pfet_01v8_hvt m=1 w=1.0u l=0.15u mult=1 sa=0.265
+ sb=0.265 sd=0.28 area=0.063 perim=1.14
MMIPX X y net59 VNB sky130_fd_pr__pfet_01v8_hvt m=1 w=1.0u l=0.15u mult=1 sa=0.265
+ sb=0.265 sd=0.28 area=0.063 perim=1.14
MMNA0 y A1 sndA1 VNB sky130_fd_pr__nfet_01v8 m=1 w=0.65u l=0.15u mult=1 sa=0.265
+ sb=0.265 sd=0.28 area=0.063 perim=1.14
MMNA1 sndA1 A2 VGND VNB sky130_fd_pr__nfet_01v8 m=1 w=0.65u l=0.15u mult=1 sa=0.265
+ sb=0.265 sd=0.28 area=0.063 perim=1.14
MMNB0 y B1 sndB1 VNB sky130_fd_pr__nfet_01v8 m=1 w=0.65u l=0.15u mult=1 sa=0.265
+ sb=0.265 sd=0.28 area=0.063 perim=1.14
MMNB1 sndB1 B2 VGND VNB sky130_fd_pr__nfet_01v8 m=1 w=0.65u l=0.15u mult=1 sa=0.265
+ sb=0.265 sd=0.28 area=0.063 perim=1.14
MMNC0 y C1 VGND VNB sky130_fd_pr__nfet_01v8 m=1 w=0.65u l=0.15u mult=1 sa=0.265
+ sb=0.265 sd=0.28 area=0.063 perim=1.14
MMINX X y VGND VNB sky130_fd_pr__nfet_01v8 m=1 w=0.65u l=0.15u mult=1 sa=0.265
+ sb=0.265 sd=0.28 area=0.063 perim=1.14
.ENDS sky130_fd_sc_hd__a221o_1
* Copyright 2020 The SkyWater PDK Authors
*
* Licensed under the Apache License, Version 2.0 (the "License");
* you may not use this file except in compliance with the License.
* You may obtain a copy of the License at
*
*     https:  www.apache.org licenses LICENSE-2.0
*
* Unless required by applicable law or agreed to in writing, software
* distributed under the License is distributed on an "AS IS" BASIS,
* WITHOUT WARRANTIES OR CONDITIONS OF ANY KIND, either express or implied.
* See the License for the specific language governing permissions and
* limitations under the License.
*
* SPDX-License-Identifier: Apache-2.0

.SUBCKT sky130_fd_sc_hd__a221o_2 A1 A2 B1 B2 C1 VGND VNB VNB net59 X
*.PININFO A1:I A2:I B1:I B2:I C1:I VGND:I VNB:I VNB:I net59:I X:O
MMPA0 pndA A1 net59 VNB sky130_fd_pr__pfet_01v8_hvt m=1 w=1.0u l=0.15u mult=1 sa=0.265
+ sb=0.265 sd=0.28 area=0.063 perim=1.14
MMPA1 pndA A2 net59 VNB sky130_fd_pr__pfet_01v8_hvt m=1 w=1.0u l=0.15u mult=1 sa=0.265
+ sb=0.265 sd=0.28 area=0.063 perim=1.14
MMPB0 pndB B1 pndA VNB sky130_fd_pr__pfet_01v8_hvt m=1 w=1.0u l=0.15u mult=1 sa=0.265
+ sb=0.265 sd=0.28 area=0.063 perim=1.14
MMPB1 pndB B2 pndA VNB sky130_fd_pr__pfet_01v8_hvt m=1 w=1.0u l=0.15u mult=1 sa=0.265
+ sb=0.265 sd=0.28 area=0.063 perim=1.14
MMPC0 y C1 pndB VNB sky130_fd_pr__pfet_01v8_hvt m=1 w=1.0u l=0.15u mult=1 sa=0.265
+ sb=0.265 sd=0.28 area=0.063 perim=1.14
MMIPX X y net59 VNB sky130_fd_pr__pfet_01v8_hvt m=2 w=1.0u l=0.15u mult=1 sa=0.265
+ sb=0.265 sd=0.28 area=0.063 perim=1.14
MMNA0 y A1 sndA1 VNB sky130_fd_pr__nfet_01v8 m=1 w=0.65u l=0.15u mult=1 sa=0.265
+ sb=0.265 sd=0.28 area=0.063 perim=1.14
MMNA1 sndA1 A2 VGND VNB sky130_fd_pr__nfet_01v8 m=1 w=0.65u l=0.15u mult=1 sa=0.265
+ sb=0.265 sd=0.28 area=0.063 perim=1.14
MMNB0 y B1 sndB1 VNB sky130_fd_pr__nfet_01v8 m=1 w=0.65u l=0.15u mult=1 sa=0.265
+ sb=0.265 sd=0.28 area=0.063 perim=1.14
MMNB1 sndB1 B2 VGND VNB sky130_fd_pr__nfet_01v8 m=1 w=0.65u l=0.15u mult=1 sa=0.265
+ sb=0.265 sd=0.28 area=0.063 perim=1.14
MMNC0 y C1 VGND VNB sky130_fd_pr__nfet_01v8 m=1 w=0.65u l=0.15u mult=1 sa=0.265
+ sb=0.265 sd=0.28 area=0.063 perim=1.14
MMINX X y VGND VNB sky130_fd_pr__nfet_01v8 m=2 w=0.65u l=0.15u mult=1 sa=0.265
+ sb=0.265 sd=0.28 area=0.063 perim=1.14
.ENDS sky130_fd_sc_hd__a221o_2
* Copyright 2020 The SkyWater PDK Authors
*
* Licensed under the Apache License, Version 2.0 (the "License");
* you may not use this file except in compliance with the License.
* You may obtain a copy of the License at
*
*     https:  www.apache.org licenses LICENSE-2.0
*
* Unless required by applicable law or agreed to in writing, software
* distributed under the License is distributed on an "AS IS" BASIS,
* WITHOUT WARRANTIES OR CONDITIONS OF ANY KIND, either express or implied.
* See the License for the specific language governing permissions and
* limitations under the License.
*
* SPDX-License-Identifier: Apache-2.0

.SUBCKT sky130_fd_sc_hd__a221o_4 A1 A2 B1 B2 C1 VGND VNB VNB net59 X
*.PININFO A1:I A2:I B1:I B2:I C1:I VGND:I VNB:I VNB:I net59:I X:O
MMPA0 pndA A1 net59 VNB sky130_fd_pr__pfet_01v8_hvt m=2 w=1.0u l=0.15u mult=1 sa=0.265
+ sb=0.265 sd=0.28 area=0.063 perim=1.14
MMPA1 pndA A2 net59 VNB sky130_fd_pr__pfet_01v8_hvt m=2 w=1.0u l=0.15u mult=1 sa=0.265
+ sb=0.265 sd=0.28 area=0.063 perim=1.14
MMPB0 pndB B1 pndA VNB sky130_fd_pr__pfet_01v8_hvt m=2 w=1.0u l=0.15u mult=1 sa=0.265
+ sb=0.265 sd=0.28 area=0.063 perim=1.14
MMPB1 pndB B2 pndA VNB sky130_fd_pr__pfet_01v8_hvt m=2 w=1.0u l=0.15u mult=1 sa=0.265
+ sb=0.265 sd=0.28 area=0.063 perim=1.14
MMPC0 y C1 pndB VNB sky130_fd_pr__pfet_01v8_hvt m=2 w=1.0u l=0.15u mult=1 sa=0.265
+ sb=0.265 sd=0.28 area=0.063 perim=1.14
MMIPX X y net59 VNB sky130_fd_pr__pfet_01v8_hvt m=4 w=1.0u l=0.15u mult=1 sa=0.265
+ sb=0.265 sd=0.28 area=0.063 perim=1.14
MMNA0 y A1 sndA1 VNB sky130_fd_pr__nfet_01v8 m=2 w=0.65u l=0.15u mult=1 sa=0.265
+ sb=0.265 sd=0.28 area=0.063 perim=1.14
MMNA1 sndA1 A2 VGND VNB sky130_fd_pr__nfet_01v8 m=2 w=0.65u l=0.15u mult=1 sa=0.265
+ sb=0.265 sd=0.28 area=0.063 perim=1.14
MMNB0 y B1 sndB1 VNB sky130_fd_pr__nfet_01v8 m=2 w=0.65u l=0.15u mult=1 sa=0.265
+ sb=0.265 sd=0.28 area=0.063 perim=1.14
MMNB1 sndB1 B2 VGND VNB sky130_fd_pr__nfet_01v8 m=2 w=0.65u l=0.15u mult=1 sa=0.265
+ sb=0.265 sd=0.28 area=0.063 perim=1.14
MMNC0 y C1 VGND VNB sky130_fd_pr__nfet_01v8 m=2 w=0.65u l=0.15u mult=1 sa=0.265
+ sb=0.265 sd=0.28 area=0.063 perim=1.14
MMINX X y VGND VNB sky130_fd_pr__nfet_01v8 m=4 w=0.65u l=0.15u mult=1 sa=0.265
+ sb=0.265 sd=0.28 area=0.063 perim=1.14
.ENDS sky130_fd_sc_hd__a221o_4
* Copyright 2020 The SkyWater PDK Authors
*
* Licensed under the Apache License, Version 2.0 (the "License");
* you may not use this file except in compliance with the License.
* You may obtain a copy of the License at
*
*     https:  www.apache.org licenses LICENSE-2.0
*
* Unless required by applicable law or agreed to in writing, software
* distributed under the License is distributed on an "AS IS" BASIS,
* WITHOUT WARRANTIES OR CONDITIONS OF ANY KIND, either express or implied.
* See the License for the specific language governing permissions and
* limitations under the License.
*
* SPDX-License-Identifier: Apache-2.0

.SUBCKT sky130_fd_sc_hd__a221oi_1 A1 A2 B1 B2 C1 VGND VNB VNB net59 Y
*.PININFO A1:I A2:I B1:I B2:I C1:I VGND:I VNB:I VNB:I net59:I Y:O
MMPA0 pndA A1 net59 VNB sky130_fd_pr__pfet_01v8_hvt m=1 w=1.0u l=0.15u mult=1 sa=0.265
+ sb=0.265 sd=0.28 area=0.063 perim=1.14
MMPA1 pndA A2 net59 VNB sky130_fd_pr__pfet_01v8_hvt m=1 w=1.0u l=0.15u mult=1 sa=0.265
+ sb=0.265 sd=0.28 area=0.063 perim=1.14
MMPB0 pndB B1 pndA VNB sky130_fd_pr__pfet_01v8_hvt m=1 w=1.0u l=0.15u mult=1 sa=0.265
+ sb=0.265 sd=0.28 area=0.063 perim=1.14
MMPB1 pndB B2 pndA VNB sky130_fd_pr__pfet_01v8_hvt m=1 w=1.0u l=0.15u mult=1 sa=0.265
+ sb=0.265 sd=0.28 area=0.063 perim=1.14
MMPC0 Y C1 pndB VNB sky130_fd_pr__pfet_01v8_hvt m=1 w=1.0u l=0.15u mult=1 sa=0.265
+ sb=0.265 sd=0.28 area=0.063 perim=1.14
MMNA0 Y A1 sndA1 VNB sky130_fd_pr__nfet_01v8 m=1 w=0.65u l=0.15u mult=1 sa=0.265
+ sb=0.265 sd=0.28 area=0.063 perim=1.14
MMNA1 sndA1 A2 VGND VNB sky130_fd_pr__nfet_01v8 m=1 w=0.65u l=0.15u mult=1 sa=0.265
+ sb=0.265 sd=0.28 area=0.063 perim=1.14
MMNB0 Y B1 sndB1 VNB sky130_fd_pr__nfet_01v8 m=1 w=0.65u l=0.15u mult=1 sa=0.265
+ sb=0.265 sd=0.28 area=0.063 perim=1.14
MMNB1 sndB1 B2 VGND VNB sky130_fd_pr__nfet_01v8 m=1 w=0.65u l=0.15u mult=1 sa=0.265
+ sb=0.265 sd=0.28 area=0.063 perim=1.14
MMNC0 Y C1 VGND VNB sky130_fd_pr__nfet_01v8 m=1 w=0.65u l=0.15u mult=1 sa=0.265
+ sb=0.265 sd=0.28 area=0.063 perim=1.14
.ENDS sky130_fd_sc_hd__a221oi_1
* Copyright 2020 The SkyWater PDK Authors
*
* Licensed under the Apache License, Version 2.0 (the "License");
* you may not use this file except in compliance with the License.
* You may obtain a copy of the License at
*
*     https:  www.apache.org licenses LICENSE-2.0
*
* Unless required by applicable law or agreed to in writing, software
* distributed under the License is distributed on an "AS IS" BASIS,
* WITHOUT WARRANTIES OR CONDITIONS OF ANY KIND, either express or implied.
* See the License for the specific language governing permissions and
* limitations under the License.
*
* SPDX-License-Identifier: Apache-2.0

.SUBCKT sky130_fd_sc_hd__a221oi_2 A1 A2 B1 B2 C1 VGND VNB VNB net59 Y
*.PININFO A1:I A2:I B1:I B2:I C1:I VGND:I VNB:I VNB:I net59:I Y:O
MMPA0 pndA A1 net59 VNB sky130_fd_pr__pfet_01v8_hvt m=2 w=1.0u l=0.15u mult=1 sa=0.265
+ sb=0.265 sd=0.28 area=0.063 perim=1.14
MMPA1 pndA A2 net59 VNB sky130_fd_pr__pfet_01v8_hvt m=2 w=1.0u l=0.15u mult=1 sa=0.265
+ sb=0.265 sd=0.28 area=0.063 perim=1.14
MMPB0 pndB B1 pndA VNB sky130_fd_pr__pfet_01v8_hvt m=2 w=1.0u l=0.15u mult=1 sa=0.265
+ sb=0.265 sd=0.28 area=0.063 perim=1.14
MMPB1 pndB B2 pndA VNB sky130_fd_pr__pfet_01v8_hvt m=2 w=1.0u l=0.15u mult=1 sa=0.265
+ sb=0.265 sd=0.28 area=0.063 perim=1.14
MMPC0 Y C1 pndB VNB sky130_fd_pr__pfet_01v8_hvt m=2 w=1.0u l=0.15u mult=1 sa=0.265
+ sb=0.265 sd=0.28 area=0.063 perim=1.14
MMNA0 Y A1 sndA1 VNB sky130_fd_pr__nfet_01v8 m=2 w=0.65u l=0.15u mult=1 sa=0.265
+ sb=0.265 sd=0.28 area=0.063 perim=1.14
MMNA1 sndA1 A2 VGND VNB sky130_fd_pr__nfet_01v8 m=2 w=0.65u l=0.15u mult=1 sa=0.265
+ sb=0.265 sd=0.28 area=0.063 perim=1.14
MMNB0 Y B1 sndB1 VNB sky130_fd_pr__nfet_01v8 m=2 w=0.65u l=0.15u mult=1 sa=0.265
+ sb=0.265 sd=0.28 area=0.063 perim=1.14
MMNB1 sndB1 B2 VGND VNB sky130_fd_pr__nfet_01v8 m=2 w=0.65u l=0.15u mult=1 sa=0.265
+ sb=0.265 sd=0.28 area=0.063 perim=1.14
MMNC0 Y C1 VGND VNB sky130_fd_pr__nfet_01v8 m=2 w=0.65u l=0.15u mult=1 sa=0.265
+ sb=0.265 sd=0.28 area=0.063 perim=1.14
.ENDS sky130_fd_sc_hd__a221oi_2
* Copyright 2020 The SkyWater PDK Authors
*
* Licensed under the Apache License, Version 2.0 (the "License");
* you may not use this file except in compliance with the License.
* You may obtain a copy of the License at
*
*     https:  www.apache.org licenses LICENSE-2.0
*
* Unless required by applicable law or agreed to in writing, software
* distributed under the License is distributed on an "AS IS" BASIS,
* WITHOUT WARRANTIES OR CONDITIONS OF ANY KIND, either express or implied.
* See the License for the specific language governing permissions and
* limitations under the License.
*
* SPDX-License-Identifier: Apache-2.0

.SUBCKT sky130_fd_sc_hd__a221oi_4 A1 A2 B1 B2 C1 VGND VNB VNB net59 Y
*.PININFO A1:I A2:I B1:I B2:I C1:I VGND:I VNB:I VNB:I net59:I Y:O
MMPA0 pndA A1 net59 VNB sky130_fd_pr__pfet_01v8_hvt m=4 w=1.0u l=0.15u mult=1 sa=0.265
+ sb=0.265 sd=0.28 area=0.063 perim=1.14
MMPA1 pndA A2 net59 VNB sky130_fd_pr__pfet_01v8_hvt m=4 w=1.0u l=0.15u mult=1 sa=0.265
+ sb=0.265 sd=0.28 area=0.063 perim=1.14
MMPB0 pndB B1 pndA VNB sky130_fd_pr__pfet_01v8_hvt m=4 w=1.0u l=0.15u mult=1 sa=0.265
+ sb=0.265 sd=0.28 area=0.063 perim=1.14
MMPB1 pndB B2 pndA VNB sky130_fd_pr__pfet_01v8_hvt m=4 w=1.0u l=0.15u mult=1 sa=0.265
+ sb=0.265 sd=0.28 area=0.063 perim=1.14
MMPC0 Y C1 pndB VNB sky130_fd_pr__pfet_01v8_hvt m=4 w=1.0u l=0.15u mult=1 sa=0.265
+ sb=0.265 sd=0.28 area=0.063 perim=1.14
MMNA0 Y A1 sndA1 VNB sky130_fd_pr__nfet_01v8 m=4 w=0.65u l=0.15u mult=1 sa=0.265
+ sb=0.265 sd=0.28 area=0.063 perim=1.14
MMNA1 sndA1 A2 VGND VNB sky130_fd_pr__nfet_01v8 m=4 w=0.65u l=0.15u mult=1 sa=0.265
+ sb=0.265 sd=0.28 area=0.063 perim=1.14
MMNB0 Y B1 sndB1 VNB sky130_fd_pr__nfet_01v8 m=4 w=0.65u l=0.15u mult=1 sa=0.265
+ sb=0.265 sd=0.28 area=0.063 perim=1.14
MMNB1 sndB1 B2 VGND VNB sky130_fd_pr__nfet_01v8 m=4 w=0.65u l=0.15u mult=1 sa=0.265
+ sb=0.265 sd=0.28 area=0.063 perim=1.14
MMNC0 Y C1 VGND VNB sky130_fd_pr__nfet_01v8 m=4 w=0.65u l=0.15u mult=1 sa=0.265
+ sb=0.265 sd=0.28 area=0.063 perim=1.14
.ENDS sky130_fd_sc_hd__a221oi_4
* Copyright 2020 The SkyWater PDK Authors
*
* Licensed under the Apache License, Version 2.0 (the "License");
* you may not use this file except in compliance with the License.
* You may obtain a copy of the License at
*
*     https:  www.apache.org licenses LICENSE-2.0
*
* Unless required by applicable law or agreed to in writing, software
* distributed under the License is distributed on an "AS IS" BASIS,
* WITHOUT WARRANTIES OR CONDITIONS OF ANY KIND, either express or implied.
* See the License for the specific language governing permissions and
* limitations under the License.
*
* SPDX-License-Identifier: Apache-2.0

.SUBCKT sky130_fd_sc_hd__a222oi_1 A1 A2 B1 B2 C1 C2 VGND VNB VNB net59 Y
*.PININFO A1:I A2:I B1:I B2:I C1:I C2:I VGND:I VNB:I VNB:I net59:I Y:O
MMPA0 pndA A1 net59 VNB sky130_fd_pr__pfet_01v8_hvt m=1 w=1.0u l=0.15u mult=1 sa=0.265
+ sb=0.265 sd=0.28 area=0.063 perim=1.14
MMPA1 pndA A2 net59 VNB sky130_fd_pr__pfet_01v8_hvt m=1 w=1.0u l=0.15u mult=1 sa=0.265
+ sb=0.265 sd=0.28 area=0.063 perim=1.14
MMPB0 pndB B1 pndA VNB sky130_fd_pr__pfet_01v8_hvt m=1 w=1.0u l=0.15u mult=1 sa=0.265
+ sb=0.265 sd=0.28 area=0.063 perim=1.14
MMPB1 pndB B2 pndA VNB sky130_fd_pr__pfet_01v8_hvt m=1 w=1.0u l=0.15u mult=1 sa=0.265
+ sb=0.265 sd=0.28 area=0.063 perim=1.14
MMPC0 Y C1 pndB VNB sky130_fd_pr__pfet_01v8_hvt m=1 w=1.0u l=0.15u mult=1 sa=0.265
+ sb=0.265 sd=0.28 area=0.063 perim=1.14
MI8 Y C2 pndB VNB sky130_fd_pr__pfet_01v8_hvt m=1 w=1.0u l=0.15u mult=1 sa=0.265
+ sb=0.265 sd=0.28 area=0.063 perim=1.14
MMNA0 Y A1 sndA1 VNB sky130_fd_pr__nfet_01v8 m=1 w=0.64u l=0.15u mult=1 sa=0.265
+ sb=0.265 sd=0.28 area=0.063 perim=1.14
MMNA1 sndA1 A2 VGND VNB sky130_fd_pr__nfet_01v8 m=1 w=0.64u l=0.15u mult=1 sa=0.265
+ sb=0.265 sd=0.28 area=0.063 perim=1.14
MMNB0 Y B1 sndB1 VNB sky130_fd_pr__nfet_01v8 m=1 w=0.64u l=0.15u mult=1 sa=0.265
+ sb=0.265 sd=0.28 area=0.063 perim=1.14
MMNB1 sndB1 B2 VGND VNB sky130_fd_pr__nfet_01v8 m=1 w=0.64u l=0.15u mult=1 sa=0.265
+ sb=0.265 sd=0.28 area=0.063 perim=1.14
MMNC0 Y C1 net62 VNB sky130_fd_pr__nfet_01v8 m=1 w=0.64u l=0.15u mult=1 sa=0.265
+ sb=0.265 sd=0.28 area=0.063 perim=1.14
MI10 net62 C2 VGND VNB sky130_fd_pr__nfet_01v8 m=1 w=0.64u l=0.15u mult=1 sa=0.265
+ sb=0.265 sd=0.28 area=0.063 perim=1.14
.ENDS sky130_fd_sc_hd__a222oi_1
* Copyright 2020 The SkyWater PDK Authors
*
* Licensed under the Apache License, Version 2.0 (the "License");
* you may not use this file except in compliance with the License.
* You may obtain a copy of the License at
*
*     https:  www.apache.org licenses LICENSE-2.0
*
* Unless required by applicable law or agreed to in writing, software
* distributed under the License is distributed on an "AS IS" BASIS,
* WITHOUT WARRANTIES OR CONDITIONS OF ANY KIND, either express or implied.
* See the License for the specific language governing permissions and
* limitations under the License.
*
* SPDX-License-Identifier: Apache-2.0

.SUBCKT sky130_fd_sc_hd__a22o_1 A1 A2 B1 B2 VGND VNB VNB net59 X
*.PININFO A1:I A2:I B1:I B2:I VGND:I VNB:I VNB:I net59:I X:O
MMPA0 pndA A1 net59 VNB sky130_fd_pr__pfet_01v8_hvt m=1 w=1.0u l=0.15u mult=1 sa=0.265
+ sb=0.265 sd=0.28 area=0.063 perim=1.14
MMPA1 pndA A2 net59 VNB sky130_fd_pr__pfet_01v8_hvt m=1 w=1.0u l=0.15u mult=1 sa=0.265
+ sb=0.265 sd=0.28 area=0.063 perim=1.14
MMPB0 y B1 pndA VNB sky130_fd_pr__pfet_01v8_hvt m=1 w=1.0u l=0.15u mult=1 sa=0.265
+ sb=0.265 sd=0.28 area=0.063 perim=1.14
MMPB1 y B2 pndA VNB sky130_fd_pr__pfet_01v8_hvt m=1 w=1.0u l=0.15u mult=1 sa=0.265
+ sb=0.265 sd=0.28 area=0.063 perim=1.14
MMIPX X y net59 VNB sky130_fd_pr__pfet_01v8_hvt m=1 w=1.0u l=0.15u mult=1 sa=0.265
+ sb=0.265 sd=0.28 area=0.063 perim=1.14
MMNA0 y A1 sndA1 VNB sky130_fd_pr__nfet_01v8 m=1 w=0.65u l=0.15u mult=1 sa=0.265
+ sb=0.265 sd=0.28 area=0.063 perim=1.14
MMNA1 sndA1 A2 VGND VNB sky130_fd_pr__nfet_01v8 m=1 w=0.65u l=0.15u mult=1 sa=0.265
+ sb=0.265 sd=0.28 area=0.063 perim=1.14
MMNB0 y B1 sndB1 VNB sky130_fd_pr__nfet_01v8 m=1 w=0.65u l=0.15u mult=1 sa=0.265
+ sb=0.265 sd=0.28 area=0.063 perim=1.14
MMNB1 sndB1 B2 VGND VNB sky130_fd_pr__nfet_01v8 m=1 w=0.65u l=0.15u mult=1 sa=0.265
+ sb=0.265 sd=0.28 area=0.063 perim=1.14
MMINX X y VGND VNB sky130_fd_pr__nfet_01v8 m=1 w=0.65u l=0.15u mult=1 sa=0.265
+ sb=0.265 sd=0.28 area=0.063 perim=1.14
.ENDS sky130_fd_sc_hd__a22o_1
* Copyright 2020 The SkyWater PDK Authors
*
* Licensed under the Apache License, Version 2.0 (the "License");
* you may not use this file except in compliance with the License.
* You may obtain a copy of the License at
*
*     https:  www.apache.org licenses LICENSE-2.0
*
* Unless required by applicable law or agreed to in writing, software
* distributed under the License is distributed on an "AS IS" BASIS,
* WITHOUT WARRANTIES OR CONDITIONS OF ANY KIND, either express or implied.
* See the License for the specific language governing permissions and
* limitations under the License.
*
* SPDX-License-Identifier: Apache-2.0

.SUBCKT sky130_fd_sc_hd__a22o_2 A1 A2 B1 B2 VGND VNB VNB net59 X
*.PININFO A1:I A2:I B1:I B2:I VGND:I VNB:I VNB:I net59:I X:O
MMPA0 pndA A1 net59 VNB sky130_fd_pr__pfet_01v8_hvt m=1 w=1.0u l=0.15u mult=1 sa=0.265
+ sb=0.265 sd=0.28 area=0.063 perim=1.14
MMPA1 pndA A2 net59 VNB sky130_fd_pr__pfet_01v8_hvt m=1 w=1.0u l=0.15u mult=1 sa=0.265
+ sb=0.265 sd=0.28 area=0.063 perim=1.14
MMPB0 y B1 pndA VNB sky130_fd_pr__pfet_01v8_hvt m=1 w=1.0u l=0.15u mult=1 sa=0.265
+ sb=0.265 sd=0.28 area=0.063 perim=1.14
MMPB1 y B2 pndA VNB sky130_fd_pr__pfet_01v8_hvt m=1 w=1.0u l=0.15u mult=1 sa=0.265
+ sb=0.265 sd=0.28 area=0.063 perim=1.14
MMIPX X y net59 VNB sky130_fd_pr__pfet_01v8_hvt m=2 w=1.0u l=0.15u mult=1 sa=0.265
+ sb=0.265 sd=0.28 area=0.063 perim=1.14
MMNA0 y A1 sndA1 VNB sky130_fd_pr__nfet_01v8 m=1 w=0.65u l=0.15u mult=1 sa=0.265
+ sb=0.265 sd=0.28 area=0.063 perim=1.14
MMNA1 sndA1 A2 VGND VNB sky130_fd_pr__nfet_01v8 m=1 w=0.65u l=0.15u mult=1 sa=0.265
+ sb=0.265 sd=0.28 area=0.063 perim=1.14
MMNB0 y B1 sndB1 VNB sky130_fd_pr__nfet_01v8 m=1 w=0.65u l=0.15u mult=1 sa=0.265
+ sb=0.265 sd=0.28 area=0.063 perim=1.14
MMNB1 sndB1 B2 VGND VNB sky130_fd_pr__nfet_01v8 m=1 w=0.65u l=0.15u mult=1 sa=0.265
+ sb=0.265 sd=0.28 area=0.063 perim=1.14
MMINX X y VGND VNB sky130_fd_pr__nfet_01v8 m=2 w=0.65u l=0.15u mult=1 sa=0.265
+ sb=0.265 sd=0.28 area=0.063 perim=1.14
.ENDS sky130_fd_sc_hd__a22o_2
* Copyright 2020 The SkyWater PDK Authors
*
* Licensed under the Apache License, Version 2.0 (the "License");
* you may not use this file except in compliance with the License.
* You may obtain a copy of the License at
*
*     https:  www.apache.org licenses LICENSE-2.0
*
* Unless required by applicable law or agreed to in writing, software
* distributed under the License is distributed on an "AS IS" BASIS,
* WITHOUT WARRANTIES OR CONDITIONS OF ANY KIND, either express or implied.
* See the License for the specific language governing permissions and
* limitations under the License.
*
* SPDX-License-Identifier: Apache-2.0

.SUBCKT sky130_fd_sc_hd__a22o_4 A1 A2 B1 B2 VGND VNB VNB net59 X
*.PININFO A1:I A2:I B1:I B2:I VGND:I VNB:I VNB:I net59:I X:O
MMPA0 pndA A1 net59 VNB sky130_fd_pr__pfet_01v8_hvt m=2 w=1.0u l=0.15u mult=1 sa=0.265
+ sb=0.265 sd=0.28 area=0.063 perim=1.14
MMPA1 pndA A2 net59 VNB sky130_fd_pr__pfet_01v8_hvt m=2 w=1.0u l=0.15u mult=1 sa=0.265
+ sb=0.265 sd=0.28 area=0.063 perim=1.14
MMPB0 y B1 pndA VNB sky130_fd_pr__pfet_01v8_hvt m=2 w=1.0u l=0.15u mult=1 sa=0.265
+ sb=0.265 sd=0.28 area=0.063 perim=1.14
MMPB1 y B2 pndA VNB sky130_fd_pr__pfet_01v8_hvt m=2 w=1.0u l=0.15u mult=1 sa=0.265
+ sb=0.265 sd=0.28 area=0.063 perim=1.14
MMIPX X y net59 VNB sky130_fd_pr__pfet_01v8_hvt m=4 w=1.0u l=0.15u mult=1 sa=0.265
+ sb=0.265 sd=0.28 area=0.063 perim=1.14
MMNA0 y A1 sndA1 VNB sky130_fd_pr__nfet_01v8 m=2 w=0.65u l=0.15u mult=1 sa=0.265
+ sb=0.265 sd=0.28 area=0.063 perim=1.14
MMNA1 sndA1 A2 VGND VNB sky130_fd_pr__nfet_01v8 m=2 w=0.65u l=0.15u mult=1 sa=0.265
+ sb=0.265 sd=0.28 area=0.063 perim=1.14
MMNB0 y B1 sndB1 VNB sky130_fd_pr__nfet_01v8 m=2 w=0.65u l=0.15u mult=1 sa=0.265
+ sb=0.265 sd=0.28 area=0.063 perim=1.14
MMNB1 sndB1 B2 VGND VNB sky130_fd_pr__nfet_01v8 m=2 w=0.65u l=0.15u mult=1 sa=0.265
+ sb=0.265 sd=0.28 area=0.063 perim=1.14
MMINX X y VGND VNB sky130_fd_pr__nfet_01v8 m=4 w=0.65u l=0.15u mult=1 sa=0.265
+ sb=0.265 sd=0.28 area=0.063 perim=1.14
.ENDS sky130_fd_sc_hd__a22o_4
* Copyright 2020 The SkyWater PDK Authors
*
* Licensed under the Apache License, Version 2.0 (the "License");
* you may not use this file except in compliance with the License.
* You may obtain a copy of the License at
*
*     https:  www.apache.org licenses LICENSE-2.0
*
* Unless required by applicable law or agreed to in writing, software
* distributed under the License is distributed on an "AS IS" BASIS,
* WITHOUT WARRANTIES OR CONDITIONS OF ANY KIND, either express or implied.
* See the License for the specific language governing permissions and
* limitations under the License.
*
* SPDX-License-Identifier: Apache-2.0

.SUBCKT sky130_fd_sc_hd__a22oi_1 A1 A2 B1 B2 VGND VNB VNB net59 Y
*.PININFO A1:I A2:I B1:I B2:I VGND:I VNB:I VNB:I net59:I Y:O
MMPA0 pndA A1 net59 VNB sky130_fd_pr__pfet_01v8_hvt m=1 w=1.0u l=0.15u mult=1 sa=0.265
+ sb=0.265 sd=0.28 area=0.063 perim=1.14
MMPA1 pndA A2 net59 VNB sky130_fd_pr__pfet_01v8_hvt m=1 w=1.0u l=0.15u mult=1 sa=0.265
+ sb=0.265 sd=0.28 area=0.063 perim=1.14
MMPB0 Y B1 pndA VNB sky130_fd_pr__pfet_01v8_hvt m=1 w=1.0u l=0.15u mult=1 sa=0.265
+ sb=0.265 sd=0.28 area=0.063 perim=1.14
MMPB1 Y B2 pndA VNB sky130_fd_pr__pfet_01v8_hvt m=1 w=1.0u l=0.15u mult=1 sa=0.265
+ sb=0.265 sd=0.28 area=0.063 perim=1.14
MMNA0 Y A1 sndA1 VNB sky130_fd_pr__nfet_01v8 m=1 w=0.65u l=0.15u mult=1 sa=0.265
+ sb=0.265 sd=0.28 area=0.063 perim=1.14
MMNA1 sndA1 A2 VGND VNB sky130_fd_pr__nfet_01v8 m=1 w=0.65u l=0.15u mult=1 sa=0.265
+ sb=0.265 sd=0.28 area=0.063 perim=1.14
MMNB0 Y B1 sndB1 VNB sky130_fd_pr__nfet_01v8 m=1 w=0.65u l=0.15u mult=1 sa=0.265
+ sb=0.265 sd=0.28 area=0.063 perim=1.14
MMNB1 sndB1 B2 VGND VNB sky130_fd_pr__nfet_01v8 m=1 w=0.65u l=0.15u mult=1 sa=0.265
+ sb=0.265 sd=0.28 area=0.063 perim=1.14
.ENDS sky130_fd_sc_hd__a22oi_1
* Copyright 2020 The SkyWater PDK Authors
*
* Licensed under the Apache License, Version 2.0 (the "License");
* you may not use this file except in compliance with the License.
* You may obtain a copy of the License at
*
*     https:  www.apache.org licenses LICENSE-2.0
*
* Unless required by applicable law or agreed to in writing, software
* distributed under the License is distributed on an "AS IS" BASIS,
* WITHOUT WARRANTIES OR CONDITIONS OF ANY KIND, either express or implied.
* See the License for the specific language governing permissions and
* limitations under the License.
*
* SPDX-License-Identifier: Apache-2.0

.SUBCKT sky130_fd_sc_hd__a22oi_2 A1 A2 B1 B2 VGND VNB VNB net59 Y
*.PININFO A1:I A2:I B1:I B2:I VGND:I VNB:I VNB:I net59:I Y:O
MMPA0 pndA A1 net59 VNB sky130_fd_pr__pfet_01v8_hvt m=2 w=1.0u l=0.15u mult=1 sa=0.265
+ sb=0.265 sd=0.28 area=0.063 perim=1.14
MMPA1 pndA A2 net59 VNB sky130_fd_pr__pfet_01v8_hvt m=2 w=1.0u l=0.15u mult=1 sa=0.265
+ sb=0.265 sd=0.28 area=0.063 perim=1.14
MMPB0 Y B1 pndA VNB sky130_fd_pr__pfet_01v8_hvt m=2 w=1.0u l=0.15u mult=1 sa=0.265
+ sb=0.265 sd=0.28 area=0.063 perim=1.14
MMPB1 Y B2 pndA VNB sky130_fd_pr__pfet_01v8_hvt m=2 w=1.0u l=0.15u mult=1 sa=0.265
+ sb=0.265 sd=0.28 area=0.063 perim=1.14
MMNA0 Y A1 sndA1 VNB sky130_fd_pr__nfet_01v8 m=2 w=0.65u l=0.15u mult=1 sa=0.265
+ sb=0.265 sd=0.28 area=0.063 perim=1.14
MMNA1 sndA1 A2 VGND VNB sky130_fd_pr__nfet_01v8 m=2 w=0.65u l=0.15u mult=1 sa=0.265
+ sb=0.265 sd=0.28 area=0.063 perim=1.14
MMNB0 Y B1 sndB1 VNB sky130_fd_pr__nfet_01v8 m=2 w=0.65u l=0.15u mult=1 sa=0.265
+ sb=0.265 sd=0.28 area=0.063 perim=1.14
MMNB1 sndB1 B2 VGND VNB sky130_fd_pr__nfet_01v8 m=2 w=0.65u l=0.15u mult=1 sa=0.265
+ sb=0.265 sd=0.28 area=0.063 perim=1.14
.ENDS sky130_fd_sc_hd__a22oi_2
* Copyright 2020 The SkyWater PDK Authors
*
* Licensed under the Apache License, Version 2.0 (the "License");
* you may not use this file except in compliance with the License.
* You may obtain a copy of the License at
*
*     https:  www.apache.org licenses LICENSE-2.0
*
* Unless required by applicable law or agreed to in writing, software
* distributed under the License is distributed on an "AS IS" BASIS,
* WITHOUT WARRANTIES OR CONDITIONS OF ANY KIND, either express or implied.
* See the License for the specific language governing permissions and
* limitations under the License.
*
* SPDX-License-Identifier: Apache-2.0

.SUBCKT sky130_fd_sc_hd__a22oi_4 A1 A2 B1 B2 VGND VNB VNB net59 Y
*.PININFO A1:I A2:I B1:I B2:I VGND:I VNB:I VNB:I net59:I Y:O
MMPA0 pndA A1 net59 VNB sky130_fd_pr__pfet_01v8_hvt m=4 w=1.0u l=0.15u mult=1 sa=0.265
+ sb=0.265 sd=0.28 area=0.063 perim=1.14
MMPA1 pndA A2 net59 VNB sky130_fd_pr__pfet_01v8_hvt m=4 w=1.0u l=0.15u mult=1 sa=0.265
+ sb=0.265 sd=0.28 area=0.063 perim=1.14
MMPB0 Y B1 pndA VNB sky130_fd_pr__pfet_01v8_hvt m=4 w=1.0u l=0.15u mult=1 sa=0.265
+ sb=0.265 sd=0.28 area=0.063 perim=1.14
MMPB1 Y B2 pndA VNB sky130_fd_pr__pfet_01v8_hvt m=4 w=1.0u l=0.15u mult=1 sa=0.265
+ sb=0.265 sd=0.28 area=0.063 perim=1.14
MMNA0 Y A1 sndA1 VNB sky130_fd_pr__nfet_01v8 m=4 w=0.65u l=0.15u mult=1 sa=0.265
+ sb=0.265 sd=0.28 area=0.063 perim=1.14
MMNA1 sndA1 A2 VGND VNB sky130_fd_pr__nfet_01v8 m=4 w=0.65u l=0.15u mult=1 sa=0.265
+ sb=0.265 sd=0.28 area=0.063 perim=1.14
MMNB0 Y B1 sndB1 VNB sky130_fd_pr__nfet_01v8 m=4 w=0.65u l=0.15u mult=1 sa=0.265
+ sb=0.265 sd=0.28 area=0.063 perim=1.14
MMNB1 sndB1 B2 VGND VNB sky130_fd_pr__nfet_01v8 m=4 w=0.65u l=0.15u mult=1 sa=0.265
+ sb=0.265 sd=0.28 area=0.063 perim=1.14
.ENDS sky130_fd_sc_hd__a22oi_4
* Copyright 2020 The SkyWater PDK Authors
*
* Licensed under the Apache License, Version 2.0 (the "License");
* you may not use this file except in compliance with the License.
* You may obtain a copy of the License at
*
*     https:  www.apache.org licenses LICENSE-2.0
*
* Unless required by applicable law or agreed to in writing, software
* distributed under the License is distributed on an "AS IS" BASIS,
* WITHOUT WARRANTIES OR CONDITIONS OF ANY KIND, either express or implied.
* See the License for the specific language governing permissions and
* limitations under the License.
*
* SPDX-License-Identifier: Apache-2.0

.SUBCKT sky130_fd_sc_hd__a2bb2o_1 A1_N A2_N B1 B2 VGND VNB VNB net59 X
*.PININFO A1_N:I A2_N:I B1:I B2:I VGND:I VNB:I VNB:I net59:I X:O
MMIN2 X y VGND VNB sky130_fd_pr__nfet_01v8 m=1 w=0.65u l=0.15u mult=1 sa=0.265
+ sb=0.265 sd=0.28 area=0.063 perim=1.14
MMNnor0 inor A1_N VGND VNB sky130_fd_pr__nfet_01v8 m=1 w=0.42u l=0.15u mult=1 sa=0.265
+ sb=0.265 sd=0.28 area=0.063 perim=1.14
MMNnor1 inor A2_N VGND VNB sky130_fd_pr__nfet_01v8 m=1 w=0.42u l=0.15u mult=1 sa=0.265
+ sb=0.265 sd=0.28 area=0.063 perim=1.14
MMNaoi10 VGND B1 sndNB1 VNB sky130_fd_pr__nfet_01v8 m=1 w=0.42u l=0.15u mult=1
+ sa=0.265 sb=0.265 sd=0.28 area=0.063 perim=1.14
MMNaoi11 sndNB1 B2 y VNB sky130_fd_pr__nfet_01v8 m=1 w=0.42u l=0.15u mult=1 sa=0.265
+ sb=0.265 sd=0.28 area=0.063 perim=1.14
MMNaoi20 y inor VGND VNB sky130_fd_pr__nfet_01v8 m=1 w=0.42u l=0.15u mult=1 sa=0.265
+ sb=0.265 sd=0.28 area=0.063 perim=1.14
MMPaoi20 y inor pmid VNB sky130_fd_pr__pfet_01v8_hvt m=1 w=0.42u l=0.15u mult=1
+ sa=0.265 sb=0.265 sd=0.28 area=0.063 perim=1.14
MMIP2 X y net59 VNB sky130_fd_pr__pfet_01v8_hvt m=1 w=1.0u l=0.15u mult=1 sa=0.265
+ sb=0.265 sd=0.28 area=0.063 perim=1.14
MMPnor0 net59 A1_N sndPA1N VNB sky130_fd_pr__pfet_01v8_hvt m=1 w=0.42u l=0.15u mult=1
+ sa=0.265 sb=0.265 sd=0.28 area=0.063 perim=1.14
MMPnor1 sndPA1N A2_N inor VNB sky130_fd_pr__pfet_01v8_hvt m=1 w=0.42u l=0.15u mult=1
+ sa=0.265 sb=0.265 sd=0.28 area=0.063 perim=1.14
MMPaoi10 pmid B1 net59 VNB sky130_fd_pr__pfet_01v8_hvt m=1 w=0.42u l=0.15u mult=1
+ sa=0.265 sb=0.265 sd=0.28 area=0.063 perim=1.14
MMPaoi11 pmid B2 net59 VNB sky130_fd_pr__pfet_01v8_hvt m=1 w=0.42u l=0.15u mult=1
+ sa=0.265 sb=0.265 sd=0.28 area=0.063 perim=1.14
.ENDS sky130_fd_sc_hd__a2bb2o_1
* Copyright 2020 The SkyWater PDK Authors
*
* Licensed under the Apache License, Version 2.0 (the "License");
* you may not use this file except in compliance with the License.
* You may obtain a copy of the License at
*
*     https:  www.apache.org licenses LICENSE-2.0
*
* Unless required by applicable law or agreed to in writing, software
* distributed under the License is distributed on an "AS IS" BASIS,
* WITHOUT WARRANTIES OR CONDITIONS OF ANY KIND, either express or implied.
* See the License for the specific language governing permissions and
* limitations under the License.
*
* SPDX-License-Identifier: Apache-2.0

.SUBCKT sky130_fd_sc_hd__a2bb2o_2 A1_N A2_N B1 B2 VGND VNB VNB net59 X
*.PININFO A1_N:I A2_N:I B1:I B2:I VGND:I VNB:I VNB:I net59:I X:O
MMIN2 X y VGND VNB sky130_fd_pr__nfet_01v8 m=2 w=0.65u l=0.15u mult=1 sa=0.265
+ sb=0.265 sd=0.28 area=0.063 perim=1.14
MMNnor0 inor A1_N VGND VNB sky130_fd_pr__nfet_01v8 m=1 w=0.42u l=0.15u mult=1 sa=0.265
+ sb=0.265 sd=0.28 area=0.063 perim=1.14
MMNnor1 inor A2_N VGND VNB sky130_fd_pr__nfet_01v8 m=1 w=0.42u l=0.15u mult=1 sa=0.265
+ sb=0.265 sd=0.28 area=0.063 perim=1.14
MMNaoi10 VGND B1 sndNB1 VNB sky130_fd_pr__nfet_01v8 m=1 w=0.42u l=0.15u mult=1
+ sa=0.265 sb=0.265 sd=0.28 area=0.063 perim=1.14
MMNaoi11 sndNB1 B2 y VNB sky130_fd_pr__nfet_01v8 m=1 w=0.42u l=0.15u mult=1 sa=0.265
+ sb=0.265 sd=0.28 area=0.063 perim=1.14
MMNaoi20 y inor VGND VNB sky130_fd_pr__nfet_01v8 m=1 w=0.42u l=0.15u mult=1 sa=0.265
+ sb=0.265 sd=0.28 area=0.063 perim=1.14
MMPaoi20 y inor pmid VNB sky130_fd_pr__pfet_01v8_hvt m=1 w=0.64u l=0.15u mult=1
+ sa=0.265 sb=0.265 sd=0.28 area=0.063 perim=1.14
MMIP2 X y net59 VNB sky130_fd_pr__pfet_01v8_hvt m=2 w=1.0u l=0.15u mult=1 sa=0.265
+ sb=0.265 sd=0.28 area=0.063 perim=1.14
MMPnor0 net59 A1_N sndPA1N VNB sky130_fd_pr__pfet_01v8_hvt m=1 w=0.64u l=0.15u mult=1
+ sa=0.265 sb=0.265 sd=0.28 area=0.063 perim=1.14
MMPnor1 sndPA1N A2_N inor VNB sky130_fd_pr__pfet_01v8_hvt m=1 w=0.64u l=0.15u mult=1
+ sa=0.265 sb=0.265 sd=0.28 area=0.063 perim=1.14
MMPaoi10 pmid B1 net59 VNB sky130_fd_pr__pfet_01v8_hvt m=1 w=0.64u l=0.15u mult=1
+ sa=0.265 sb=0.265 sd=0.28 area=0.063 perim=1.14
MMPaoi11 pmid B2 net59 VNB sky130_fd_pr__pfet_01v8_hvt m=1 w=0.64u l=0.15u mult=1
+ sa=0.265 sb=0.265 sd=0.28 area=0.063 perim=1.14
.ENDS sky130_fd_sc_hd__a2bb2o_2
* Copyright 2020 The SkyWater PDK Authors
*
* Licensed under the Apache License, Version 2.0 (the "License");
* you may not use this file except in compliance with the License.
* You may obtain a copy of the License at
*
*     https:  www.apache.org licenses LICENSE-2.0
*
* Unless required by applicable law or agreed to in writing, software
* distributed under the License is distributed on an "AS IS" BASIS,
* WITHOUT WARRANTIES OR CONDITIONS OF ANY KIND, either express or implied.
* See the License for the specific language governing permissions and
* limitations under the License.
*
* SPDX-License-Identifier: Apache-2.0

.SUBCKT sky130_fd_sc_hd__a2bb2o_4 A1_N A2_N B1 B2 VGND VNB VNB net59 X
*.PININFO A1_N:I A2_N:I B1:I B2:I VGND:I VNB:I VNB:I net59:I X:O
MMIN2 X y VGND VNB sky130_fd_pr__nfet_01v8 m=4 w=0.65u l=0.15u mult=1 sa=0.265
+ sb=0.265 sd=0.28 area=0.063 perim=1.14
MMNnor0 inor A1_N VGND VNB sky130_fd_pr__nfet_01v8 m=2 w=0.65u l=0.15u mult=1 sa=0.265
+ sb=0.265 sd=0.28 area=0.063 perim=1.14
MMNnor1 inor A2_N VGND VNB sky130_fd_pr__nfet_01v8 m=2 w=0.65u l=0.15u mult=1 sa=0.265
+ sb=0.265 sd=0.28 area=0.063 perim=1.14
MMNaoi10 VGND B1 sndNB1 VNB sky130_fd_pr__nfet_01v8 m=2 w=0.65u l=0.15u mult=1
+ sa=0.265 sb=0.265 sd=0.28 area=0.063 perim=1.14
MMNaoi11 sndNB1 B2 y VNB sky130_fd_pr__nfet_01v8 m=2 w=0.65u l=0.15u mult=1 sa=0.265
+ sb=0.265 sd=0.28 area=0.063 perim=1.14
MMNaoi20 y inor VGND VNB sky130_fd_pr__nfet_01v8 m=2 w=0.65u l=0.15u mult=1 sa=0.265
+ sb=0.265 sd=0.28 area=0.063 perim=1.14
MMPaoi20 y inor pmid VNB sky130_fd_pr__pfet_01v8_hvt m=2 w=1.0u l=0.15u mult=1
+ sa=0.265 sb=0.265 sd=0.28 area=0.063 perim=1.14
MMIP2 X y net59 VNB sky130_fd_pr__pfet_01v8_hvt m=4 w=1.0u l=0.15u mult=1 sa=0.265
+ sb=0.265 sd=0.28 area=0.063 perim=1.14
MMPnor0 net59 A1_N sndPA1N VNB sky130_fd_pr__pfet_01v8_hvt m=2 w=1.0u l=0.15u mult=1
+ sa=0.265 sb=0.265 sd=0.28 area=0.063 perim=1.14
MMPnor1 sndPA1N A2_N inor VNB sky130_fd_pr__pfet_01v8_hvt m=2 w=1.0u l=0.15u mult=1
+ sa=0.265 sb=0.265 sd=0.28 area=0.063 perim=1.14
MMPaoi10 pmid B1 net59 VNB sky130_fd_pr__pfet_01v8_hvt m=2 w=1.0u l=0.15u mult=1
+ sa=0.265 sb=0.265 sd=0.28 area=0.063 perim=1.14
MMPaoi11 pmid B2 net59 VNB sky130_fd_pr__pfet_01v8_hvt m=2 w=1.0u l=0.15u mult=1
+ sa=0.265 sb=0.265 sd=0.28 area=0.063 perim=1.14
.ENDS sky130_fd_sc_hd__a2bb2o_4
* Copyright 2020 The SkyWater PDK Authors
*
* Licensed under the Apache License, Version 2.0 (the "License");
* you may not use this file except in compliance with the License.
* You may obtain a copy of the License at
*
*     https:  www.apache.org licenses LICENSE-2.0
*
* Unless required by applicable law or agreed to in writing, software
* distributed under the License is distributed on an "AS IS" BASIS,
* WITHOUT WARRANTIES OR CONDITIONS OF ANY KIND, either express or implied.
* See the License for the specific language governing permissions and
* limitations under the License.
*
* SPDX-License-Identifier: Apache-2.0

.SUBCKT sky130_fd_sc_hd__a2bb2oi_1 A1_N A2_N B1 B2 VGND VNB VNB net59 Y
*.PININFO A1_N:I A2_N:I B1:I B2:I VGND:I VNB:I VNB:I net59:I Y:O
MMNnor0 inor A1_N VGND VNB sky130_fd_pr__nfet_01v8 m=1 w=0.65u l=0.15u mult=1 sa=0.265
+ sb=0.265 sd=0.28 area=0.063 perim=1.14
MMNnor1 inor A2_N VGND VNB sky130_fd_pr__nfet_01v8 m=1 w=0.65u l=0.15u mult=1 sa=0.265
+ sb=0.265 sd=0.28 area=0.063 perim=1.14
MMNaoi10 VGND B1 sndNB1 VNB sky130_fd_pr__nfet_01v8 m=1 w=0.65u l=0.15u mult=1
+ sa=0.265 sb=0.265 sd=0.28 area=0.063 perim=1.14
MMNaoi11 sndNB1 B2 Y VNB sky130_fd_pr__nfet_01v8 m=1 w=0.65u l=0.15u mult=1 sa=0.265
+ sb=0.265 sd=0.28 area=0.063 perim=1.14
MMNaoi20 Y inor VGND VNB sky130_fd_pr__nfet_01v8 m=1 w=0.65u l=0.15u mult=1 sa=0.265
+ sb=0.265 sd=0.28 area=0.063 perim=1.14
MMPnor0 net59 A1_N sndPA1N VNB sky130_fd_pr__pfet_01v8_hvt m=1 w=1.0u l=0.15u mult=1
+ sa=0.265 sb=0.265 sd=0.28 area=0.063 perim=1.14
MMPnor1 sndPA1N A2_N inor VNB sky130_fd_pr__pfet_01v8_hvt m=1 w=1.0u l=0.15u mult=1
+ sa=0.265 sb=0.265 sd=0.28 area=0.063 perim=1.14
MMPaoi10 pmid B1 net59 VNB sky130_fd_pr__pfet_01v8_hvt m=1 w=1.0u l=0.15u mult=1
+ sa=0.265 sb=0.265 sd=0.28 area=0.063 perim=1.14
MMPaoi11 pmid B2 net59 VNB sky130_fd_pr__pfet_01v8_hvt m=1 w=1.0u l=0.15u mult=1
+ sa=0.265 sb=0.265 sd=0.28 area=0.063 perim=1.14
MMPaoi20 Y inor pmid VNB sky130_fd_pr__pfet_01v8_hvt m=1 w=1.0u l=0.15u mult=1
+ sa=0.265 sb=0.265 sd=0.28 area=0.063 perim=1.14
.ENDS sky130_fd_sc_hd__a2bb2oi_1
* Copyright 2020 The SkyWater PDK Authors
*
* Licensed under the Apache License, Version 2.0 (the "License");
* you may not use this file except in compliance with the License.
* You may obtain a copy of the License at
*
*     https:  www.apache.org licenses LICENSE-2.0
*
* Unless required by applicable law or agreed to in writing, software
* distributed under the License is distributed on an "AS IS" BASIS,
* WITHOUT WARRANTIES OR CONDITIONS OF ANY KIND, either express or implied.
* See the License for the specific language governing permissions and
* limitations under the License.
*
* SPDX-License-Identifier: Apache-2.0

.SUBCKT sky130_fd_sc_hd__a2bb2oi_2 A1_N A2_N B1 B2 VGND VNB VNB net59 Y
*.PININFO A1_N:I A2_N:I B1:I B2:I VGND:I VNB:I VNB:I net59:I Y:O
MMNnor0 inor A1_N VGND VNB sky130_fd_pr__nfet_01v8 m=2 w=0.65u l=0.15u mult=1 sa=0.265
+ sb=0.265 sd=0.28 area=0.063 perim=1.14
MMNnor1 inor A2_N VGND VNB sky130_fd_pr__nfet_01v8 m=2 w=0.65u l=0.15u mult=1 sa=0.265
+ sb=0.265 sd=0.28 area=0.063 perim=1.14
MMNaoi10 VGND B1 sndNB1 VNB sky130_fd_pr__nfet_01v8 m=2 w=0.65u l=0.15u mult=1
+ sa=0.265 sb=0.265 sd=0.28 area=0.063 perim=1.14
MMNaoi11 sndNB1 B2 Y VNB sky130_fd_pr__nfet_01v8 m=2 w=0.65u l=0.15u mult=1 sa=0.265
+ sb=0.265 sd=0.28 area=0.063 perim=1.14
MMNaoi20 Y inor VGND VNB sky130_fd_pr__nfet_01v8 m=2 w=0.65u l=0.15u mult=1 sa=0.265
+ sb=0.265 sd=0.28 area=0.063 perim=1.14
MMPnor0 net59 A1_N sndPA1N VNB sky130_fd_pr__pfet_01v8_hvt m=2 w=1.0u l=0.15u mult=1
+ sa=0.265 sb=0.265 sd=0.28 area=0.063 perim=1.14
MMPnor1 sndPA1N A2_N inor VNB sky130_fd_pr__pfet_01v8_hvt m=2 w=1.0u l=0.15u mult=1
+ sa=0.265 sb=0.265 sd=0.28 area=0.063 perim=1.14
MMPaoi10 pmid B1 net59 VNB sky130_fd_pr__pfet_01v8_hvt m=2 w=1.0u l=0.15u mult=1
+ sa=0.265 sb=0.265 sd=0.28 area=0.063 perim=1.14
MMPaoi11 pmid B2 net59 VNB sky130_fd_pr__pfet_01v8_hvt m=2 w=1.0u l=0.15u mult=1
+ sa=0.265 sb=0.265 sd=0.28 area=0.063 perim=1.14
MMPaoi20 Y inor pmid VNB sky130_fd_pr__pfet_01v8_hvt m=2 w=1.0u l=0.15u mult=1
+ sa=0.265 sb=0.265 sd=0.28 area=0.063 perim=1.14
.ENDS sky130_fd_sc_hd__a2bb2oi_2
* Copyright 2020 The SkyWater PDK Authors
*
* Licensed under the Apache License, Version 2.0 (the "License");
* you may not use this file except in compliance with the License.
* You may obtain a copy of the License at
*
*     https:  www.apache.org licenses LICENSE-2.0
*
* Unless required by applicable law or agreed to in writing, software
* distributed under the License is distributed on an "AS IS" BASIS,
* WITHOUT WARRANTIES OR CONDITIONS OF ANY KIND, either express or implied.
* See the License for the specific language governing permissions and
* limitations under the License.
*
* SPDX-License-Identifier: Apache-2.0

.SUBCKT sky130_fd_sc_hd__a2bb2oi_4 A1_N A2_N B1 B2 VGND VNB VNB net59 Y
*.PININFO A1_N:I A2_N:I B1:I B2:I VGND:I VNB:I VNB:I net59:I Y:O
MMNnor0 inor A1_N VGND VNB sky130_fd_pr__nfet_01v8 m=4 w=0.65u l=0.15u mult=1 sa=0.265
+ sb=0.265 sd=0.28 area=0.063 perim=1.14
MMNnor1 inor A2_N VGND VNB sky130_fd_pr__nfet_01v8 m=4 w=0.65u l=0.15u mult=1 sa=0.265
+ sb=0.265 sd=0.28 area=0.063 perim=1.14
MMNaoi10 VGND B1 sndNB1 VNB sky130_fd_pr__nfet_01v8 m=4 w=0.65u l=0.15u mult=1
+ sa=0.265 sb=0.265 sd=0.28 area=0.063 perim=1.14
MMNaoi11 sndNB1 B2 Y VNB sky130_fd_pr__nfet_01v8 m=4 w=0.65u l=0.15u mult=1 sa=0.265
+ sb=0.265 sd=0.28 area=0.063 perim=1.14
MMNaoi20 Y inor VGND VNB sky130_fd_pr__nfet_01v8 m=4 w=0.65u l=0.15u mult=1 sa=0.265
+ sb=0.265 sd=0.28 area=0.063 perim=1.14
MMPnor0 net59 A1_N sndPA1N VNB sky130_fd_pr__pfet_01v8_hvt m=4 w=1.0u l=0.15u mult=1
+ sa=0.265 sb=0.265 sd=0.28 area=0.063 perim=1.14
MMPnor1 sndPA1N A2_N inor VNB sky130_fd_pr__pfet_01v8_hvt m=4 w=1.0u l=0.15u mult=1
+ sa=0.265 sb=0.265 sd=0.28 area=0.063 perim=1.14
MMPaoi10 pmid B1 net59 VNB sky130_fd_pr__pfet_01v8_hvt m=4 w=1.0u l=0.15u mult=1
+ sa=0.265 sb=0.265 sd=0.28 area=0.063 perim=1.14
MMPaoi11 pmid B2 net59 VNB sky130_fd_pr__pfet_01v8_hvt m=4 w=1.0u l=0.15u mult=1
+ sa=0.265 sb=0.265 sd=0.28 area=0.063 perim=1.14
MMPaoi20 Y inor pmid VNB sky130_fd_pr__pfet_01v8_hvt m=4 w=1.0u l=0.15u mult=1
+ sa=0.265 sb=0.265 sd=0.28 area=0.063 perim=1.14
.ENDS sky130_fd_sc_hd__a2bb2oi_4
* Copyright 2020 The SkyWater PDK Authors
*
* Licensed under the Apache License, Version 2.0 (the "License");
* you may not use this file except in compliance with the License.
* You may obtain a copy of the License at
*
*     https:  www.apache.org licenses LICENSE-2.0
*
* Unless required by applicable law or agreed to in writing, software
* distributed under the License is distributed on an "AS IS" BASIS,
* WITHOUT WARRANTIES OR CONDITIONS OF ANY KIND, either express or implied.
* See the License for the specific language governing permissions and
* limitations under the License.
*
* SPDX-License-Identifier: Apache-2.0

.SUBCKT sky130_fd_sc_hd__a311o_1 A1 A2 A3 B1 C1 VGND VNB VNB net59 X
*.PININFO A1:I A2:I A3:I B1:I C1:I VGND:I VNB:I VNB:I net59:I X:O
MMPA0 pndA A1 net59 VNB sky130_fd_pr__pfet_01v8_hvt m=1 w=1.0u l=0.15u mult=1 sa=0.265
+ sb=0.265 sd=0.28 area=0.063 perim=1.14
MMPA1 pndA A2 net59 VNB sky130_fd_pr__pfet_01v8_hvt m=1 w=1.0u l=0.15u mult=1 sa=0.265
+ sb=0.265 sd=0.28 area=0.063 perim=1.14
MMPA2 pndA A3 net59 VNB sky130_fd_pr__pfet_01v8_hvt m=1 w=1.0u l=0.15u mult=1 sa=0.265
+ sb=0.265 sd=0.28 area=0.063 perim=1.14
MMPB0 pndB B1 pndA VNB sky130_fd_pr__pfet_01v8_hvt m=1 w=1.0u l=0.15u mult=1 sa=0.265
+ sb=0.265 sd=0.28 area=0.063 perim=1.14
MMPC0 y C1 pndB VNB sky130_fd_pr__pfet_01v8_hvt m=1 w=1.0u l=0.15u mult=1 sa=0.265
+ sb=0.265 sd=0.28 area=0.063 perim=1.14
MMIPX X y net59 VNB sky130_fd_pr__pfet_01v8_hvt m=1 w=1.0u l=0.15u mult=1 sa=0.265
+ sb=0.265 sd=0.28 area=0.063 perim=1.14
MMNA0 y A1 sndA1 VNB sky130_fd_pr__nfet_01v8 m=1 w=0.65u l=0.15u mult=1 sa=0.265
+ sb=0.265 sd=0.28 area=0.063 perim=1.14
MMNA1 sndA1 A2 sndA2 VNB sky130_fd_pr__nfet_01v8 m=1 w=0.65u l=0.15u mult=1 sa=0.265
+ sb=0.265 sd=0.28 area=0.063 perim=1.14
MMNA2 sndA2 A3 VGND VNB sky130_fd_pr__nfet_01v8 m=1 w=0.65u l=0.15u mult=1 sa=0.265
+ sb=0.265 sd=0.28 area=0.063 perim=1.14
MMNB0 y B1 VGND VNB sky130_fd_pr__nfet_01v8 m=1 w=0.65u l=0.15u mult=1 sa=0.265
+ sb=0.265 sd=0.28 area=0.063 perim=1.14
MMNC0 y C1 VGND VNB sky130_fd_pr__nfet_01v8 m=1 w=0.65u l=0.15u mult=1 sa=0.265
+ sb=0.265 sd=0.28 area=0.063 perim=1.14
MMINX X y VGND VNB sky130_fd_pr__nfet_01v8 m=1 w=0.65u l=0.15u mult=1 sa=0.265
+ sb=0.265 sd=0.28 area=0.063 perim=1.14
.ENDS sky130_fd_sc_hd__a311o_1
* Copyright 2020 The SkyWater PDK Authors
*
* Licensed under the Apache License, Version 2.0 (the "License");
* you may not use this file except in compliance with the License.
* You may obtain a copy of the License at
*
*     https:  www.apache.org licenses LICENSE-2.0
*
* Unless required by applicable law or agreed to in writing, software
* distributed under the License is distributed on an "AS IS" BASIS,
* WITHOUT WARRANTIES OR CONDITIONS OF ANY KIND, either express or implied.
* See the License for the specific language governing permissions and
* limitations under the License.
*
* SPDX-License-Identifier: Apache-2.0

.SUBCKT sky130_fd_sc_hd__a311o_2 A1 A2 A3 B1 C1 VGND VNB VNB net59 X
*.PININFO A1:I A2:I A3:I B1:I C1:I VGND:I VNB:I VNB:I net59:I X:O
MMPA0 pndA A1 net59 VNB sky130_fd_pr__pfet_01v8_hvt m=1 w=1.0u l=0.15u mult=1 sa=0.265
+ sb=0.265 sd=0.28 area=0.063 perim=1.14
MMPA1 pndA A2 net59 VNB sky130_fd_pr__pfet_01v8_hvt m=1 w=1.0u l=0.15u mult=1 sa=0.265
+ sb=0.265 sd=0.28 area=0.063 perim=1.14
MMPA2 pndA A3 net59 VNB sky130_fd_pr__pfet_01v8_hvt m=1 w=1.0u l=0.15u mult=1 sa=0.265
+ sb=0.265 sd=0.28 area=0.063 perim=1.14
MMPB0 pndB B1 pndA VNB sky130_fd_pr__pfet_01v8_hvt m=1 w=1.0u l=0.15u mult=1 sa=0.265
+ sb=0.265 sd=0.28 area=0.063 perim=1.14
MMPC0 y C1 pndB VNB sky130_fd_pr__pfet_01v8_hvt m=1 w=1.0u l=0.15u mult=1 sa=0.265
+ sb=0.265 sd=0.28 area=0.063 perim=1.14
MMIPX X y net59 VNB sky130_fd_pr__pfet_01v8_hvt m=2 w=1.0u l=0.15u mult=1 sa=0.265
+ sb=0.265 sd=0.28 area=0.063 perim=1.14
MMNA0 y A1 sndA1 VNB sky130_fd_pr__nfet_01v8 m=1 w=0.65u l=0.15u mult=1 sa=0.265
+ sb=0.265 sd=0.28 area=0.063 perim=1.14
MMNA1 sndA1 A2 sndA2 VNB sky130_fd_pr__nfet_01v8 m=1 w=0.65u l=0.15u mult=1 sa=0.265
+ sb=0.265 sd=0.28 area=0.063 perim=1.14
MMNA2 sndA2 A3 VGND VNB sky130_fd_pr__nfet_01v8 m=1 w=0.65u l=0.15u mult=1 sa=0.265
+ sb=0.265 sd=0.28 area=0.063 perim=1.14
MMNB0 y B1 VGND VNB sky130_fd_pr__nfet_01v8 m=1 w=0.65u l=0.15u mult=1 sa=0.265
+ sb=0.265 sd=0.28 area=0.063 perim=1.14
MMNC0 y C1 VGND VNB sky130_fd_pr__nfet_01v8 m=1 w=0.65u l=0.15u mult=1 sa=0.265
+ sb=0.265 sd=0.28 area=0.063 perim=1.14
MMINX X y VGND VNB sky130_fd_pr__nfet_01v8 m=2 w=0.65u l=0.15u mult=1 sa=0.265
+ sb=0.265 sd=0.28 area=0.063 perim=1.14
.ENDS sky130_fd_sc_hd__a311o_2
* Copyright 2020 The SkyWater PDK Authors
*
* Licensed under the Apache License, Version 2.0 (the "License");
* you may not use this file except in compliance with the License.
* You may obtain a copy of the License at
*
*     https:  www.apache.org licenses LICENSE-2.0
*
* Unless required by applicable law or agreed to in writing, software
* distributed under the License is distributed on an "AS IS" BASIS,
* WITHOUT WARRANTIES OR CONDITIONS OF ANY KIND, either express or implied.
* See the License for the specific language governing permissions and
* limitations under the License.
*
* SPDX-License-Identifier: Apache-2.0

.SUBCKT sky130_fd_sc_hd__a311o_4 A1 A2 A3 B1 C1 VGND VNB VNB net59 X
*.PININFO A1:I A2:I A3:I B1:I C1:I VGND:I VNB:I VNB:I net59:I X:O
MMPA0 pndA A1 net59 VNB sky130_fd_pr__pfet_01v8_hvt m=2 w=1.0u l=0.15u mult=1 sa=0.265
+ sb=0.265 sd=0.28 area=0.063 perim=1.14
MMPA1 pndA A2 net59 VNB sky130_fd_pr__pfet_01v8_hvt m=2 w=1.0u l=0.15u mult=1 sa=0.265
+ sb=0.265 sd=0.28 area=0.063 perim=1.14
MMPA2 pndA A3 net59 VNB sky130_fd_pr__pfet_01v8_hvt m=2 w=1.0u l=0.15u mult=1 sa=0.265
+ sb=0.265 sd=0.28 area=0.063 perim=1.14
MMPB0 pndB B1 pndA VNB sky130_fd_pr__pfet_01v8_hvt m=2 w=1.0u l=0.15u mult=1 sa=0.265
+ sb=0.265 sd=0.28 area=0.063 perim=1.14
MMPC0 y C1 pndB VNB sky130_fd_pr__pfet_01v8_hvt m=2 w=1.0u l=0.15u mult=1 sa=0.265
+ sb=0.265 sd=0.28 area=0.063 perim=1.14
MMIPX X y net59 VNB sky130_fd_pr__pfet_01v8_hvt m=4 w=1.0u l=0.15u mult=1 sa=0.265
+ sb=0.265 sd=0.28 area=0.063 perim=1.14
MMNA0 y A1 sndA1 VNB sky130_fd_pr__nfet_01v8 m=2 w=0.65u l=0.15u mult=1 sa=0.265
+ sb=0.265 sd=0.28 area=0.063 perim=1.14
MMNA1 sndA1 A2 sndA2 VNB sky130_fd_pr__nfet_01v8 m=2 w=0.65u l=0.15u mult=1 sa=0.265
+ sb=0.265 sd=0.28 area=0.063 perim=1.14
MMNA2 sndA2 A3 VGND VNB sky130_fd_pr__nfet_01v8 m=2 w=0.65u l=0.15u mult=1 sa=0.265
+ sb=0.265 sd=0.28 area=0.063 perim=1.14
MMNB0 y B1 VGND VNB sky130_fd_pr__nfet_01v8 m=2 w=0.65u l=0.15u mult=1 sa=0.265
+ sb=0.265 sd=0.28 area=0.063 perim=1.14
MMNC0 y C1 VGND VNB sky130_fd_pr__nfet_01v8 m=2 w=0.65u l=0.15u mult=1 sa=0.265
+ sb=0.265 sd=0.28 area=0.063 perim=1.14
MMINX X y VGND VNB sky130_fd_pr__nfet_01v8 m=4 w=0.65u l=0.15u mult=1 sa=0.265
+ sb=0.265 sd=0.28 area=0.063 perim=1.14
.ENDS sky130_fd_sc_hd__a311o_4
* Copyright 2020 The SkyWater PDK Authors
*
* Licensed under the Apache License, Version 2.0 (the "License");
* you may not use this file except in compliance with the License.
* You may obtain a copy of the License at
*
*     https:  www.apache.org licenses LICENSE-2.0
*
* Unless required by applicable law or agreed to in writing, software
* distributed under the License is distributed on an "AS IS" BASIS,
* WITHOUT WARRANTIES OR CONDITIONS OF ANY KIND, either express or implied.
* See the License for the specific language governing permissions and
* limitations under the License.
*
* SPDX-License-Identifier: Apache-2.0

.SUBCKT sky130_fd_sc_hd__a311oi_1 A1 A2 A3 B1 C1 VGND VNB VNB net59 Y
*.PININFO A1:I A2:I A3:I B1:I C1:I VGND:I VNB:I VNB:I net59:I Y:O
MMPA0 pndA A1 net59 VNB sky130_fd_pr__pfet_01v8_hvt m=1 w=1.0u l=0.15u mult=1 sa=0.265
+ sb=0.265 sd=0.28 area=0.063 perim=1.14
MMPA1 pndA A2 net59 VNB sky130_fd_pr__pfet_01v8_hvt m=1 w=1.0u l=0.15u mult=1 sa=0.265
+ sb=0.265 sd=0.28 area=0.063 perim=1.14
MMPA2 pndA A3 net59 VNB sky130_fd_pr__pfet_01v8_hvt m=1 w=1.0u l=0.15u mult=1 sa=0.265
+ sb=0.265 sd=0.28 area=0.063 perim=1.14
MMPB0 pndB B1 pndA VNB sky130_fd_pr__pfet_01v8_hvt m=1 w=1.0u l=0.15u mult=1 sa=0.265
+ sb=0.265 sd=0.28 area=0.063 perim=1.14
MMPC0 Y C1 pndB VNB sky130_fd_pr__pfet_01v8_hvt m=1 w=1.0u l=0.15u mult=1 sa=0.265
+ sb=0.265 sd=0.28 area=0.063 perim=1.14
MMNA0 Y A1 sndA1 VNB sky130_fd_pr__nfet_01v8 m=1 w=0.65u l=0.15u mult=1 sa=0.265
+ sb=0.265 sd=0.28 area=0.063 perim=1.14
MMNA1 sndA1 A2 sndA2 VNB sky130_fd_pr__nfet_01v8 m=1 w=0.65u l=0.15u mult=1 sa=0.265
+ sb=0.265 sd=0.28 area=0.063 perim=1.14
MMNA2 sndA2 A3 VGND VNB sky130_fd_pr__nfet_01v8 m=1 w=0.65u l=0.15u mult=1 sa=0.265
+ sb=0.265 sd=0.28 area=0.063 perim=1.14
MMNB0 Y B1 VGND VNB sky130_fd_pr__nfet_01v8 m=1 w=0.65u l=0.15u mult=1 sa=0.265
+ sb=0.265 sd=0.28 area=0.063 perim=1.14
MMNC0 Y C1 VGND VNB sky130_fd_pr__nfet_01v8 m=1 w=0.65u l=0.15u mult=1 sa=0.265
+ sb=0.265 sd=0.28 area=0.063 perim=1.14
.ENDS sky130_fd_sc_hd__a311oi_1
* Copyright 2020 The SkyWater PDK Authors
*
* Licensed under the Apache License, Version 2.0 (the "License");
* you may not use this file except in compliance with the License.
* You may obtain a copy of the License at
*
*     https:  www.apache.org licenses LICENSE-2.0
*
* Unless required by applicable law or agreed to in writing, software
* distributed under the License is distributed on an "AS IS" BASIS,
* WITHOUT WARRANTIES OR CONDITIONS OF ANY KIND, either express or implied.
* See the License for the specific language governing permissions and
* limitations under the License.
*
* SPDX-License-Identifier: Apache-2.0

.SUBCKT sky130_fd_sc_hd__a311oi_2 A1 A2 A3 B1 C1 VGND VNB VNB net59 Y
*.PININFO A1:I A2:I A3:I B1:I C1:I VGND:I VNB:I VNB:I net59:I Y:O
MMPA0 pndA A1 net59 VNB sky130_fd_pr__pfet_01v8_hvt m=2 w=1.0u l=0.15u mult=1 sa=0.265
+ sb=0.265 sd=0.28 area=0.063 perim=1.14
MMPA1 pndA A2 net59 VNB sky130_fd_pr__pfet_01v8_hvt m=2 w=1.0u l=0.15u mult=1 sa=0.265
+ sb=0.265 sd=0.28 area=0.063 perim=1.14
MMPA2 pndA A3 net59 VNB sky130_fd_pr__pfet_01v8_hvt m=2 w=1.0u l=0.15u mult=1 sa=0.265
+ sb=0.265 sd=0.28 area=0.063 perim=1.14
MMPB0 pndB B1 pndA VNB sky130_fd_pr__pfet_01v8_hvt m=2 w=1.0u l=0.15u mult=1 sa=0.265
+ sb=0.265 sd=0.28 area=0.063 perim=1.14
MMPC0 Y C1 pndB VNB sky130_fd_pr__pfet_01v8_hvt m=2 w=1.0u l=0.15u mult=1 sa=0.265
+ sb=0.265 sd=0.28 area=0.063 perim=1.14
MMNA0 Y A1 sndA1 VNB sky130_fd_pr__nfet_01v8 m=2 w=0.65u l=0.15u mult=1 sa=0.265
+ sb=0.265 sd=0.28 area=0.063 perim=1.14
MMNA1 sndA1 A2 sndA2 VNB sky130_fd_pr__nfet_01v8 m=2 w=0.65u l=0.15u mult=1 sa=0.265
+ sb=0.265 sd=0.28 area=0.063 perim=1.14
MMNA2 sndA2 A3 VGND VNB sky130_fd_pr__nfet_01v8 m=2 w=0.65u l=0.15u mult=1 sa=0.265
+ sb=0.265 sd=0.28 area=0.063 perim=1.14
MMNB0 Y B1 VGND VNB sky130_fd_pr__nfet_01v8 m=2 w=0.65u l=0.15u mult=1 sa=0.265
+ sb=0.265 sd=0.28 area=0.063 perim=1.14
MMNC0 Y C1 VGND VNB sky130_fd_pr__nfet_01v8 m=2 w=0.65u l=0.15u mult=1 sa=0.265
+ sb=0.265 sd=0.28 area=0.063 perim=1.14
.ENDS sky130_fd_sc_hd__a311oi_2
* Copyright 2020 The SkyWater PDK Authors
*
* Licensed under the Apache License, Version 2.0 (the "License");
* you may not use this file except in compliance with the License.
* You may obtain a copy of the License at
*
*     https:  www.apache.org licenses LICENSE-2.0
*
* Unless required by applicable law or agreed to in writing, software
* distributed under the License is distributed on an "AS IS" BASIS,
* WITHOUT WARRANTIES OR CONDITIONS OF ANY KIND, either express or implied.
* See the License for the specific language governing permissions and
* limitations under the License.
*
* SPDX-License-Identifier: Apache-2.0

.SUBCKT sky130_fd_sc_hd__a311oi_4 A1 A2 A3 B1 C1 VGND VNB VNB net59 Y
*.PININFO A1:I A2:I A3:I B1:I C1:I VGND:I VNB:I VNB:I net59:I Y:O
MMPA0 pndA A1 net59 VNB sky130_fd_pr__pfet_01v8_hvt m=4 w=1.0u l=0.15u mult=1 sa=0.265
+ sb=0.265 sd=0.28 area=0.063 perim=1.14
MMPA1 pndA A2 net59 VNB sky130_fd_pr__pfet_01v8_hvt m=4 w=1.0u l=0.15u mult=1 sa=0.265
+ sb=0.265 sd=0.28 area=0.063 perim=1.14
MMPA2 pndA A3 net59 VNB sky130_fd_pr__pfet_01v8_hvt m=4 w=1.0u l=0.15u mult=1 sa=0.265
+ sb=0.265 sd=0.28 area=0.063 perim=1.14
MMPB0 pndB B1 pndA VNB sky130_fd_pr__pfet_01v8_hvt m=4 w=1.0u l=0.15u mult=1 sa=0.265
+ sb=0.265 sd=0.28 area=0.063 perim=1.14
MMPC0 Y C1 pndB VNB sky130_fd_pr__pfet_01v8_hvt m=4 w=1.0u l=0.15u mult=1 sa=0.265
+ sb=0.265 sd=0.28 area=0.063 perim=1.14
MMNA0 Y A1 sndA1 VNB sky130_fd_pr__nfet_01v8 m=4 w=0.65u l=0.15u mult=1 sa=0.265
+ sb=0.265 sd=0.28 area=0.063 perim=1.14
MMNA1 sndA1 A2 sndA2 VNB sky130_fd_pr__nfet_01v8 m=4 w=0.65u l=0.15u mult=1 sa=0.265
+ sb=0.265 sd=0.28 area=0.063 perim=1.14
MMNA2 sndA2 A3 VGND VNB sky130_fd_pr__nfet_01v8 m=4 w=0.65u l=0.15u mult=1 sa=0.265
+ sb=0.265 sd=0.28 area=0.063 perim=1.14
MMNB0 Y B1 VGND VNB sky130_fd_pr__nfet_01v8 m=4 w=0.65u l=0.15u mult=1 sa=0.265
+ sb=0.265 sd=0.28 area=0.063 perim=1.14
MMNC0 Y C1 VGND VNB sky130_fd_pr__nfet_01v8 m=4 w=0.65u l=0.15u mult=1 sa=0.265
+ sb=0.265 sd=0.28 area=0.063 perim=1.14
.ENDS sky130_fd_sc_hd__a311oi_4
* Copyright 2020 The SkyWater PDK Authors
*
* Licensed under the Apache License, Version 2.0 (the "License");
* you may not use this file except in compliance with the License.
* You may obtain a copy of the License at
*
*     https:  www.apache.org licenses LICENSE-2.0
*
* Unless required by applicable law or agreed to in writing, software
* distributed under the License is distributed on an "AS IS" BASIS,
* WITHOUT WARRANTIES OR CONDITIONS OF ANY KIND, either express or implied.
* See the License for the specific language governing permissions and
* limitations under the License.
*
* SPDX-License-Identifier: Apache-2.0

.SUBCKT sky130_fd_sc_hd__a31o_1 A1 A2 A3 B1 VGND VNB VNB net59 X
*.PININFO A1:I A2:I A3:I B1:I VGND:I VNB:I VNB:I net59:I X:O
MMPA0 pndA A1 net59 VNB sky130_fd_pr__pfet_01v8_hvt m=1 w=1.0u l=0.15u mult=1 sa=0.265
+ sb=0.265 sd=0.28 area=0.063 perim=1.14
MMPA1 pndA A2 net59 VNB sky130_fd_pr__pfet_01v8_hvt m=1 w=1.0u l=0.15u mult=1 sa=0.265
+ sb=0.265 sd=0.28 area=0.063 perim=1.14
MMPA2 pndA A3 net59 VNB sky130_fd_pr__pfet_01v8_hvt m=1 w=1.0u l=0.15u mult=1 sa=0.265
+ sb=0.265 sd=0.28 area=0.063 perim=1.14
MMPB0 y B1 pndA VNB sky130_fd_pr__pfet_01v8_hvt m=1 w=1.0u l=0.15u mult=1 sa=0.265
+ sb=0.265 sd=0.28 area=0.063 perim=1.14
MMIPX X y net59 VNB sky130_fd_pr__pfet_01v8_hvt m=1 w=1.0u l=0.15u mult=1 sa=0.265
+ sb=0.265 sd=0.28 area=0.063 perim=1.14
MMNA0 y A1 sndA1 VNB sky130_fd_pr__nfet_01v8 m=1 w=0.65u l=0.15u mult=1 sa=0.265
+ sb=0.265 sd=0.28 area=0.063 perim=1.14
MMNA1 sndA1 A2 sndA2 VNB sky130_fd_pr__nfet_01v8 m=1 w=0.65u l=0.15u mult=1 sa=0.265
+ sb=0.265 sd=0.28 area=0.063 perim=1.14
MMNA2 sndA2 A3 VGND VNB sky130_fd_pr__nfet_01v8 m=1 w=0.65u l=0.15u mult=1 sa=0.265
+ sb=0.265 sd=0.28 area=0.063 perim=1.14
MMNB0 y B1 VGND VNB sky130_fd_pr__nfet_01v8 m=1 w=0.65u l=0.15u mult=1 sa=0.265
+ sb=0.265 sd=0.28 area=0.063 perim=1.14
MMINX X y VGND VNB sky130_fd_pr__nfet_01v8 m=1 w=0.65u l=0.15u mult=1 sa=0.265
+ sb=0.265 sd=0.28 area=0.063 perim=1.14
.ENDS sky130_fd_sc_hd__a31o_1
* Copyright 2020 The SkyWater PDK Authors
*
* Licensed under the Apache License, Version 2.0 (the "License");
* you may not use this file except in compliance with the License.
* You may obtain a copy of the License at
*
*     https:  www.apache.org licenses LICENSE-2.0
*
* Unless required by applicable law or agreed to in writing, software
* distributed under the License is distributed on an "AS IS" BASIS,
* WITHOUT WARRANTIES OR CONDITIONS OF ANY KIND, either express or implied.
* See the License for the specific language governing permissions and
* limitations under the License.
*
* SPDX-License-Identifier: Apache-2.0

.SUBCKT sky130_fd_sc_hd__a31o_2 A1 A2 A3 B1 VGND VNB VNB net59 X
*.PININFO A1:I A2:I A3:I B1:I VGND:I VNB:I VNB:I net59:I X:O
MMPA0 pndA A1 net59 VNB sky130_fd_pr__pfet_01v8_hvt m=1 w=1.0u l=0.15u mult=1 sa=0.265
+ sb=0.265 sd=0.28 area=0.063 perim=1.14
MMPA1 pndA A2 net59 VNB sky130_fd_pr__pfet_01v8_hvt m=1 w=1.0u l=0.15u mult=1 sa=0.265
+ sb=0.265 sd=0.28 area=0.063 perim=1.14
MMPA2 pndA A3 net59 VNB sky130_fd_pr__pfet_01v8_hvt m=1 w=1.0u l=0.15u mult=1 sa=0.265
+ sb=0.265 sd=0.28 area=0.063 perim=1.14
MMPB0 y B1 pndA VNB sky130_fd_pr__pfet_01v8_hvt m=1 w=1.0u l=0.15u mult=1 sa=0.265
+ sb=0.265 sd=0.28 area=0.063 perim=1.14
MMIPX X y net59 VNB sky130_fd_pr__pfet_01v8_hvt m=2 w=1.0u l=0.15u mult=1 sa=0.265
+ sb=0.265 sd=0.28 area=0.063 perim=1.14
MMNA0 y A1 sndA1 VNB sky130_fd_pr__nfet_01v8 m=1 w=0.65u l=0.15u mult=1 sa=0.265
+ sb=0.265 sd=0.28 area=0.063 perim=1.14
MMNA1 sndA1 A2 sndA2 VNB sky130_fd_pr__nfet_01v8 m=1 w=0.65u l=0.15u mult=1 sa=0.265
+ sb=0.265 sd=0.28 area=0.063 perim=1.14
MMNA2 sndA2 A3 VGND VNB sky130_fd_pr__nfet_01v8 m=1 w=0.65u l=0.15u mult=1 sa=0.265
+ sb=0.265 sd=0.28 area=0.063 perim=1.14
MMNB0 y B1 VGND VNB sky130_fd_pr__nfet_01v8 m=1 w=0.65u l=0.15u mult=1 sa=0.265
+ sb=0.265 sd=0.28 area=0.063 perim=1.14
MMINX X y VGND VNB sky130_fd_pr__nfet_01v8 m=2 w=0.65u l=0.15u mult=1 sa=0.265
+ sb=0.265 sd=0.28 area=0.063 perim=1.14
.ENDS sky130_fd_sc_hd__a31o_2
* Copyright 2020 The SkyWater PDK Authors
*
* Licensed under the Apache License, Version 2.0 (the "License");
* you may not use this file except in compliance with the License.
* You may obtain a copy of the License at
*
*     https:  www.apache.org licenses LICENSE-2.0
*
* Unless required by applicable law or agreed to in writing, software
* distributed under the License is distributed on an "AS IS" BASIS,
* WITHOUT WARRANTIES OR CONDITIONS OF ANY KIND, either express or implied.
* See the License for the specific language governing permissions and
* limitations under the License.
*
* SPDX-License-Identifier: Apache-2.0

.SUBCKT sky130_fd_sc_hd__a31o_4 A1 A2 A3 B1 VGND VNB VNB net59 X
*.PININFO A1:I A2:I A3:I B1:I VGND:I VNB:I VNB:I net59:I X:O
MMPA0 pndA A1 net59 VNB sky130_fd_pr__pfet_01v8_hvt m=2 w=1.0u l=0.15u mult=1 sa=0.265
+ sb=0.265 sd=0.28 area=0.063 perim=1.14
MMPA1 pndA A2 net59 VNB sky130_fd_pr__pfet_01v8_hvt m=2 w=1.0u l=0.15u mult=1 sa=0.265
+ sb=0.265 sd=0.28 area=0.063 perim=1.14
MMPA2 pndA A3 net59 VNB sky130_fd_pr__pfet_01v8_hvt m=2 w=1.0u l=0.15u mult=1 sa=0.265
+ sb=0.265 sd=0.28 area=0.063 perim=1.14
MMPB0 y B1 pndA VNB sky130_fd_pr__pfet_01v8_hvt m=2 w=1.0u l=0.15u mult=1 sa=0.265
+ sb=0.265 sd=0.28 area=0.063 perim=1.14
MMIPX X y net59 VNB sky130_fd_pr__pfet_01v8_hvt m=4 w=1.0u l=0.15u mult=1 sa=0.265
+ sb=0.265 sd=0.28 area=0.063 perim=1.14
MMNA0 y A1 sndA1 VNB sky130_fd_pr__nfet_01v8 m=2 w=0.65u l=0.15u mult=1 sa=0.265
+ sb=0.265 sd=0.28 area=0.063 perim=1.14
MMNA1 sndA1 A2 sndA2 VNB sky130_fd_pr__nfet_01v8 m=2 w=0.65u l=0.15u mult=1 sa=0.265
+ sb=0.265 sd=0.28 area=0.063 perim=1.14
MMNA2 sndA2 A3 VGND VNB sky130_fd_pr__nfet_01v8 m=2 w=0.65u l=0.15u mult=1 sa=0.265
+ sb=0.265 sd=0.28 area=0.063 perim=1.14
MMNB0 y B1 VGND VNB sky130_fd_pr__nfet_01v8 m=2 w=0.65u l=0.15u mult=1 sa=0.265
+ sb=0.265 sd=0.28 area=0.063 perim=1.14
MMINX X y VGND VNB sky130_fd_pr__nfet_01v8 m=4 w=0.65u l=0.15u mult=1 sa=0.265
+ sb=0.265 sd=0.28 area=0.063 perim=1.14
.ENDS sky130_fd_sc_hd__a31o_4
* Copyright 2020 The SkyWater PDK Authors
*
* Licensed under the Apache License, Version 2.0 (the "License");
* you may not use this file except in compliance with the License.
* You may obtain a copy of the License at
*
*     https:  www.apache.org licenses LICENSE-2.0
*
* Unless required by applicable law or agreed to in writing, software
* distributed under the License is distributed on an "AS IS" BASIS,
* WITHOUT WARRANTIES OR CONDITIONS OF ANY KIND, either express or implied.
* See the License for the specific language governing permissions and
* limitations under the License.
*
* SPDX-License-Identifier: Apache-2.0

.SUBCKT sky130_fd_sc_hd__a31oi_1 A1 A2 A3 B1 VGND VNB VNB net59 Y
*.PININFO A1:I A2:I A3:I B1:I VGND:I VNB:I VNB:I net59:I Y:O
MMPA0 pndA A1 net59 VNB sky130_fd_pr__pfet_01v8_hvt m=1 w=1.0u l=0.15u mult=1 sa=0.265
+ sb=0.265 sd=0.28 area=0.063 perim=1.14
MMPA1 pndA A2 net59 VNB sky130_fd_pr__pfet_01v8_hvt m=1 w=1.0u l=0.15u mult=1 sa=0.265
+ sb=0.265 sd=0.28 area=0.063 perim=1.14
MMPA2 pndA A3 net59 VNB sky130_fd_pr__pfet_01v8_hvt m=1 w=1.0u l=0.15u mult=1 sa=0.265
+ sb=0.265 sd=0.28 area=0.063 perim=1.14
MMPB0 Y B1 pndA VNB sky130_fd_pr__pfet_01v8_hvt m=1 w=1.0u l=0.15u mult=1 sa=0.265
+ sb=0.265 sd=0.28 area=0.063 perim=1.14
MMNA0 Y A1 sndA1 VNB sky130_fd_pr__nfet_01v8 m=1 w=0.65u l=0.15u mult=1 sa=0.265
+ sb=0.265 sd=0.28 area=0.063 perim=1.14
MMNA1 sndA1 A2 sndA2 VNB sky130_fd_pr__nfet_01v8 m=1 w=0.65u l=0.15u mult=1 sa=0.265
+ sb=0.265 sd=0.28 area=0.063 perim=1.14
MMNA2 sndA2 A3 VGND VNB sky130_fd_pr__nfet_01v8 m=1 w=0.65u l=0.15u mult=1 sa=0.265
+ sb=0.265 sd=0.28 area=0.063 perim=1.14
MMNB0 Y B1 VGND VNB sky130_fd_pr__nfet_01v8 m=1 w=0.65u l=0.15u mult=1 sa=0.265
+ sb=0.265 sd=0.28 area=0.063 perim=1.14
.ENDS sky130_fd_sc_hd__a31oi_1
* Copyright 2020 The SkyWater PDK Authors
*
* Licensed under the Apache License, Version 2.0 (the "License");
* you may not use this file except in compliance with the License.
* You may obtain a copy of the License at
*
*     https:  www.apache.org licenses LICENSE-2.0
*
* Unless required by applicable law or agreed to in writing, software
* distributed under the License is distributed on an "AS IS" BASIS,
* WITHOUT WARRANTIES OR CONDITIONS OF ANY KIND, either express or implied.
* See the License for the specific language governing permissions and
* limitations under the License.
*
* SPDX-License-Identifier: Apache-2.0

.SUBCKT sky130_fd_sc_hd__a31oi_2 A1 A2 A3 B1 VGND VNB VNB net59 Y
*.PININFO A1:I A2:I A3:I B1:I VGND:I VNB:I VNB:I net59:I Y:O
MMPA0 pndA A1 net59 VNB sky130_fd_pr__pfet_01v8_hvt m=2 w=1.0u l=0.15u mult=1 sa=0.265
+ sb=0.265 sd=0.28 area=0.063 perim=1.14
MMPA1 pndA A2 net59 VNB sky130_fd_pr__pfet_01v8_hvt m=2 w=1.0u l=0.15u mult=1 sa=0.265
+ sb=0.265 sd=0.28 area=0.063 perim=1.14
MMPA2 pndA A3 net59 VNB sky130_fd_pr__pfet_01v8_hvt m=2 w=1.0u l=0.15u mult=1 sa=0.265
+ sb=0.265 sd=0.28 area=0.063 perim=1.14
MMPB0 Y B1 pndA VNB sky130_fd_pr__pfet_01v8_hvt m=2 w=1.0u l=0.15u mult=1 sa=0.265
+ sb=0.265 sd=0.28 area=0.063 perim=1.14
MMNA0 Y A1 sndA1 VNB sky130_fd_pr__nfet_01v8 m=2 w=0.65u l=0.15u mult=1 sa=0.265
+ sb=0.265 sd=0.28 area=0.063 perim=1.14
MMNA1 sndA1 A2 sndA2 VNB sky130_fd_pr__nfet_01v8 m=2 w=0.65u l=0.15u mult=1 sa=0.265
+ sb=0.265 sd=0.28 area=0.063 perim=1.14
MMNA2 sndA2 A3 VGND VNB sky130_fd_pr__nfet_01v8 m=2 w=0.65u l=0.15u mult=1 sa=0.265
+ sb=0.265 sd=0.28 area=0.063 perim=1.14
MMNB0 Y B1 VGND VNB sky130_fd_pr__nfet_01v8 m=2 w=0.65u l=0.15u mult=1 sa=0.265
+ sb=0.265 sd=0.28 area=0.063 perim=1.14
.ENDS sky130_fd_sc_hd__a31oi_2
* Copyright 2020 The SkyWater PDK Authors
*
* Licensed under the Apache License, Version 2.0 (the "License");
* you may not use this file except in compliance with the License.
* You may obtain a copy of the License at
*
*     https:  www.apache.org licenses LICENSE-2.0
*
* Unless required by applicable law or agreed to in writing, software
* distributed under the License is distributed on an "AS IS" BASIS,
* WITHOUT WARRANTIES OR CONDITIONS OF ANY KIND, either express or implied.
* See the License for the specific language governing permissions and
* limitations under the License.
*
* SPDX-License-Identifier: Apache-2.0

.SUBCKT sky130_fd_sc_hd__a31oi_4 A1 A2 A3 B1 VGND VNB VNB net59 Y
*.PININFO A1:I A2:I A3:I B1:I VGND:I VNB:I VNB:I net59:I Y:O
MMPA0 pndA A1 net59 VNB sky130_fd_pr__pfet_01v8_hvt m=4 w=1.0u l=0.15u mult=1 sa=0.265
+ sb=0.265 sd=0.28 area=0.063 perim=1.14
MMPA1 pndA A2 net59 VNB sky130_fd_pr__pfet_01v8_hvt m=4 w=1.0u l=0.15u mult=1 sa=0.265
+ sb=0.265 sd=0.28 area=0.063 perim=1.14
MMPA2 pndA A3 net59 VNB sky130_fd_pr__pfet_01v8_hvt m=4 w=1.0u l=0.15u mult=1 sa=0.265
+ sb=0.265 sd=0.28 area=0.063 perim=1.14
MMPB0 Y B1 pndA VNB sky130_fd_pr__pfet_01v8_hvt m=4 w=1.0u l=0.15u mult=1 sa=0.265
+ sb=0.265 sd=0.28 area=0.063 perim=1.14
MMNA0 Y A1 sndA1 VNB sky130_fd_pr__nfet_01v8 m=4 w=0.65u l=0.15u mult=1 sa=0.265
+ sb=0.265 sd=0.28 area=0.063 perim=1.14
MMNA1 sndA1 A2 sndA2 VNB sky130_fd_pr__nfet_01v8 m=4 w=0.65u l=0.15u mult=1 sa=0.265
+ sb=0.265 sd=0.28 area=0.063 perim=1.14
MMNA2 sndA2 A3 VGND VNB sky130_fd_pr__nfet_01v8 m=4 w=0.65u l=0.15u mult=1 sa=0.265
+ sb=0.265 sd=0.28 area=0.063 perim=1.14
MMNB0 Y B1 VGND VNB sky130_fd_pr__nfet_01v8 m=4 w=0.65u l=0.15u mult=1 sa=0.265
+ sb=0.265 sd=0.28 area=0.063 perim=1.14
.ENDS sky130_fd_sc_hd__a31oi_4
* Copyright 2020 The SkyWater PDK Authors
*
* Licensed under the Apache License, Version 2.0 (the "License");
* you may not use this file except in compliance with the License.
* You may obtain a copy of the License at
*
*     https:  www.apache.org licenses LICENSE-2.0
*
* Unless required by applicable law or agreed to in writing, software
* distributed under the License is distributed on an "AS IS" BASIS,
* WITHOUT WARRANTIES OR CONDITIONS OF ANY KIND, either express or implied.
* See the License for the specific language governing permissions and
* limitations under the License.
*
* SPDX-License-Identifier: Apache-2.0

.SUBCKT sky130_fd_sc_hd__a32o_1 A1 A2 A3 B1 B2 VGND VNB VNB net59 X
*.PININFO A1:I A2:I A3:I B1:I B2:I VGND:I VNB:I VNB:I net59:I X:O
MMPA0 pndA A1 net59 VNB sky130_fd_pr__pfet_01v8_hvt m=1 w=1.0u l=0.15u mult=1 sa=0.265
+ sb=0.265 sd=0.28 area=0.063 perim=1.14
MMPA1 pndA A2 net59 VNB sky130_fd_pr__pfet_01v8_hvt m=1 w=1.0u l=0.15u mult=1 sa=0.265
+ sb=0.265 sd=0.28 area=0.063 perim=1.14
MMPA2 pndA A3 net59 VNB sky130_fd_pr__pfet_01v8_hvt m=1 w=1.0u l=0.15u mult=1 sa=0.265
+ sb=0.265 sd=0.28 area=0.063 perim=1.14
MMPB0 y B1 pndA VNB sky130_fd_pr__pfet_01v8_hvt m=1 w=1.0u l=0.15u mult=1 sa=0.265
+ sb=0.265 sd=0.28 area=0.063 perim=1.14
MMPB1 y B2 pndA VNB sky130_fd_pr__pfet_01v8_hvt m=1 w=1.0u l=0.15u mult=1 sa=0.265
+ sb=0.265 sd=0.28 area=0.063 perim=1.14
MMIPX X y net59 VNB sky130_fd_pr__pfet_01v8_hvt m=1 w=1.0u l=0.15u mult=1 sa=0.265
+ sb=0.265 sd=0.28 area=0.063 perim=1.14
MMNA0 y A1 sndA1 VNB sky130_fd_pr__nfet_01v8 m=1 w=0.65u l=0.15u mult=1 sa=0.265
+ sb=0.265 sd=0.28 area=0.063 perim=1.14
MMNA1 sndA1 A2 sndA2 VNB sky130_fd_pr__nfet_01v8 m=1 w=0.65u l=0.15u mult=1 sa=0.265
+ sb=0.265 sd=0.28 area=0.063 perim=1.14
MMNA2 sndA2 A3 VGND VNB sky130_fd_pr__nfet_01v8 m=1 w=0.65u l=0.15u mult=1 sa=0.265
+ sb=0.265 sd=0.28 area=0.063 perim=1.14
MMNB0 y B1 sndB1 VNB sky130_fd_pr__nfet_01v8 m=1 w=0.65u l=0.15u mult=1 sa=0.265
+ sb=0.265 sd=0.28 area=0.063 perim=1.14
MMNB1 sndB1 B2 VGND VNB sky130_fd_pr__nfet_01v8 m=1 w=0.65u l=0.15u mult=1 sa=0.265
+ sb=0.265 sd=0.28 area=0.063 perim=1.14
MMINX X y VGND VNB sky130_fd_pr__nfet_01v8 m=1 w=0.65u l=0.15u mult=1 sa=0.265
+ sb=0.265 sd=0.28 area=0.063 perim=1.14
.ENDS sky130_fd_sc_hd__a32o_1
* Copyright 2020 The SkyWater PDK Authors
*
* Licensed under the Apache License, Version 2.0 (the "License");
* you may not use this file except in compliance with the License.
* You may obtain a copy of the License at
*
*     https:  www.apache.org licenses LICENSE-2.0
*
* Unless required by applicable law or agreed to in writing, software
* distributed under the License is distributed on an "AS IS" BASIS,
* WITHOUT WARRANTIES OR CONDITIONS OF ANY KIND, either express or implied.
* See the License for the specific language governing permissions and
* limitations under the License.
*
* SPDX-License-Identifier: Apache-2.0

.SUBCKT sky130_fd_sc_hd__a32o_2 A1 A2 A3 B1 B2 VGND VNB VNB net59 X
*.PININFO A1:I A2:I A3:I B1:I B2:I VGND:I VNB:I VNB:I net59:I X:O
MMPA0 pndA A1 net59 VNB sky130_fd_pr__pfet_01v8_hvt m=1 w=1.0u l=0.15u mult=1 sa=0.265
+ sb=0.265 sd=0.28 area=0.063 perim=1.14
MMPA1 pndA A2 net59 VNB sky130_fd_pr__pfet_01v8_hvt m=1 w=1.0u l=0.15u mult=1 sa=0.265
+ sb=0.265 sd=0.28 area=0.063 perim=1.14
MMPA2 pndA A3 net59 VNB sky130_fd_pr__pfet_01v8_hvt m=1 w=1.0u l=0.15u mult=1 sa=0.265
+ sb=0.265 sd=0.28 area=0.063 perim=1.14
MMPB0 y B1 pndA VNB sky130_fd_pr__pfet_01v8_hvt m=1 w=1.0u l=0.15u mult=1 sa=0.265
+ sb=0.265 sd=0.28 area=0.063 perim=1.14
MMPB1 y B2 pndA VNB sky130_fd_pr__pfet_01v8_hvt m=1 w=1.0u l=0.15u mult=1 sa=0.265
+ sb=0.265 sd=0.28 area=0.063 perim=1.14
MMIPX X y net59 VNB sky130_fd_pr__pfet_01v8_hvt m=2 w=1.0u l=0.15u mult=1 sa=0.265
+ sb=0.265 sd=0.28 area=0.063 perim=1.14
MMNA0 y A1 sndA1 VNB sky130_fd_pr__nfet_01v8 m=1 w=0.65u l=0.15u mult=1 sa=0.265
+ sb=0.265 sd=0.28 area=0.063 perim=1.14
MMNA1 sndA1 A2 sndA2 VNB sky130_fd_pr__nfet_01v8 m=1 w=0.65u l=0.15u mult=1 sa=0.265
+ sb=0.265 sd=0.28 area=0.063 perim=1.14
MMNA2 sndA2 A3 VGND VNB sky130_fd_pr__nfet_01v8 m=1 w=0.65u l=0.15u mult=1 sa=0.265
+ sb=0.265 sd=0.28 area=0.063 perim=1.14
MMNB0 y B1 sndB1 VNB sky130_fd_pr__nfet_01v8 m=1 w=0.65u l=0.15u mult=1 sa=0.265
+ sb=0.265 sd=0.28 area=0.063 perim=1.14
MMNB1 sndB1 B2 VGND VNB sky130_fd_pr__nfet_01v8 m=1 w=0.65u l=0.15u mult=1 sa=0.265
+ sb=0.265 sd=0.28 area=0.063 perim=1.14
MMINX X y VGND VNB sky130_fd_pr__nfet_01v8 m=2 w=0.65u l=0.15u mult=1 sa=0.265
+ sb=0.265 sd=0.28 area=0.063 perim=1.14
.ENDS sky130_fd_sc_hd__a32o_2
* Copyright 2020 The SkyWater PDK Authors
*
* Licensed under the Apache License, Version 2.0 (the "License");
* you may not use this file except in compliance with the License.
* You may obtain a copy of the License at
*
*     https:  www.apache.org licenses LICENSE-2.0
*
* Unless required by applicable law or agreed to in writing, software
* distributed under the License is distributed on an "AS IS" BASIS,
* WITHOUT WARRANTIES OR CONDITIONS OF ANY KIND, either express or implied.
* See the License for the specific language governing permissions and
* limitations under the License.
*
* SPDX-License-Identifier: Apache-2.0

.SUBCKT sky130_fd_sc_hd__a32o_4 A1 A2 A3 B1 B2 VGND VNB VNB net59 X
*.PININFO A1:I A2:I A3:I B1:I B2:I VGND:I VNB:I VNB:I net59:I X:O
MMPA0 pndA A1 net59 VNB sky130_fd_pr__pfet_01v8_hvt m=2 w=1.0u l=0.15u mult=1 sa=0.265
+ sb=0.265 sd=0.28 area=0.063 perim=1.14
MMPA1 pndA A2 net59 VNB sky130_fd_pr__pfet_01v8_hvt m=2 w=1.0u l=0.15u mult=1 sa=0.265
+ sb=0.265 sd=0.28 area=0.063 perim=1.14
MMPA2 pndA A3 net59 VNB sky130_fd_pr__pfet_01v8_hvt m=2 w=1.0u l=0.15u mult=1 sa=0.265
+ sb=0.265 sd=0.28 area=0.063 perim=1.14
MMPB0 y B1 pndA VNB sky130_fd_pr__pfet_01v8_hvt m=2 w=1.0u l=0.15u mult=1 sa=0.265
+ sb=0.265 sd=0.28 area=0.063 perim=1.14
MMPB1 y B2 pndA VNB sky130_fd_pr__pfet_01v8_hvt m=2 w=1.0u l=0.15u mult=1 sa=0.265
+ sb=0.265 sd=0.28 area=0.063 perim=1.14
MMIPX X y net59 VNB sky130_fd_pr__pfet_01v8_hvt m=4 w=1.0u l=0.15u mult=1 sa=0.265
+ sb=0.265 sd=0.28 area=0.063 perim=1.14
MMNA0 y A1 sndA1 VNB sky130_fd_pr__nfet_01v8 m=2 w=0.65u l=0.15u mult=1 sa=0.265
+ sb=0.265 sd=0.28 area=0.063 perim=1.14
MMNA1 sndA1 A2 sndA2 VNB sky130_fd_pr__nfet_01v8 m=2 w=0.65u l=0.15u mult=1 sa=0.265
+ sb=0.265 sd=0.28 area=0.063 perim=1.14
MMNA2 sndA2 A3 VGND VNB sky130_fd_pr__nfet_01v8 m=2 w=0.65u l=0.15u mult=1 sa=0.265
+ sb=0.265 sd=0.28 area=0.063 perim=1.14
MMNB0 y B1 sndB1 VNB sky130_fd_pr__nfet_01v8 m=2 w=0.65u l=0.15u mult=1 sa=0.265
+ sb=0.265 sd=0.28 area=0.063 perim=1.14
MMNB1 sndB1 B2 VGND VNB sky130_fd_pr__nfet_01v8 m=2 w=0.65u l=0.15u mult=1 sa=0.265
+ sb=0.265 sd=0.28 area=0.063 perim=1.14
MMINX X y VGND VNB sky130_fd_pr__nfet_01v8 m=4 w=0.65u l=0.15u mult=1 sa=0.265
+ sb=0.265 sd=0.28 area=0.063 perim=1.14
.ENDS sky130_fd_sc_hd__a32o_4
* Copyright 2020 The SkyWater PDK Authors
*
* Licensed under the Apache License, Version 2.0 (the "License");
* you may not use this file except in compliance with the License.
* You may obtain a copy of the License at
*
*     https:  www.apache.org licenses LICENSE-2.0
*
* Unless required by applicable law or agreed to in writing, software
* distributed under the License is distributed on an "AS IS" BASIS,
* WITHOUT WARRANTIES OR CONDITIONS OF ANY KIND, either express or implied.
* See the License for the specific language governing permissions and
* limitations under the License.
*
* SPDX-License-Identifier: Apache-2.0

.SUBCKT sky130_fd_sc_hd__a32oi_1 A1 A2 A3 B1 B2 VGND VNB VNB net59 Y
*.PININFO A1:I A2:I A3:I B1:I B2:I VGND:I VNB:I VNB:I net59:I Y:O
MMPA0 pndA A1 net59 VNB sky130_fd_pr__pfet_01v8_hvt m=1 w=1.0u l=0.15u mult=1 sa=0.265
+ sb=0.265 sd=0.28 area=0.063 perim=1.14
MMPA1 pndA A2 net59 VNB sky130_fd_pr__pfet_01v8_hvt m=1 w=1.0u l=0.15u mult=1 sa=0.265
+ sb=0.265 sd=0.28 area=0.063 perim=1.14
MMPA2 pndA A3 net59 VNB sky130_fd_pr__pfet_01v8_hvt m=1 w=1.0u l=0.15u mult=1 sa=0.265
+ sb=0.265 sd=0.28 area=0.063 perim=1.14
MMPB0 Y B1 pndA VNB sky130_fd_pr__pfet_01v8_hvt m=1 w=1.0u l=0.15u mult=1 sa=0.265
+ sb=0.265 sd=0.28 area=0.063 perim=1.14
MMPB1 Y B2 pndA VNB sky130_fd_pr__pfet_01v8_hvt m=1 w=1.0u l=0.15u mult=1 sa=0.265
+ sb=0.265 sd=0.28 area=0.063 perim=1.14
MMNA0 Y A1 sndA1 VNB sky130_fd_pr__nfet_01v8 m=1 w=0.65u l=0.15u mult=1 sa=0.265
+ sb=0.265 sd=0.28 area=0.063 perim=1.14
MMNA1 sndA1 A2 sndA2 VNB sky130_fd_pr__nfet_01v8 m=1 w=0.65u l=0.15u mult=1 sa=0.265
+ sb=0.265 sd=0.28 area=0.063 perim=1.14
MMNA2 sndA2 A3 VGND VNB sky130_fd_pr__nfet_01v8 m=1 w=0.65u l=0.15u mult=1 sa=0.265
+ sb=0.265 sd=0.28 area=0.063 perim=1.14
MMNB0 Y B1 sndB1 VNB sky130_fd_pr__nfet_01v8 m=1 w=0.65u l=0.15u mult=1 sa=0.265
+ sb=0.265 sd=0.28 area=0.063 perim=1.14
MMNB1 sndB1 B2 VGND VNB sky130_fd_pr__nfet_01v8 m=1 w=0.65u l=0.15u mult=1 sa=0.265
+ sb=0.265 sd=0.28 area=0.063 perim=1.14
.ENDS sky130_fd_sc_hd__a32oi_1
* Copyright 2020 The SkyWater PDK Authors
*
* Licensed under the Apache License, Version 2.0 (the "License");
* you may not use this file except in compliance with the License.
* You may obtain a copy of the License at
*
*     https:  www.apache.org licenses LICENSE-2.0
*
* Unless required by applicable law or agreed to in writing, software
* distributed under the License is distributed on an "AS IS" BASIS,
* WITHOUT WARRANTIES OR CONDITIONS OF ANY KIND, either express or implied.
* See the License for the specific language governing permissions and
* limitations under the License.
*
* SPDX-License-Identifier: Apache-2.0

.SUBCKT sky130_fd_sc_hd__a32oi_2 A1 A2 A3 B1 B2 VGND VNB VNB net59 Y
*.PININFO A1:I A2:I A3:I B1:I B2:I VGND:I VNB:I VNB:I net59:I Y:O
MMPA0 pndA A1 net59 VNB sky130_fd_pr__pfet_01v8_hvt m=2 w=1.0u l=0.15u mult=1 sa=0.265
+ sb=0.265 sd=0.28 area=0.063 perim=1.14
MMPA1 pndA A2 net59 VNB sky130_fd_pr__pfet_01v8_hvt m=2 w=1.0u l=0.15u mult=1 sa=0.265
+ sb=0.265 sd=0.28 area=0.063 perim=1.14
MMPA2 pndA A3 net59 VNB sky130_fd_pr__pfet_01v8_hvt m=2 w=1.0u l=0.15u mult=1 sa=0.265
+ sb=0.265 sd=0.28 area=0.063 perim=1.14
MMPB0 Y B1 pndA VNB sky130_fd_pr__pfet_01v8_hvt m=2 w=1.0u l=0.15u mult=1 sa=0.265
+ sb=0.265 sd=0.28 area=0.063 perim=1.14
MMPB1 Y B2 pndA VNB sky130_fd_pr__pfet_01v8_hvt m=2 w=1.0u l=0.15u mult=1 sa=0.265
+ sb=0.265 sd=0.28 area=0.063 perim=1.14
MMNA0 Y A1 sndA1 VNB sky130_fd_pr__nfet_01v8 m=2 w=0.65u l=0.15u mult=1 sa=0.265
+ sb=0.265 sd=0.28 area=0.063 perim=1.14
MMNA1 sndA1 A2 sndA2 VNB sky130_fd_pr__nfet_01v8 m=2 w=0.65u l=0.15u mult=1 sa=0.265
+ sb=0.265 sd=0.28 area=0.063 perim=1.14
MMNA2 sndA2 A3 VGND VNB sky130_fd_pr__nfet_01v8 m=2 w=0.65u l=0.15u mult=1 sa=0.265
+ sb=0.265 sd=0.28 area=0.063 perim=1.14
MMNB0 Y B1 sndB1 VNB sky130_fd_pr__nfet_01v8 m=2 w=0.65u l=0.15u mult=1 sa=0.265
+ sb=0.265 sd=0.28 area=0.063 perim=1.14
MMNB1 sndB1 B2 VGND VNB sky130_fd_pr__nfet_01v8 m=2 w=0.65u l=0.15u mult=1 sa=0.265
+ sb=0.265 sd=0.28 area=0.063 perim=1.14
.ENDS sky130_fd_sc_hd__a32oi_2
* Copyright 2020 The SkyWater PDK Authors
*
* Licensed under the Apache License, Version 2.0 (the "License");
* you may not use this file except in compliance with the License.
* You may obtain a copy of the License at
*
*     https:  www.apache.org licenses LICENSE-2.0
*
* Unless required by applicable law or agreed to in writing, software
* distributed under the License is distributed on an "AS IS" BASIS,
* WITHOUT WARRANTIES OR CONDITIONS OF ANY KIND, either express or implied.
* See the License for the specific language governing permissions and
* limitations under the License.
*
* SPDX-License-Identifier: Apache-2.0

.SUBCKT sky130_fd_sc_hd__a32oi_4 A1 A2 A3 B1 B2 VGND VNB VNB net59 Y
*.PININFO A1:I A2:I A3:I B1:I B2:I VGND:I VNB:I VNB:I net59:I Y:O
MMPA0 pndA A1 net59 VNB sky130_fd_pr__pfet_01v8_hvt m=4 w=1.0u l=0.15u mult=1 sa=0.265
+ sb=0.265 sd=0.28 area=0.063 perim=1.14
MMPA1 pndA A2 net59 VNB sky130_fd_pr__pfet_01v8_hvt m=4 w=1.0u l=0.15u mult=1 sa=0.265
+ sb=0.265 sd=0.28 area=0.063 perim=1.14
MMPA2 pndA A3 net59 VNB sky130_fd_pr__pfet_01v8_hvt m=4 w=1.0u l=0.15u mult=1 sa=0.265
+ sb=0.265 sd=0.28 area=0.063 perim=1.14
MMPB0 Y B1 pndA VNB sky130_fd_pr__pfet_01v8_hvt m=4 w=1.0u l=0.15u mult=1 sa=0.265
+ sb=0.265 sd=0.28 area=0.063 perim=1.14
MMPB1 Y B2 pndA VNB sky130_fd_pr__pfet_01v8_hvt m=4 w=1.0u l=0.15u mult=1 sa=0.265
+ sb=0.265 sd=0.28 area=0.063 perim=1.14
MMNA0 Y A1 sndA1 VNB sky130_fd_pr__nfet_01v8 m=4 w=0.65u l=0.15u mult=1 sa=0.265
+ sb=0.265 sd=0.28 area=0.063 perim=1.14
MMNA1 sndA1 A2 sndA2 VNB sky130_fd_pr__nfet_01v8 m=4 w=0.65u l=0.15u mult=1 sa=0.265
+ sb=0.265 sd=0.28 area=0.063 perim=1.14
MMNA2 sndA2 A3 VGND VNB sky130_fd_pr__nfet_01v8 m=4 w=0.65u l=0.15u mult=1 sa=0.265
+ sb=0.265 sd=0.28 area=0.063 perim=1.14
MMNB0 Y B1 sndB1 VNB sky130_fd_pr__nfet_01v8 m=4 w=0.65u l=0.15u mult=1 sa=0.265
+ sb=0.265 sd=0.28 area=0.063 perim=1.14
MMNB1 sndB1 B2 VGND VNB sky130_fd_pr__nfet_01v8 m=4 w=0.65u l=0.15u mult=1 sa=0.265
+ sb=0.265 sd=0.28 area=0.063 perim=1.14
.ENDS sky130_fd_sc_hd__a32oi_4
* Copyright 2020 The SkyWater PDK Authors
*
* Licensed under the Apache License, Version 2.0 (the "License");
* you may not use this file except in compliance with the License.
* You may obtain a copy of the License at
*
*     https:  www.apache.org licenses LICENSE-2.0
*
* Unless required by applicable law or agreed to in writing, software
* distributed under the License is distributed on an "AS IS" BASIS,
* WITHOUT WARRANTIES OR CONDITIONS OF ANY KIND, either express or implied.
* See the License for the specific language governing permissions and
* limitations under the License.
*
* SPDX-License-Identifier: Apache-2.0

.SUBCKT sky130_fd_sc_hd__a41o_1 A1 A2 A3 A4 B1 VGND VNB VNB net59 X
*.PININFO A1:I A2:I A3:I A4:I B1:I VGND:I VNB:I VNB:I net59:I X:O
MMPA0 pndA A1 net59 VNB sky130_fd_pr__pfet_01v8_hvt m=1 w=1.0u l=0.15u mult=1 sa=0.265
+ sb=0.265 sd=0.28 area=0.063 perim=1.14
MMPA1 pndA A2 net59 VNB sky130_fd_pr__pfet_01v8_hvt m=1 w=1.0u l=0.15u mult=1 sa=0.265
+ sb=0.265 sd=0.28 area=0.063 perim=1.14
MMPA2 pndA A3 net59 VNB sky130_fd_pr__pfet_01v8_hvt m=1 w=1.0u l=0.15u mult=1 sa=0.265
+ sb=0.265 sd=0.28 area=0.063 perim=1.14
MMPA3 pndA A4 net59 VNB sky130_fd_pr__pfet_01v8_hvt m=1 w=1.0u l=0.15u mult=1 sa=0.265
+ sb=0.265 sd=0.28 area=0.063 perim=1.14
MMPB0 y B1 pndA VNB sky130_fd_pr__pfet_01v8_hvt m=1 w=1.0u l=0.15u mult=1 sa=0.265
+ sb=0.265 sd=0.28 area=0.063 perim=1.14
MMIPX X y net59 VNB sky130_fd_pr__pfet_01v8_hvt m=1 w=1.0u l=0.15u mult=1 sa=0.265
+ sb=0.265 sd=0.28 area=0.063 perim=1.14
MMNA0 y A1 sndA1 VNB sky130_fd_pr__nfet_01v8 m=1 w=0.65u l=0.15u mult=1 sa=0.265
+ sb=0.265 sd=0.28 area=0.063 perim=1.14
MMNA1 sndA1 A2 sndA2 VNB sky130_fd_pr__nfet_01v8 m=1 w=0.65u l=0.15u mult=1 sa=0.265
+ sb=0.265 sd=0.28 area=0.063 perim=1.14
MMNA2 sndA2 A3 sndA3 VNB sky130_fd_pr__nfet_01v8 m=1 w=0.65u l=0.15u mult=1 sa=0.265
+ sb=0.265 sd=0.28 area=0.063 perim=1.14
MMNA3 sndA3 A4 VGND VNB sky130_fd_pr__nfet_01v8 m=1 w=0.65u l=0.15u mult=1 sa=0.265
+ sb=0.265 sd=0.28 area=0.063 perim=1.14
MMNB0 y B1 VGND VNB sky130_fd_pr__nfet_01v8 m=1 w=0.65u l=0.15u mult=1 sa=0.265
+ sb=0.265 sd=0.28 area=0.063 perim=1.14
MMINX X y VGND VNB sky130_fd_pr__nfet_01v8 m=1 w=0.65u l=0.15u mult=1 sa=0.265
+ sb=0.265 sd=0.28 area=0.063 perim=1.14
.ENDS sky130_fd_sc_hd__a41o_1
* Copyright 2020 The SkyWater PDK Authors
*
* Licensed under the Apache License, Version 2.0 (the "License");
* you may not use this file except in compliance with the License.
* You may obtain a copy of the License at
*
*     https:  www.apache.org licenses LICENSE-2.0
*
* Unless required by applicable law or agreed to in writing, software
* distributed under the License is distributed on an "AS IS" BASIS,
* WITHOUT WARRANTIES OR CONDITIONS OF ANY KIND, either express or implied.
* See the License for the specific language governing permissions and
* limitations under the License.
*
* SPDX-License-Identifier: Apache-2.0

.SUBCKT sky130_fd_sc_hd__a41o_2 A1 A2 A3 A4 B1 VGND VNB VNB net59 X
*.PININFO A1:I A2:I A3:I A4:I B1:I VGND:I VNB:I VNB:I net59:I X:O
MMPA0 pndA A1 net59 VNB sky130_fd_pr__pfet_01v8_hvt m=1 w=1.0u l=0.15u mult=1 sa=0.265
+ sb=0.265 sd=0.28 area=0.063 perim=1.14
MMPA1 pndA A2 net59 VNB sky130_fd_pr__pfet_01v8_hvt m=1 w=1.0u l=0.15u mult=1 sa=0.265
+ sb=0.265 sd=0.28 area=0.063 perim=1.14
MMPA2 pndA A3 net59 VNB sky130_fd_pr__pfet_01v8_hvt m=1 w=1.0u l=0.15u mult=1 sa=0.265
+ sb=0.265 sd=0.28 area=0.063 perim=1.14
MMPA3 pndA A4 net59 VNB sky130_fd_pr__pfet_01v8_hvt m=1 w=1.0u l=0.15u mult=1 sa=0.265
+ sb=0.265 sd=0.28 area=0.063 perim=1.14
MMPB0 y B1 pndA VNB sky130_fd_pr__pfet_01v8_hvt m=1 w=1.0u l=0.15u mult=1 sa=0.265
+ sb=0.265 sd=0.28 area=0.063 perim=1.14
MMIPX X y net59 VNB sky130_fd_pr__pfet_01v8_hvt m=2 w=1.0u l=0.15u mult=1 sa=0.265
+ sb=0.265 sd=0.28 area=0.063 perim=1.14
MMNA0 y A1 sndA1 VNB sky130_fd_pr__nfet_01v8 m=1 w=0.65u l=0.15u mult=1 sa=0.265
+ sb=0.265 sd=0.28 area=0.063 perim=1.14
MMNA1 sndA1 A2 sndA2 VNB sky130_fd_pr__nfet_01v8 m=1 w=0.65u l=0.15u mult=1 sa=0.265
+ sb=0.265 sd=0.28 area=0.063 perim=1.14
MMNA2 sndA2 A3 sndA3 VNB sky130_fd_pr__nfet_01v8 m=1 w=0.65u l=0.15u mult=1 sa=0.265
+ sb=0.265 sd=0.28 area=0.063 perim=1.14
MMNA3 sndA3 A4 VGND VNB sky130_fd_pr__nfet_01v8 m=1 w=0.65u l=0.15u mult=1 sa=0.265
+ sb=0.265 sd=0.28 area=0.063 perim=1.14
MMNB0 y B1 VGND VNB sky130_fd_pr__nfet_01v8 m=1 w=0.65u l=0.15u mult=1 sa=0.265
+ sb=0.265 sd=0.28 area=0.063 perim=1.14
MMINX X y VGND VNB sky130_fd_pr__nfet_01v8 m=2 w=0.65u l=0.15u mult=1 sa=0.265
+ sb=0.265 sd=0.28 area=0.063 perim=1.14
.ENDS sky130_fd_sc_hd__a41o_2
* Copyright 2020 The SkyWater PDK Authors
*
* Licensed under the Apache License, Version 2.0 (the "License");
* you may not use this file except in compliance with the License.
* You may obtain a copy of the License at
*
*     https:  www.apache.org licenses LICENSE-2.0
*
* Unless required by applicable law or agreed to in writing, software
* distributed under the License is distributed on an "AS IS" BASIS,
* WITHOUT WARRANTIES OR CONDITIONS OF ANY KIND, either express or implied.
* See the License for the specific language governing permissions and
* limitations under the License.
*
* SPDX-License-Identifier: Apache-2.0

.SUBCKT sky130_fd_sc_hd__a41o_4 A1 A2 A3 A4 B1 VGND VNB VNB net59 X
*.PININFO A1:I A2:I A3:I A4:I B1:I VGND:I VNB:I VNB:I net59:I X:O
MMPA0 pndA A1 net59 VNB sky130_fd_pr__pfet_01v8_hvt m=2 w=1.0u l=0.15u mult=1 sa=0.265
+ sb=0.265 sd=0.28 area=0.063 perim=1.14
MMPA1 pndA A2 net59 VNB sky130_fd_pr__pfet_01v8_hvt m=2 w=1.0u l=0.15u mult=1 sa=0.265
+ sb=0.265 sd=0.28 area=0.063 perim=1.14
MMPA2 pndA A3 net59 VNB sky130_fd_pr__pfet_01v8_hvt m=2 w=1.0u l=0.15u mult=1 sa=0.265
+ sb=0.265 sd=0.28 area=0.063 perim=1.14
MMPA3 pndA A4 net59 VNB sky130_fd_pr__pfet_01v8_hvt m=2 w=1.0u l=0.15u mult=1 sa=0.265
+ sb=0.265 sd=0.28 area=0.063 perim=1.14
MMPB0 y B1 pndA VNB sky130_fd_pr__pfet_01v8_hvt m=2 w=1.0u l=0.15u mult=1 sa=0.265
+ sb=0.265 sd=0.28 area=0.063 perim=1.14
MMIPX X y net59 VNB sky130_fd_pr__pfet_01v8_hvt m=4 w=1.0u l=0.15u mult=1 sa=0.265
+ sb=0.265 sd=0.28 area=0.063 perim=1.14
MMNA0 y A1 sndA1 VNB sky130_fd_pr__nfet_01v8 m=2 w=0.65u l=0.15u mult=1 sa=0.265
+ sb=0.265 sd=0.28 area=0.063 perim=1.14
MMNA1 sndA1 A2 sndA2 VNB sky130_fd_pr__nfet_01v8 m=2 w=0.65u l=0.15u mult=1 sa=0.265
+ sb=0.265 sd=0.28 area=0.063 perim=1.14
MMNA2 sndA2 A3 sndA3 VNB sky130_fd_pr__nfet_01v8 m=2 w=0.65u l=0.15u mult=1 sa=0.265
+ sb=0.265 sd=0.28 area=0.063 perim=1.14
MMNA3 sndA3 A4 VGND VNB sky130_fd_pr__nfet_01v8 m=2 w=0.65u l=0.15u mult=1 sa=0.265
+ sb=0.265 sd=0.28 area=0.063 perim=1.14
MMNB0 y B1 VGND VNB sky130_fd_pr__nfet_01v8 m=2 w=0.65u l=0.15u mult=1 sa=0.265
+ sb=0.265 sd=0.28 area=0.063 perim=1.14
MMINX X y VGND VNB sky130_fd_pr__nfet_01v8 m=4 w=0.65u l=0.15u mult=1 sa=0.265
+ sb=0.265 sd=0.28 area=0.063 perim=1.14
.ENDS sky130_fd_sc_hd__a41o_4
* Copyright 2020 The SkyWater PDK Authors
*
* Licensed under the Apache License, Version 2.0 (the "License");
* you may not use this file except in compliance with the License.
* You may obtain a copy of the License at
*
*     https:  www.apache.org licenses LICENSE-2.0
*
* Unless required by applicable law or agreed to in writing, software
* distributed under the License is distributed on an "AS IS" BASIS,
* WITHOUT WARRANTIES OR CONDITIONS OF ANY KIND, either express or implied.
* See the License for the specific language governing permissions and
* limitations under the License.
*
* SPDX-License-Identifier: Apache-2.0

.SUBCKT sky130_fd_sc_hd__a41oi_1 A1 A2 A3 A4 B1 VGND VNB VNB net59 Y
*.PININFO A1:I A2:I A3:I A4:I B1:I VGND:I VNB:I VNB:I net59:I Y:O
MMPA0 pndA A1 net59 VNB sky130_fd_pr__pfet_01v8_hvt m=1 w=1.0u l=0.15u mult=1 sa=0.265
+ sb=0.265 sd=0.28 area=0.063 perim=1.14
MMPA1 pndA A2 net59 VNB sky130_fd_pr__pfet_01v8_hvt m=1 w=1.0u l=0.15u mult=1 sa=0.265
+ sb=0.265 sd=0.28 area=0.063 perim=1.14
MMPA2 pndA A3 net59 VNB sky130_fd_pr__pfet_01v8_hvt m=1 w=1.0u l=0.15u mult=1 sa=0.265
+ sb=0.265 sd=0.28 area=0.063 perim=1.14
MMPA3 pndA A4 net59 VNB sky130_fd_pr__pfet_01v8_hvt m=1 w=1.0u l=0.15u mult=1 sa=0.265
+ sb=0.265 sd=0.28 area=0.063 perim=1.14
MMPB0 Y B1 pndA VNB sky130_fd_pr__pfet_01v8_hvt m=1 w=1.0u l=0.15u mult=1 sa=0.265
+ sb=0.265 sd=0.28 area=0.063 perim=1.14
MMNA0 Y A1 sndA1 VNB sky130_fd_pr__nfet_01v8 m=1 w=0.65u l=0.15u mult=1 sa=0.265
+ sb=0.265 sd=0.28 area=0.063 perim=1.14
MMNA1 sndA1 A2 sndA2 VNB sky130_fd_pr__nfet_01v8 m=1 w=0.65u l=0.15u mult=1 sa=0.265
+ sb=0.265 sd=0.28 area=0.063 perim=1.14
MMNA2 sndA2 A3 sndA3 VNB sky130_fd_pr__nfet_01v8 m=1 w=0.65u l=0.15u mult=1 sa=0.265
+ sb=0.265 sd=0.28 area=0.063 perim=1.14
MMNA3 sndA3 A4 VGND VNB sky130_fd_pr__nfet_01v8 m=1 w=0.65u l=0.15u mult=1 sa=0.265
+ sb=0.265 sd=0.28 area=0.063 perim=1.14
MMNB0 Y B1 VGND VNB sky130_fd_pr__nfet_01v8 m=1 w=0.65u l=0.15u mult=1 sa=0.265
+ sb=0.265 sd=0.28 area=0.063 perim=1.14
.ENDS sky130_fd_sc_hd__a41oi_1
* Copyright 2020 The SkyWater PDK Authors
*
* Licensed under the Apache License, Version 2.0 (the "License");
* you may not use this file except in compliance with the License.
* You may obtain a copy of the License at
*
*     https:  www.apache.org licenses LICENSE-2.0
*
* Unless required by applicable law or agreed to in writing, software
* distributed under the License is distributed on an "AS IS" BASIS,
* WITHOUT WARRANTIES OR CONDITIONS OF ANY KIND, either express or implied.
* See the License for the specific language governing permissions and
* limitations under the License.
*
* SPDX-License-Identifier: Apache-2.0

.SUBCKT sky130_fd_sc_hd__a41oi_2 A1 A2 A3 A4 B1 VGND VNB VNB net59 Y
*.PININFO A1:I A2:I A3:I A4:I B1:I VGND:I VNB:I VNB:I net59:I Y:O
MMPA0 pndA A1 net59 VNB sky130_fd_pr__pfet_01v8_hvt m=2 w=1.0u l=0.15u mult=1 sa=0.265
+ sb=0.265 sd=0.28 area=0.063 perim=1.14
MMPA1 pndA A2 net59 VNB sky130_fd_pr__pfet_01v8_hvt m=2 w=1.0u l=0.15u mult=1 sa=0.265
+ sb=0.265 sd=0.28 area=0.063 perim=1.14
MMPA2 pndA A3 net59 VNB sky130_fd_pr__pfet_01v8_hvt m=2 w=1.0u l=0.15u mult=1 sa=0.265
+ sb=0.265 sd=0.28 area=0.063 perim=1.14
MMPA3 pndA A4 net59 VNB sky130_fd_pr__pfet_01v8_hvt m=2 w=1.0u l=0.15u mult=1 sa=0.265
+ sb=0.265 sd=0.28 area=0.063 perim=1.14
MMPB0 Y B1 pndA VNB sky130_fd_pr__pfet_01v8_hvt m=2 w=1.0u l=0.15u mult=1 sa=0.265
+ sb=0.265 sd=0.28 area=0.063 perim=1.14
MMNA0 Y A1 sndA1 VNB sky130_fd_pr__nfet_01v8 m=2 w=0.65u l=0.15u mult=1 sa=0.265
+ sb=0.265 sd=0.28 area=0.063 perim=1.14
MMNA1 sndA1 A2 sndA2 VNB sky130_fd_pr__nfet_01v8 m=2 w=0.65u l=0.15u mult=1 sa=0.265
+ sb=0.265 sd=0.28 area=0.063 perim=1.14
MMNA2 sndA2 A3 sndA3 VNB sky130_fd_pr__nfet_01v8 m=2 w=0.65u l=0.15u mult=1 sa=0.265
+ sb=0.265 sd=0.28 area=0.063 perim=1.14
MMNA3 sndA3 A4 VGND VNB sky130_fd_pr__nfet_01v8 m=2 w=0.65u l=0.15u mult=1 sa=0.265
+ sb=0.265 sd=0.28 area=0.063 perim=1.14
MMNB0 Y B1 VGND VNB sky130_fd_pr__nfet_01v8 m=2 w=0.65u l=0.15u mult=1 sa=0.265
+ sb=0.265 sd=0.28 area=0.063 perim=1.14
.ENDS sky130_fd_sc_hd__a41oi_2
* Copyright 2020 The SkyWater PDK Authors
*
* Licensed under the Apache License, Version 2.0 (the "License");
* you may not use this file except in compliance with the License.
* You may obtain a copy of the License at
*
*     https:  www.apache.org licenses LICENSE-2.0
*
* Unless required by applicable law or agreed to in writing, software
* distributed under the License is distributed on an "AS IS" BASIS,
* WITHOUT WARRANTIES OR CONDITIONS OF ANY KIND, either express or implied.
* See the License for the specific language governing permissions and
* limitations under the License.
*
* SPDX-License-Identifier: Apache-2.0

.SUBCKT sky130_fd_sc_hd__a41oi_4 A1 A2 A3 A4 B1 VGND VNB VNB net59 Y
*.PININFO A1:I A2:I A3:I A4:I B1:I VGND:I VNB:I VNB:I net59:I Y:O
MMPA0 pndA A1 net59 VNB sky130_fd_pr__pfet_01v8_hvt m=4 w=1.0u l=0.15u mult=1 sa=0.265
+ sb=0.265 sd=0.28 area=0.063 perim=1.14
MMPA1 pndA A2 net59 VNB sky130_fd_pr__pfet_01v8_hvt m=4 w=1.0u l=0.15u mult=1 sa=0.265
+ sb=0.265 sd=0.28 area=0.063 perim=1.14
MMPA2 pndA A3 net59 VNB sky130_fd_pr__pfet_01v8_hvt m=4 w=1.0u l=0.15u mult=1 sa=0.265
+ sb=0.265 sd=0.28 area=0.063 perim=1.14
MMPA3 pndA A4 net59 VNB sky130_fd_pr__pfet_01v8_hvt m=4 w=1.0u l=0.15u mult=1 sa=0.265
+ sb=0.265 sd=0.28 area=0.063 perim=1.14
MMPB0 Y B1 pndA VNB sky130_fd_pr__pfet_01v8_hvt m=4 w=1.0u l=0.15u mult=1 sa=0.265
+ sb=0.265 sd=0.28 area=0.063 perim=1.14
MMNA0 Y A1 sndA1 VNB sky130_fd_pr__nfet_01v8 m=4 w=0.65u l=0.15u mult=1 sa=0.265
+ sb=0.265 sd=0.28 area=0.063 perim=1.14
MMNA1 sndA1 A2 sndA2 VNB sky130_fd_pr__nfet_01v8 m=4 w=0.65u l=0.15u mult=1 sa=0.265
+ sb=0.265 sd=0.28 area=0.063 perim=1.14
MMNA2 sndA2 A3 sndA3 VNB sky130_fd_pr__nfet_01v8 m=4 w=0.65u l=0.15u mult=1 sa=0.265
+ sb=0.265 sd=0.28 area=0.063 perim=1.14
MMNA3 sndA3 A4 VGND VNB sky130_fd_pr__nfet_01v8 m=4 w=0.65u l=0.15u mult=1 sa=0.265
+ sb=0.265 sd=0.28 area=0.063 perim=1.14
MMNB0 Y B1 VGND VNB sky130_fd_pr__nfet_01v8 m=4 w=0.65u l=0.15u mult=1 sa=0.265
+ sb=0.265 sd=0.28 area=0.063 perim=1.14
.ENDS sky130_fd_sc_hd__a41oi_4
* Copyright 2020 The SkyWater PDK Authors
*
* Licensed under the Apache License, Version 2.0 (the "License");
* you may not use this file except in compliance with the License.
* You may obtain a copy of the License at
*
*     https:  www.apache.org licenses LICENSE-2.0
*
* Unless required by applicable law or agreed to in writing, software
* distributed under the License is distributed on an "AS IS" BASIS,
* WITHOUT WARRANTIES OR CONDITIONS OF ANY KIND, either express or implied.
* See the License for the specific language governing permissions and
* limitations under the License.
*
* SPDX-License-Identifier: Apache-2.0

.SUBCKT sky130_fd_sc_hd__and2_0 A B VGND VNB VNB net59 X
*.PININFO A:I B:I VGND:I VNB:I VNB:I net59:I X:O
MMP0 y A net59 VNB sky130_fd_pr__pfet_01v8_hvt m=1 w=0.42u l=0.15u mult=1 sa=0.265
+ sb=0.265 sd=0.28 area=0.063 perim=1.14
MMP1 y B net59 VNB sky130_fd_pr__pfet_01v8_hvt m=1 w=0.42u l=0.15u mult=1 sa=0.265
+ sb=0.265 sd=0.28 area=0.063 perim=1.14
MMIP0 X y net59 VNB sky130_fd_pr__pfet_01v8_hvt m=1 w=0.64u l=0.15u mult=1 sa=0.265
+ sb=0.265 sd=0.28 area=0.063 perim=1.14
MMN0 y A sndA VNB sky130_fd_pr__nfet_01v8 m=1 w=0.42u l=0.15u mult=1 sa=0.265 sb=0.265
+ sd=0.28 area=0.063 perim=1.14
MMN1 sndA B VGND VNB sky130_fd_pr__nfet_01v8 m=1 w=0.42u l=0.15u mult=1 sa=0.265
+ sb=0.265 sd=0.28 area=0.063 perim=1.14
MMIN0 X y VGND VNB sky130_fd_pr__nfet_01v8 m=1 w=0.42u l=0.15u mult=1 sa=0.265
+ sb=0.265 sd=0.28 area=0.063 perim=1.14
.ENDS sky130_fd_sc_hd__and2_0
* Copyright 2020 The SkyWater PDK Authors
*
* Licensed under the Apache License, Version 2.0 (the "License");
* you may not use this file except in compliance with the License.
* You may obtain a copy of the License at
*
*     https:  www.apache.org licenses LICENSE-2.0
*
* Unless required by applicable law or agreed to in writing, software
* distributed under the License is distributed on an "AS IS" BASIS,
* WITHOUT WARRANTIES OR CONDITIONS OF ANY KIND, either express or implied.
* See the License for the specific language governing permissions and
* limitations under the License.
*
* SPDX-License-Identifier: Apache-2.0

.SUBCKT sky130_fd_sc_hd__and2_1 A B VGND VNB VNB net59 X
*.PININFO A:I B:I VGND:I VNB:I VNB:I net59:I X:O
MMP0 y A net59 VNB sky130_fd_pr__pfet_01v8_hvt m=1 w=0.42u l=0.15u mult=1 sa=0.265
+ sb=0.265 sd=0.28 area=0.063 perim=1.14
MMP1 y B net59 VNB sky130_fd_pr__pfet_01v8_hvt m=1 w=0.42u l=0.15u mult=1 sa=0.265
+ sb=0.265 sd=0.28 area=0.063 perim=1.14
MMIP0 X y net59 VNB sky130_fd_pr__pfet_01v8_hvt m=1 w=1.0u l=0.15u mult=1 sa=0.265
+ sb=0.265 sd=0.28 area=0.063 perim=1.14
MMN0 y A sndA VNB sky130_fd_pr__nfet_01v8 m=1 w=0.42u l=0.15u mult=1 sa=0.265 sb=0.265
+ sd=0.28 area=0.063 perim=1.14
MMN1 sndA B VGND VNB sky130_fd_pr__nfet_01v8 m=1 w=0.42u l=0.15u mult=1 sa=0.265
+ sb=0.265 sd=0.28 area=0.063 perim=1.14
MMIN0 X y VGND VNB sky130_fd_pr__nfet_01v8 m=1 w=0.65u l=0.15u mult=1 sa=0.265
+ sb=0.265 sd=0.28 area=0.063 perim=1.14
.ENDS sky130_fd_sc_hd__and2_1
* Copyright 2020 The SkyWater PDK Authors
*
* Licensed under the Apache License, Version 2.0 (the "License");
* you may not use this file except in compliance with the License.
* You may obtain a copy of the License at
*
*     https:  www.apache.org licenses LICENSE-2.0
*
* Unless required by applicable law or agreed to in writing, software
* distributed under the License is distributed on an "AS IS" BASIS,
* WITHOUT WARRANTIES OR CONDITIONS OF ANY KIND, either express or implied.
* See the License for the specific language governing permissions and
* limitations under the License.
*
* SPDX-License-Identifier: Apache-2.0

.SUBCKT sky130_fd_sc_hd__and2_2 A B VGND VNB VNB net59 X
*.PININFO A:I B:I VGND:I VNB:I VNB:I net59:I X:O
MMP0 y A net59 VNB sky130_fd_pr__pfet_01v8_hvt m=1 w=0.42u l=0.15u mult=1 sa=0.265
+ sb=0.265 sd=0.28 area=0.063 perim=1.14
MMP1 y B net59 VNB sky130_fd_pr__pfet_01v8_hvt m=1 w=0.42u l=0.15u mult=1 sa=0.265
+ sb=0.265 sd=0.28 area=0.063 perim=1.14
MMIP0 X y net59 VNB sky130_fd_pr__pfet_01v8_hvt m=2 w=1.0u l=0.15u mult=1 sa=0.265
+ sb=0.265 sd=0.28 area=0.063 perim=1.14
MMN0 y A sndA VNB sky130_fd_pr__nfet_01v8 m=1 w=0.42u l=0.15u mult=1 sa=0.265 sb=0.265
+ sd=0.28 area=0.063 perim=1.14
MMN1 sndA B VGND VNB sky130_fd_pr__nfet_01v8 m=1 w=0.42u l=0.15u mult=1 sa=0.265
+ sb=0.265 sd=0.28 area=0.063 perim=1.14
MMIN0 X y VGND VNB sky130_fd_pr__nfet_01v8 m=2 w=0.65u l=0.15u mult=1 sa=0.265
+ sb=0.265 sd=0.28 area=0.063 perim=1.14
.ENDS sky130_fd_sc_hd__and2_2
* Copyright 2020 The SkyWater PDK Authors
*
* Licensed under the Apache License, Version 2.0 (the "License");
* you may not use this file except in compliance with the License.
* You may obtain a copy of the License at
*
*     https:  www.apache.org licenses LICENSE-2.0
*
* Unless required by applicable law or agreed to in writing, software
* distributed under the License is distributed on an "AS IS" BASIS,
* WITHOUT WARRANTIES OR CONDITIONS OF ANY KIND, either express or implied.
* See the License for the specific language governing permissions and
* limitations under the License.
*
* SPDX-License-Identifier: Apache-2.0

.SUBCKT sky130_fd_sc_hd__and2_4 A B VGND VNB VNB net59 X
*.PININFO A:I B:I VGND:I VNB:I VNB:I net59:I X:O
MMP0 y A net59 VNB sky130_fd_pr__pfet_01v8_hvt m=1 w=1.0u l=0.15u mult=1 sa=0.265
+ sb=0.265 sd=0.28 area=0.063 perim=1.14
MMP1 y B net59 VNB sky130_fd_pr__pfet_01v8_hvt m=1 w=1.0u l=0.15u mult=1 sa=0.265
+ sb=0.265 sd=0.28 area=0.063 perim=1.14
MMIP0 X y net59 VNB sky130_fd_pr__pfet_01v8_hvt m=4 w=1.0u l=0.15u mult=1 sa=0.265
+ sb=0.265 sd=0.28 area=0.063 perim=1.14
MMN0 y A sndA VNB sky130_fd_pr__nfet_01v8 m=1 w=0.65u l=0.15u mult=1 sa=0.265 sb=0.265
+ sd=0.28 area=0.063 perim=1.14
MMN1 sndA B VGND VNB sky130_fd_pr__nfet_01v8 m=1 w=0.65u l=0.15u mult=1 sa=0.265
+ sb=0.265 sd=0.28 area=0.063 perim=1.14
MMIN0 X y VGND VNB sky130_fd_pr__nfet_01v8 m=4 w=0.65u l=0.15u mult=1 sa=0.265
+ sb=0.265 sd=0.28 area=0.063 perim=1.14
.ENDS sky130_fd_sc_hd__and2_4
* Copyright 2020 The SkyWater PDK Authors
*
* Licensed under the Apache License, Version 2.0 (the "License");
* you may not use this file except in compliance with the License.
* You may obtain a copy of the License at
*
*     https:  www.apache.org licenses LICENSE-2.0
*
* Unless required by applicable law or agreed to in writing, software
* distributed under the License is distributed on an "AS IS" BASIS,
* WITHOUT WARRANTIES OR CONDITIONS OF ANY KIND, either express or implied.
* See the License for the specific language governing permissions and
* limitations under the License.
*
* SPDX-License-Identifier: Apache-2.0

.SUBCKT sky130_fd_sc_hd__and2b_1 A_N B VGND VNB VNB net59 X
*.PININFO A_N:I B:I VGND:I VNB:I VNB:I net59:I X:O
MMP0 y A net59 VNB sky130_fd_pr__pfet_01v8_hvt m=1 w=0.42u l=0.15u mult=1 sa=0.265
+ sb=0.265 sd=0.28 area=0.063 perim=1.14
MMP1 y B net59 VNB sky130_fd_pr__pfet_01v8_hvt m=1 w=0.42u l=0.15u mult=1 sa=0.265
+ sb=0.265 sd=0.28 area=0.063 perim=1.14
MMIP0 A A_N net59 VNB sky130_fd_pr__pfet_01v8_hvt m=1 w=0.42u l=0.15u mult=1 sa=0.265
+ sb=0.265 sd=0.28 area=0.063 perim=1.14
MMIP1 X y net59 VNB sky130_fd_pr__pfet_01v8_hvt m=1 w=1.0u l=0.15u mult=1 sa=0.265
+ sb=0.265 sd=0.28 area=0.063 perim=1.14
MMN0 y A sndA VNB sky130_fd_pr__nfet_01v8 m=1 w=0.42u l=0.15u mult=1 sa=0.265 sb=0.265
+ sd=0.28 area=0.063 perim=1.14
MMN1 sndA B VGND VNB sky130_fd_pr__nfet_01v8 m=1 w=0.42u l=0.15u mult=1 sa=0.265
+ sb=0.265 sd=0.28 area=0.063 perim=1.14
MMIN0 A A_N VGND VNB sky130_fd_pr__nfet_01v8 m=1 w=0.42u l=0.15u mult=1 sa=0.265
+ sb=0.265 sd=0.28 area=0.063 perim=1.14
MMIN1 X y VGND VNB sky130_fd_pr__nfet_01v8 m=1 w=0.65u l=0.15u mult=1 sa=0.265
+ sb=0.265 sd=0.28 area=0.063 perim=1.14
.ENDS sky130_fd_sc_hd__and2b_1
* Copyright 2020 The SkyWater PDK Authors
*
* Licensed under the Apache License, Version 2.0 (the "License");
* you may not use this file except in compliance with the License.
* You may obtain a copy of the License at
*
*     https:  www.apache.org licenses LICENSE-2.0
*
* Unless required by applicable law or agreed to in writing, software
* distributed under the License is distributed on an "AS IS" BASIS,
* WITHOUT WARRANTIES OR CONDITIONS OF ANY KIND, either express or implied.
* See the License for the specific language governing permissions and
* limitations under the License.
*
* SPDX-License-Identifier: Apache-2.0

.SUBCKT sky130_fd_sc_hd__and2b_2 A_N B VGND VNB VNB net59 X
*.PININFO A_N:I B:I VGND:I VNB:I VNB:I net59:I X:O
MMP0 y A net59 VNB sky130_fd_pr__pfet_01v8_hvt m=1 w=0.42u l=0.15u mult=1 sa=0.265
+ sb=0.265 sd=0.28 area=0.063 perim=1.14
MMP1 y B net59 VNB sky130_fd_pr__pfet_01v8_hvt m=1 w=0.42u l=0.15u mult=1 sa=0.265
+ sb=0.265 sd=0.28 area=0.063 perim=1.14
MMIP0 A A_N net59 VNB sky130_fd_pr__pfet_01v8_hvt m=1 w=0.42u l=0.15u mult=1 sa=0.265
+ sb=0.265 sd=0.28 area=0.063 perim=1.14
MMIP1 X y net59 VNB sky130_fd_pr__pfet_01v8_hvt m=2 w=1.0u l=0.15u mult=1 sa=0.265
+ sb=0.265 sd=0.28 area=0.063 perim=1.14
MMN0 y A sndA VNB sky130_fd_pr__nfet_01v8 m=1 w=0.42u l=0.15u mult=1 sa=0.265 sb=0.265
+ sd=0.28 area=0.063 perim=1.14
MMN1 sndA B VGND VNB sky130_fd_pr__nfet_01v8 m=1 w=0.42u l=0.15u mult=1 sa=0.265
+ sb=0.265 sd=0.28 area=0.063 perim=1.14
MMIN0 A A_N VGND VNB sky130_fd_pr__nfet_01v8 m=1 w=0.42u l=0.15u mult=1 sa=0.265
+ sb=0.265 sd=0.28 area=0.063 perim=1.14
MMIN1 X y VGND VNB sky130_fd_pr__nfet_01v8 m=2 w=0.65u l=0.15u mult=1 sa=0.265
+ sb=0.265 sd=0.28 area=0.063 perim=1.14
.ENDS sky130_fd_sc_hd__and2b_2
* Copyright 2020 The SkyWater PDK Authors
*
* Licensed under the Apache License, Version 2.0 (the "License");
* you may not use this file except in compliance with the License.
* You may obtain a copy of the License at
*
*     https:  www.apache.org licenses LICENSE-2.0
*
* Unless required by applicable law or agreed to in writing, software
* distributed under the License is distributed on an "AS IS" BASIS,
* WITHOUT WARRANTIES OR CONDITIONS OF ANY KIND, either express or implied.
* See the License for the specific language governing permissions and
* limitations under the License.
*
* SPDX-License-Identifier: Apache-2.0

.SUBCKT sky130_fd_sc_hd__and2b_4 A_N B VGND VNB VNB net59 X
*.PININFO A_N:I B:I VGND:I VNB:I VNB:I net59:I X:O
MMP0 y A net59 VNB sky130_fd_pr__pfet_01v8_hvt m=1 w=1.0u l=0.15u mult=1 sa=0.265
+ sb=0.265 sd=0.28 area=0.063 perim=1.14
MMP1 y B net59 VNB sky130_fd_pr__pfet_01v8_hvt m=1 w=1.0u l=0.15u mult=1 sa=0.265
+ sb=0.265 sd=0.28 area=0.063 perim=1.14
MMIP0 A A_N net59 VNB sky130_fd_pr__pfet_01v8_hvt m=1 w=0.42u l=0.15u mult=1 sa=0.265
+ sb=0.265 sd=0.28 area=0.063 perim=1.14
MMIP1 X y net59 VNB sky130_fd_pr__pfet_01v8_hvt m=4 w=1.0u l=0.15u mult=1 sa=0.265
+ sb=0.265 sd=0.28 area=0.063 perim=1.14
MMN0 y A sndA VNB sky130_fd_pr__nfet_01v8 m=1 w=0.65u l=0.15u mult=1 sa=0.265 sb=0.265
+ sd=0.28 area=0.063 perim=1.14
MMN1 sndA B VGND VNB sky130_fd_pr__nfet_01v8 m=1 w=0.65u l=0.15u mult=1 sa=0.265
+ sb=0.265 sd=0.28 area=0.063 perim=1.14
MMIN0 A A_N VGND VNB sky130_fd_pr__nfet_01v8 m=1 w=0.42u l=0.15u mult=1 sa=0.265
+ sb=0.265 sd=0.28 area=0.063 perim=1.14
MMIN1 X y VGND VNB sky130_fd_pr__nfet_01v8 m=4 w=0.65u l=0.15u mult=1 sa=0.265
+ sb=0.265 sd=0.28 area=0.063 perim=1.14
.ENDS sky130_fd_sc_hd__and2b_4
* Copyright 2020 The SkyWater PDK Authors
*
* Licensed under the Apache License, Version 2.0 (the "License");
* you may not use this file except in compliance with the License.
* You may obtain a copy of the License at
*
*     https:  www.apache.org licenses LICENSE-2.0
*
* Unless required by applicable law or agreed to in writing, software
* distributed under the License is distributed on an "AS IS" BASIS,
* WITHOUT WARRANTIES OR CONDITIONS OF ANY KIND, either express or implied.
* See the License for the specific language governing permissions and
* limitations under the License.
*
* SPDX-License-Identifier: Apache-2.0

.SUBCKT sky130_fd_sc_hd__and3_1 A B C VGND VNB VNB net59 X
*.PININFO A:I B:I C:I VGND:I VNB:I VNB:I net59:I X:O
MMP0 y A net59 VNB sky130_fd_pr__pfet_01v8_hvt m=1 w=0.42u l=0.15u mult=1 sa=0.265
+ sb=0.265 sd=0.28 area=0.063 perim=1.14
MMP1 y B net59 VNB sky130_fd_pr__pfet_01v8_hvt m=1 w=0.42u l=0.15u mult=1 sa=0.265
+ sb=0.265 sd=0.28 area=0.063 perim=1.14
MMP2 y C net59 VNB sky130_fd_pr__pfet_01v8_hvt m=1 w=0.42u l=0.15u mult=1 sa=0.265
+ sb=0.265 sd=0.28 area=0.063 perim=1.14
MMIP0 X y net59 VNB sky130_fd_pr__pfet_01v8_hvt m=1 w=1.0u l=0.15u mult=1 sa=0.265
+ sb=0.265 sd=0.28 area=0.063 perim=1.14
MMN0 y A sndA VNB sky130_fd_pr__nfet_01v8 m=1 w=0.42u l=0.15u mult=1 sa=0.265 sb=0.265
+ sd=0.28 area=0.063 perim=1.14
MMN1 sndA B sndB VNB sky130_fd_pr__nfet_01v8 m=1 w=0.42u l=0.15u mult=1 sa=0.265
+ sb=0.265 sd=0.28 area=0.063 perim=1.14
MMN2 sndB C VGND VNB sky130_fd_pr__nfet_01v8 m=1 w=0.42u l=0.15u mult=1 sa=0.265
+ sb=0.265 sd=0.28 area=0.063 perim=1.14
MMIN0 X y VGND VNB sky130_fd_pr__nfet_01v8 m=1 w=0.65u l=0.15u mult=1 sa=0.265
+ sb=0.265 sd=0.28 area=0.063 perim=1.14
.ENDS sky130_fd_sc_hd__and3_1
* Copyright 2020 The SkyWater PDK Authors
*
* Licensed under the Apache License, Version 2.0 (the "License");
* you may not use this file except in compliance with the License.
* You may obtain a copy of the License at
*
*     https:  www.apache.org licenses LICENSE-2.0
*
* Unless required by applicable law or agreed to in writing, software
* distributed under the License is distributed on an "AS IS" BASIS,
* WITHOUT WARRANTIES OR CONDITIONS OF ANY KIND, either express or implied.
* See the License for the specific language governing permissions and
* limitations under the License.
*
* SPDX-License-Identifier: Apache-2.0

.SUBCKT sky130_fd_sc_hd__and3_2 A B C VGND VNB VNB net59 X
*.PININFO A:I B:I C:I VGND:I VNB:I VNB:I net59:I X:O
MMP0 y A net59 VNB sky130_fd_pr__pfet_01v8_hvt m=1 w=0.42u l=0.15u mult=1 sa=0.265
+ sb=0.265 sd=0.28 area=0.063 perim=1.14
MMP1 y B net59 VNB sky130_fd_pr__pfet_01v8_hvt m=1 w=0.42u l=0.15u mult=1 sa=0.265
+ sb=0.265 sd=0.28 area=0.063 perim=1.14
MMP2 y C net59 VNB sky130_fd_pr__pfet_01v8_hvt m=1 w=0.42u l=0.15u mult=1 sa=0.265
+ sb=0.265 sd=0.28 area=0.063 perim=1.14
MMIP0 X y net59 VNB sky130_fd_pr__pfet_01v8_hvt m=2 w=1.0u l=0.15u mult=1 sa=0.265
+ sb=0.265 sd=0.28 area=0.063 perim=1.14
MMN0 y A sndA VNB sky130_fd_pr__nfet_01v8 m=1 w=0.42u l=0.15u mult=1 sa=0.265 sb=0.265
+ sd=0.28 area=0.063 perim=1.14
MMN1 sndA B sndB VNB sky130_fd_pr__nfet_01v8 m=1 w=0.42u l=0.15u mult=1 sa=0.265
+ sb=0.265 sd=0.28 area=0.063 perim=1.14
MMN2 sndB C VGND VNB sky130_fd_pr__nfet_01v8 m=1 w=0.42u l=0.15u mult=1 sa=0.265
+ sb=0.265 sd=0.28 area=0.063 perim=1.14
MMIN0 X y VGND VNB sky130_fd_pr__nfet_01v8 m=2 w=0.65u l=0.15u mult=1 sa=0.265
+ sb=0.265 sd=0.28 area=0.063 perim=1.14
.ENDS sky130_fd_sc_hd__and3_2
* Copyright 2020 The SkyWater PDK Authors
*
* Licensed under the Apache License, Version 2.0 (the "License");
* you may not use this file except in compliance with the License.
* You may obtain a copy of the License at
*
*     https:  www.apache.org licenses LICENSE-2.0
*
* Unless required by applicable law or agreed to in writing, software
* distributed under the License is distributed on an "AS IS" BASIS,
* WITHOUT WARRANTIES OR CONDITIONS OF ANY KIND, either express or implied.
* See the License for the specific language governing permissions and
* limitations under the License.
*
* SPDX-License-Identifier: Apache-2.0

.SUBCKT sky130_fd_sc_hd__and3_4 A B C VGND VNB VNB net59 X
*.PININFO A:I B:I C:I VGND:I VNB:I VNB:I net59:I X:O
MMP0 y A net59 VNB sky130_fd_pr__pfet_01v8_hvt m=1 w=1.0u l=0.15u mult=1 sa=0.265
+ sb=0.265 sd=0.28 area=0.063 perim=1.14
MMP1 y B net59 VNB sky130_fd_pr__pfet_01v8_hvt m=1 w=1.0u l=0.15u mult=1 sa=0.265
+ sb=0.265 sd=0.28 area=0.063 perim=1.14
MMP2 y C net59 VNB sky130_fd_pr__pfet_01v8_hvt m=1 w=1.0u l=0.15u mult=1 sa=0.265
+ sb=0.265 sd=0.28 area=0.063 perim=1.14
MMIP0 X y net59 VNB sky130_fd_pr__pfet_01v8_hvt m=4 w=1.0u l=0.15u mult=1 sa=0.265
+ sb=0.265 sd=0.28 area=0.063 perim=1.14
MMN0 y A sndA VNB sky130_fd_pr__nfet_01v8 m=1 w=0.65u l=0.15u mult=1 sa=0.265 sb=0.265
+ sd=0.28 area=0.063 perim=1.14
MMN1 sndA B sndB VNB sky130_fd_pr__nfet_01v8 m=1 w=0.65u l=0.15u mult=1 sa=0.265
+ sb=0.265 sd=0.28 area=0.063 perim=1.14
MMN2 sndB C VGND VNB sky130_fd_pr__nfet_01v8 m=1 w=0.65u l=0.15u mult=1 sa=0.265
+ sb=0.265 sd=0.28 area=0.063 perim=1.14
MMIN0 X y VGND VNB sky130_fd_pr__nfet_01v8 m=4 w=0.65u l=0.15u mult=1 sa=0.265
+ sb=0.265 sd=0.28 area=0.063 perim=1.14
.ENDS sky130_fd_sc_hd__and3_4
* Copyright 2020 The SkyWater PDK Authors
*
* Licensed under the Apache License, Version 2.0 (the "License");
* you may not use this file except in compliance with the License.
* You may obtain a copy of the License at
*
*     https:  www.apache.org licenses LICENSE-2.0
*
* Unless required by applicable law or agreed to in writing, software
* distributed under the License is distributed on an "AS IS" BASIS,
* WITHOUT WARRANTIES OR CONDITIONS OF ANY KIND, either express or implied.
* See the License for the specific language governing permissions and
* limitations under the License.
*
* SPDX-License-Identifier: Apache-2.0

.SUBCKT sky130_fd_sc_hd__and3b_1 A_N B C VGND VNB VNB net59 X
*.PININFO A_N:I B:I C:I VGND:I VNB:I VNB:I net59:I X:O
MMP0 y A net59 VNB sky130_fd_pr__pfet_01v8_hvt m=1 w=0.42u l=0.15u mult=1 sa=0.265
+ sb=0.265 sd=0.28 area=0.063 perim=1.14
MMP1 y B net59 VNB sky130_fd_pr__pfet_01v8_hvt m=1 w=0.42u l=0.15u mult=1 sa=0.265
+ sb=0.265 sd=0.28 area=0.063 perim=1.14
MMP2 y C net59 VNB sky130_fd_pr__pfet_01v8_hvt m=1 w=0.42u l=0.15u mult=1 sa=0.265
+ sb=0.265 sd=0.28 area=0.063 perim=1.14
MMIP0 A A_N net59 VNB sky130_fd_pr__pfet_01v8_hvt m=1 w=0.42u l=0.15u mult=1 sa=0.265
+ sb=0.265 sd=0.28 area=0.063 perim=1.14
MMIP1 X y net59 VNB sky130_fd_pr__pfet_01v8_hvt m=1 w=1.0u l=0.15u mult=1 sa=0.265
+ sb=0.265 sd=0.28 area=0.063 perim=1.14
MMN0 y A sndA VNB sky130_fd_pr__nfet_01v8 m=1 w=0.42u l=0.15u mult=1 sa=0.265 sb=0.265
+ sd=0.28 area=0.063 perim=1.14
MMN1 sndA B sndB VNB sky130_fd_pr__nfet_01v8 m=1 w=0.42u l=0.15u mult=1 sa=0.265
+ sb=0.265 sd=0.28 area=0.063 perim=1.14
MMN2 sndB C VGND VNB sky130_fd_pr__nfet_01v8 m=1 w=0.42u l=0.15u mult=1 sa=0.265
+ sb=0.265 sd=0.28 area=0.063 perim=1.14
MMIN0 A A_N VGND VNB sky130_fd_pr__nfet_01v8 m=1 w=0.42u l=0.15u mult=1 sa=0.265
+ sb=0.265 sd=0.28 area=0.063 perim=1.14
MMIN1 X y VGND VNB sky130_fd_pr__nfet_01v8 m=1 w=0.65u l=0.15u mult=1 sa=0.265
+ sb=0.265 sd=0.28 area=0.063 perim=1.14
.ENDS sky130_fd_sc_hd__and3b_1
* Copyright 2020 The SkyWater PDK Authors
*
* Licensed under the Apache License, Version 2.0 (the "License");
* you may not use this file except in compliance with the License.
* You may obtain a copy of the License at
*
*     https:  www.apache.org licenses LICENSE-2.0
*
* Unless required by applicable law or agreed to in writing, software
* distributed under the License is distributed on an "AS IS" BASIS,
* WITHOUT WARRANTIES OR CONDITIONS OF ANY KIND, either express or implied.
* See the License for the specific language governing permissions and
* limitations under the License.
*
* SPDX-License-Identifier: Apache-2.0

.SUBCKT sky130_fd_sc_hd__and3b_2 A_N B C VGND VNB VNB net59 X
*.PININFO A_N:I B:I C:I VGND:I VNB:I VNB:I net59:I X:O
MMP0 y A net59 VNB sky130_fd_pr__pfet_01v8_hvt m=1 w=0.42u l=0.15u mult=1 sa=0.265
+ sb=0.265 sd=0.28 area=0.063 perim=1.14
MMP1 y B net59 VNB sky130_fd_pr__pfet_01v8_hvt m=1 w=0.42u l=0.15u mult=1 sa=0.265
+ sb=0.265 sd=0.28 area=0.063 perim=1.14
MMP2 y C net59 VNB sky130_fd_pr__pfet_01v8_hvt m=1 w=0.42u l=0.15u mult=1 sa=0.265
+ sb=0.265 sd=0.28 area=0.063 perim=1.14
MMIP0 A A_N net59 VNB sky130_fd_pr__pfet_01v8_hvt m=1 w=0.42u l=0.15u mult=1 sa=0.265
+ sb=0.265 sd=0.28 area=0.063 perim=1.14
MMIP1 X y net59 VNB sky130_fd_pr__pfet_01v8_hvt m=2 w=1.0u l=0.15u mult=1 sa=0.265
+ sb=0.265 sd=0.28 area=0.063 perim=1.14
MMN0 y A sndA VNB sky130_fd_pr__nfet_01v8 m=1 w=0.42u l=0.15u mult=1 sa=0.265 sb=0.265
+ sd=0.28 area=0.063 perim=1.14
MMN1 sndA B sndB VNB sky130_fd_pr__nfet_01v8 m=1 w=0.42u l=0.15u mult=1 sa=0.265
+ sb=0.265 sd=0.28 area=0.063 perim=1.14
MMN2 sndB C VGND VNB sky130_fd_pr__nfet_01v8 m=1 w=0.42u l=0.15u mult=1 sa=0.265
+ sb=0.265 sd=0.28 area=0.063 perim=1.14
MMIN0 A A_N VGND VNB sky130_fd_pr__nfet_01v8 m=1 w=0.42u l=0.15u mult=1 sa=0.265
+ sb=0.265 sd=0.28 area=0.063 perim=1.14
MMIN1 X y VGND VNB sky130_fd_pr__nfet_01v8 m=2 w=0.65u l=0.15u mult=1 sa=0.265
+ sb=0.265 sd=0.28 area=0.063 perim=1.14
.ENDS sky130_fd_sc_hd__and3b_2
* Copyright 2020 The SkyWater PDK Authors
*
* Licensed under the Apache License, Version 2.0 (the "License");
* you may not use this file except in compliance with the License.
* You may obtain a copy of the License at
*
*     https:  www.apache.org licenses LICENSE-2.0
*
* Unless required by applicable law or agreed to in writing, software
* distributed under the License is distributed on an "AS IS" BASIS,
* WITHOUT WARRANTIES OR CONDITIONS OF ANY KIND, either express or implied.
* See the License for the specific language governing permissions and
* limitations under the License.
*
* SPDX-License-Identifier: Apache-2.0

.SUBCKT sky130_fd_sc_hd__and3b_4 A_N B C VGND VNB VNB net59 X
*.PININFO A_N:I B:I C:I VGND:I VNB:I VNB:I net59:I X:O
MMP0 y A net59 VNB sky130_fd_pr__pfet_01v8_hvt m=1 w=1.0u l=0.15u mult=1 sa=0.265
+ sb=0.265 sd=0.28 area=0.063 perim=1.14
MMP1 y B net59 VNB sky130_fd_pr__pfet_01v8_hvt m=1 w=1.0u l=0.15u mult=1 sa=0.265
+ sb=0.265 sd=0.28 area=0.063 perim=1.14
MMP2 y C net59 VNB sky130_fd_pr__pfet_01v8_hvt m=1 w=1.0u l=0.15u mult=1 sa=0.265
+ sb=0.265 sd=0.28 area=0.063 perim=1.14
MMIP0 A A_N net59 VNB sky130_fd_pr__pfet_01v8_hvt m=1 w=0.42u l=0.15u mult=1 sa=0.265
+ sb=0.265 sd=0.28 area=0.063 perim=1.14
MMIP1 X y net59 VNB sky130_fd_pr__pfet_01v8_hvt m=4 w=1.0u l=0.15u mult=1 sa=0.265
+ sb=0.265 sd=0.28 area=0.063 perim=1.14
MMN0 y A sndA VNB sky130_fd_pr__nfet_01v8 m=1 w=0.65u l=0.15u mult=1 sa=0.265 sb=0.265
+ sd=0.28 area=0.063 perim=1.14
MMN1 sndA B sndB VNB sky130_fd_pr__nfet_01v8 m=1 w=0.65u l=0.15u mult=1 sa=0.265
+ sb=0.265 sd=0.28 area=0.063 perim=1.14
MMN2 sndB C VGND VNB sky130_fd_pr__nfet_01v8 m=1 w=0.65u l=0.15u mult=1 sa=0.265
+ sb=0.265 sd=0.28 area=0.063 perim=1.14
MMIN0 A A_N VGND VNB sky130_fd_pr__nfet_01v8 m=1 w=0.42u l=0.15u mult=1 sa=0.265
+ sb=0.265 sd=0.28 area=0.063 perim=1.14
MMIN1 X y VGND VNB sky130_fd_pr__nfet_01v8 m=4 w=0.65u l=0.15u mult=1 sa=0.265
+ sb=0.265 sd=0.28 area=0.063 perim=1.14
.ENDS sky130_fd_sc_hd__and3b_4
* Copyright 2020 The SkyWater PDK Authors
*
* Licensed under the Apache License, Version 2.0 (the "License");
* you may not use this file except in compliance with the License.
* You may obtain a copy of the License at
*
*     https:  www.apache.org licenses LICENSE-2.0
*
* Unless required by applicable law or agreed to in writing, software
* distributed under the License is distributed on an "AS IS" BASIS,
* WITHOUT WARRANTIES OR CONDITIONS OF ANY KIND, either express or implied.
* See the License for the specific language governing permissions and
* limitations under the License.
*
* SPDX-License-Identifier: Apache-2.0

.SUBCKT sky130_fd_sc_hd__and4_1 A B C D VGND VNB VNB net59 X
*.PININFO A:I B:I C:I D:I VGND:I VNB:I VNB:I net59:I X:O
MMP0 y A net59 VNB sky130_fd_pr__pfet_01v8_hvt m=1 w=0.42u l=0.15u mult=1 sa=0.265
+ sb=0.265 sd=0.28 area=0.063 perim=1.14
MMP1 y B net59 VNB sky130_fd_pr__pfet_01v8_hvt m=1 w=0.42u l=0.15u mult=1 sa=0.265
+ sb=0.265 sd=0.28 area=0.063 perim=1.14
MMP2 y C net59 VNB sky130_fd_pr__pfet_01v8_hvt m=1 w=0.42u l=0.15u mult=1 sa=0.265
+ sb=0.265 sd=0.28 area=0.063 perim=1.14
MMP3 y D net59 VNB sky130_fd_pr__pfet_01v8_hvt m=1 w=0.42u l=0.15u mult=1 sa=0.265
+ sb=0.265 sd=0.28 area=0.063 perim=1.14
MMIP0 X y net59 VNB sky130_fd_pr__pfet_01v8_hvt m=1 w=1.0u l=0.15u mult=1 sa=0.265
+ sb=0.265 sd=0.28 area=0.063 perim=1.14
MMN0 y A sndA VNB sky130_fd_pr__nfet_01v8 m=1 w=0.42u l=0.15u mult=1 sa=0.265 sb=0.265
+ sd=0.28 area=0.063 perim=1.14
MMN1 sndA B sndB VNB sky130_fd_pr__nfet_01v8 m=1 w=0.42u l=0.15u mult=1 sa=0.265
+ sb=0.265 sd=0.28 area=0.063 perim=1.14
MMN2 sndB C sndC VNB sky130_fd_pr__nfet_01v8 m=1 w=0.42u l=0.15u mult=1 sa=0.265
+ sb=0.265 sd=0.28 area=0.063 perim=1.14
MMN3 sndC D VGND VNB sky130_fd_pr__nfet_01v8 m=1 w=0.42u l=0.15u mult=1 sa=0.265
+ sb=0.265 sd=0.28 area=0.063 perim=1.14
MMIN0 X y VGND VNB sky130_fd_pr__nfet_01v8 m=1 w=0.65u l=0.15u mult=1 sa=0.265
+ sb=0.265 sd=0.28 area=0.063 perim=1.14
.ENDS sky130_fd_sc_hd__and4_1
* Copyright 2020 The SkyWater PDK Authors
*
* Licensed under the Apache License, Version 2.0 (the "License");
* you may not use this file except in compliance with the License.
* You may obtain a copy of the License at
*
*     https:  www.apache.org licenses LICENSE-2.0
*
* Unless required by applicable law or agreed to in writing, software
* distributed under the License is distributed on an "AS IS" BASIS,
* WITHOUT WARRANTIES OR CONDITIONS OF ANY KIND, either express or implied.
* See the License for the specific language governing permissions and
* limitations under the License.
*
* SPDX-License-Identifier: Apache-2.0

.SUBCKT sky130_fd_sc_hd__and4_2 A B C D VGND VNB VNB net59 X
*.PININFO A:I B:I C:I D:I VGND:I VNB:I VNB:I net59:I X:O
MMP0 y A net59 VNB sky130_fd_pr__pfet_01v8_hvt m=1 w=0.42u l=0.15u mult=1 sa=0.265
+ sb=0.265 sd=0.28 area=0.063 perim=1.14
MMP1 y B net59 VNB sky130_fd_pr__pfet_01v8_hvt m=1 w=0.42u l=0.15u mult=1 sa=0.265
+ sb=0.265 sd=0.28 area=0.063 perim=1.14
MMP2 y C net59 VNB sky130_fd_pr__pfet_01v8_hvt m=1 w=0.42u l=0.15u mult=1 sa=0.265
+ sb=0.265 sd=0.28 area=0.063 perim=1.14
MMP3 y D net59 VNB sky130_fd_pr__pfet_01v8_hvt m=1 w=0.42u l=0.15u mult=1 sa=0.265
+ sb=0.265 sd=0.28 area=0.063 perim=1.14
MMIP0 X y net59 VNB sky130_fd_pr__pfet_01v8_hvt m=2 w=1.0u l=0.15u mult=1 sa=0.265
+ sb=0.265 sd=0.28 area=0.063 perim=1.14
MMN0 y A sndA VNB sky130_fd_pr__nfet_01v8 m=1 w=0.42u l=0.15u mult=1 sa=0.265 sb=0.265
+ sd=0.28 area=0.063 perim=1.14
MMN1 sndA B sndB VNB sky130_fd_pr__nfet_01v8 m=1 w=0.42u l=0.15u mult=1 sa=0.265
+ sb=0.265 sd=0.28 area=0.063 perim=1.14
MMN2 sndB C sndC VNB sky130_fd_pr__nfet_01v8 m=1 w=0.42u l=0.15u mult=1 sa=0.265
+ sb=0.265 sd=0.28 area=0.063 perim=1.14
MMN3 sndC D VGND VNB sky130_fd_pr__nfet_01v8 m=1 w=0.42u l=0.15u mult=1 sa=0.265
+ sb=0.265 sd=0.28 area=0.063 perim=1.14
MMIN0 X y VGND VNB sky130_fd_pr__nfet_01v8 m=2 w=0.65u l=0.15u mult=1 sa=0.265
+ sb=0.265 sd=0.28 area=0.063 perim=1.14
.ENDS sky130_fd_sc_hd__and4_2
* Copyright 2020 The SkyWater PDK Authors
*
* Licensed under the Apache License, Version 2.0 (the "License");
* you may not use this file except in compliance with the License.
* You may obtain a copy of the License at
*
*     https:  www.apache.org licenses LICENSE-2.0
*
* Unless required by applicable law or agreed to in writing, software
* distributed under the License is distributed on an "AS IS" BASIS,
* WITHOUT WARRANTIES OR CONDITIONS OF ANY KIND, either express or implied.
* See the License for the specific language governing permissions and
* limitations under the License.
*
* SPDX-License-Identifier: Apache-2.0

.SUBCKT sky130_fd_sc_hd__and4_4 A B C D VGND VNB VNB net59 X
*.PININFO A:I B:I C:I D:I VGND:I VNB:I VNB:I net59:I X:O
MMP0 y A net59 VNB sky130_fd_pr__pfet_01v8_hvt m=1 w=1.0u l=0.15u mult=1 sa=0.265
+ sb=0.265 sd=0.28 area=0.063 perim=1.14
MMP1 y B net59 VNB sky130_fd_pr__pfet_01v8_hvt m=1 w=1.0u l=0.15u mult=1 sa=0.265
+ sb=0.265 sd=0.28 area=0.063 perim=1.14
MMP2 y C net59 VNB sky130_fd_pr__pfet_01v8_hvt m=1 w=1.0u l=0.15u mult=1 sa=0.265
+ sb=0.265 sd=0.28 area=0.063 perim=1.14
MMP3 y D net59 VNB sky130_fd_pr__pfet_01v8_hvt m=1 w=1.0u l=0.15u mult=1 sa=0.265
+ sb=0.265 sd=0.28 area=0.063 perim=1.14
MMIP0 X y net59 VNB sky130_fd_pr__pfet_01v8_hvt m=4 w=1.0u l=0.15u mult=1 sa=0.265
+ sb=0.265 sd=0.28 area=0.063 perim=1.14
MMN0 y A sndA VNB sky130_fd_pr__nfet_01v8 m=1 w=0.65u l=0.15u mult=1 sa=0.265 sb=0.265
+ sd=0.28 area=0.063 perim=1.14
MMN1 sndA B sndB VNB sky130_fd_pr__nfet_01v8 m=1 w=0.65u l=0.15u mult=1 sa=0.265
+ sb=0.265 sd=0.28 area=0.063 perim=1.14
MMN2 sndB C sndC VNB sky130_fd_pr__nfet_01v8 m=1 w=0.65u l=0.15u mult=1 sa=0.265
+ sb=0.265 sd=0.28 area=0.063 perim=1.14
MMN3 sndC D VGND VNB sky130_fd_pr__nfet_01v8 m=1 w=0.65u l=0.15u mult=1 sa=0.265
+ sb=0.265 sd=0.28 area=0.063 perim=1.14
MMIN0 X y VGND VNB sky130_fd_pr__nfet_01v8 m=4 w=0.65u l=0.15u mult=1 sa=0.265
+ sb=0.265 sd=0.28 area=0.063 perim=1.14
.ENDS sky130_fd_sc_hd__and4_4
* Copyright 2020 The SkyWater PDK Authors
*
* Licensed under the Apache License, Version 2.0 (the "License");
* you may not use this file except in compliance with the License.
* You may obtain a copy of the License at
*
*     https:  www.apache.org licenses LICENSE-2.0
*
* Unless required by applicable law or agreed to in writing, software
* distributed under the License is distributed on an "AS IS" BASIS,
* WITHOUT WARRANTIES OR CONDITIONS OF ANY KIND, either express or implied.
* See the License for the specific language governing permissions and
* limitations under the License.
*
* SPDX-License-Identifier: Apache-2.0

.SUBCKT sky130_fd_sc_hd__and4b_1 A_N B C D VGND VNB VNB net59 X
*.PININFO A_N:I B:I C:I D:I VGND:I VNB:I VNB:I net59:I X:O
MMP0 y A net59 VNB sky130_fd_pr__pfet_01v8_hvt m=1 w=0.42u l=0.15u mult=1 sa=0.265
+ sb=0.265 sd=0.28 area=0.063 perim=1.14
MMP1 y B net59 VNB sky130_fd_pr__pfet_01v8_hvt m=1 w=0.42u l=0.15u mult=1 sa=0.265
+ sb=0.265 sd=0.28 area=0.063 perim=1.14
MMP2 y C net59 VNB sky130_fd_pr__pfet_01v8_hvt m=1 w=0.42u l=0.15u mult=1 sa=0.265
+ sb=0.265 sd=0.28 area=0.063 perim=1.14
MMP3 y D net59 VNB sky130_fd_pr__pfet_01v8_hvt m=1 w=0.42u l=0.15u mult=1 sa=0.265
+ sb=0.265 sd=0.28 area=0.063 perim=1.14
MMIP0 A A_N net59 VNB sky130_fd_pr__pfet_01v8_hvt m=1 w=0.42u l=0.15u mult=1 sa=0.265
+ sb=0.265 sd=0.28 area=0.063 perim=1.14
MMIP1 X y net59 VNB sky130_fd_pr__pfet_01v8_hvt m=1 w=1.0u l=0.15u mult=1 sa=0.265
+ sb=0.265 sd=0.28 area=0.063 perim=1.14
MMN0 y A sndA VNB sky130_fd_pr__nfet_01v8 m=1 w=0.42u l=0.15u mult=1 sa=0.265 sb=0.265
+ sd=0.28 area=0.063 perim=1.14
MMN1 sndA B sndB VNB sky130_fd_pr__nfet_01v8 m=1 w=0.42u l=0.15u mult=1 sa=0.265
+ sb=0.265 sd=0.28 area=0.063 perim=1.14
MMN2 sndB C sndC VNB sky130_fd_pr__nfet_01v8 m=1 w=0.42u l=0.15u mult=1 sa=0.265
+ sb=0.265 sd=0.28 area=0.063 perim=1.14
MMN3 sndC D VGND VNB sky130_fd_pr__nfet_01v8 m=1 w=0.42u l=0.15u mult=1 sa=0.265
+ sb=0.265 sd=0.28 area=0.063 perim=1.14
MMIN0 A A_N VGND VNB sky130_fd_pr__nfet_01v8 m=1 w=0.42u l=0.15u mult=1 sa=0.265
+ sb=0.265 sd=0.28 area=0.063 perim=1.14
MMIN1 X y VGND VNB sky130_fd_pr__nfet_01v8 m=1 w=0.65u l=0.15u mult=1 sa=0.265
+ sb=0.265 sd=0.28 area=0.063 perim=1.14
.ENDS sky130_fd_sc_hd__and4b_1
* Copyright 2020 The SkyWater PDK Authors
*
* Licensed under the Apache License, Version 2.0 (the "License");
* you may not use this file except in compliance with the License.
* You may obtain a copy of the License at
*
*     https:  www.apache.org licenses LICENSE-2.0
*
* Unless required by applicable law or agreed to in writing, software
* distributed under the License is distributed on an "AS IS" BASIS,
* WITHOUT WARRANTIES OR CONDITIONS OF ANY KIND, either express or implied.
* See the License for the specific language governing permissions and
* limitations under the License.
*
* SPDX-License-Identifier: Apache-2.0

.SUBCKT sky130_fd_sc_hd__and4b_2 A_N B C D VGND VNB VNB net59 X
*.PININFO A_N:I B:I C:I D:I VGND:I VNB:I VNB:I net59:I X:O
MMP0 y A net59 VNB sky130_fd_pr__pfet_01v8_hvt m=1 w=0.42u l=0.15u mult=1 sa=0.265
+ sb=0.265 sd=0.28 area=0.063 perim=1.14
MMP1 y B net59 VNB sky130_fd_pr__pfet_01v8_hvt m=1 w=0.42u l=0.15u mult=1 sa=0.265
+ sb=0.265 sd=0.28 area=0.063 perim=1.14
MMP2 y C net59 VNB sky130_fd_pr__pfet_01v8_hvt m=1 w=0.42u l=0.15u mult=1 sa=0.265
+ sb=0.265 sd=0.28 area=0.063 perim=1.14
MMP3 y D net59 VNB sky130_fd_pr__pfet_01v8_hvt m=1 w=0.42u l=0.15u mult=1 sa=0.265
+ sb=0.265 sd=0.28 area=0.063 perim=1.14
MMIP0 A A_N net59 VNB sky130_fd_pr__pfet_01v8_hvt m=1 w=0.42u l=0.15u mult=1 sa=0.265
+ sb=0.265 sd=0.28 area=0.063 perim=1.14
MMIP1 X y net59 VNB sky130_fd_pr__pfet_01v8_hvt m=2 w=1.0u l=0.15u mult=1 sa=0.265
+ sb=0.265 sd=0.28 area=0.063 perim=1.14
MMN0 y A sndA VNB sky130_fd_pr__nfet_01v8 m=1 w=0.42u l=0.15u mult=1 sa=0.265 sb=0.265
+ sd=0.28 area=0.063 perim=1.14
MMN1 sndA B sndB VNB sky130_fd_pr__nfet_01v8 m=1 w=0.42u l=0.15u mult=1 sa=0.265
+ sb=0.265 sd=0.28 area=0.063 perim=1.14
MMN2 sndB C sndC VNB sky130_fd_pr__nfet_01v8 m=1 w=0.42u l=0.15u mult=1 sa=0.265
+ sb=0.265 sd=0.28 area=0.063 perim=1.14
MMN3 sndC D VGND VNB sky130_fd_pr__nfet_01v8 m=1 w=0.42u l=0.15u mult=1 sa=0.265
+ sb=0.265 sd=0.28 area=0.063 perim=1.14
MMIN0 A A_N VGND VNB sky130_fd_pr__nfet_01v8 m=1 w=0.42u l=0.15u mult=1 sa=0.265
+ sb=0.265 sd=0.28 area=0.063 perim=1.14
MMIN1 X y VGND VNB sky130_fd_pr__nfet_01v8 m=2 w=0.65u l=0.15u mult=1 sa=0.265
+ sb=0.265 sd=0.28 area=0.063 perim=1.14
.ENDS sky130_fd_sc_hd__and4b_2
* Copyright 2020 The SkyWater PDK Authors
*
* Licensed under the Apache License, Version 2.0 (the "License");
* you may not use this file except in compliance with the License.
* You may obtain a copy of the License at
*
*     https:  www.apache.org licenses LICENSE-2.0
*
* Unless required by applicable law or agreed to in writing, software
* distributed under the License is distributed on an "AS IS" BASIS,
* WITHOUT WARRANTIES OR CONDITIONS OF ANY KIND, either express or implied.
* See the License for the specific language governing permissions and
* limitations under the License.
*
* SPDX-License-Identifier: Apache-2.0

.SUBCKT sky130_fd_sc_hd__and4b_4 A_N B C D VGND VNB VNB net59 X
*.PININFO A_N:I B:I C:I D:I VGND:I VNB:I VNB:I net59:I X:O
MMP0 y A net59 VNB sky130_fd_pr__pfet_01v8_hvt m=1 w=1.0u l=0.15u mult=1 sa=0.265
+ sb=0.265 sd=0.28 area=0.063 perim=1.14
MMP1 y B net59 VNB sky130_fd_pr__pfet_01v8_hvt m=1 w=1.0u l=0.15u mult=1 sa=0.265
+ sb=0.265 sd=0.28 area=0.063 perim=1.14
MMP2 y C net59 VNB sky130_fd_pr__pfet_01v8_hvt m=1 w=1.0u l=0.15u mult=1 sa=0.265
+ sb=0.265 sd=0.28 area=0.063 perim=1.14
MMP3 y D net59 VNB sky130_fd_pr__pfet_01v8_hvt m=1 w=1.0u l=0.15u mult=1 sa=0.265
+ sb=0.265 sd=0.28 area=0.063 perim=1.14
MMIP0 A A_N net59 VNB sky130_fd_pr__pfet_01v8_hvt m=1 w=0.42u l=0.15u mult=1 sa=0.265
+ sb=0.265 sd=0.28 area=0.063 perim=1.14
MMIP1 X y net59 VNB sky130_fd_pr__pfet_01v8_hvt m=4 w=1.0u l=0.15u mult=1 sa=0.265
+ sb=0.265 sd=0.28 area=0.063 perim=1.14
MMN0 y A sndA VNB sky130_fd_pr__nfet_01v8 m=1 w=0.65u l=0.15u mult=1 sa=0.265 sb=0.265
+ sd=0.28 area=0.063 perim=1.14
MMN1 sndA B sndB VNB sky130_fd_pr__nfet_01v8 m=1 w=0.65u l=0.15u mult=1 sa=0.265
+ sb=0.265 sd=0.28 area=0.063 perim=1.14
MMN2 sndB C sndC VNB sky130_fd_pr__nfet_01v8 m=1 w=0.65u l=0.15u mult=1 sa=0.265
+ sb=0.265 sd=0.28 area=0.063 perim=1.14
MMN3 sndC D VGND VNB sky130_fd_pr__nfet_01v8 m=1 w=0.65u l=0.15u mult=1 sa=0.265
+ sb=0.265 sd=0.28 area=0.063 perim=1.14
MMIN0 A A_N VGND VNB sky130_fd_pr__nfet_01v8 m=1 w=0.42u l=0.15u mult=1 sa=0.265
+ sb=0.265 sd=0.28 area=0.063 perim=1.14
MMIN1 X y VGND VNB sky130_fd_pr__nfet_01v8 m=4 w=0.65u l=0.15u mult=1 sa=0.265
+ sb=0.265 sd=0.28 area=0.063 perim=1.14
.ENDS sky130_fd_sc_hd__and4b_4
* Copyright 2020 The SkyWater PDK Authors
*
* Licensed under the Apache License, Version 2.0 (the "License");
* you may not use this file except in compliance with the License.
* You may obtain a copy of the License at
*
*     https:  www.apache.org licenses LICENSE-2.0
*
* Unless required by applicable law or agreed to in writing, software
* distributed under the License is distributed on an "AS IS" BASIS,
* WITHOUT WARRANTIES OR CONDITIONS OF ANY KIND, either express or implied.
* See the License for the specific language governing permissions and
* limitations under the License.
*
* SPDX-License-Identifier: Apache-2.0

.SUBCKT sky130_fd_sc_hd__and4bb_1 A_N B_N C D VGND VNB VNB net59 X
*.PININFO A_N:I B_N:I C:I D:I VGND:I VNB:I VNB:I net59:I X:O
MMP0 y A net59 VNB sky130_fd_pr__pfet_01v8_hvt m=1 w=0.42u l=0.15u mult=1 sa=0.265
+ sb=0.265 sd=0.28 area=0.063 perim=1.14
MMP1 y B net59 VNB sky130_fd_pr__pfet_01v8_hvt m=1 w=0.42u l=0.15u mult=1 sa=0.265
+ sb=0.265 sd=0.28 area=0.063 perim=1.14
MMP2 y C net59 VNB sky130_fd_pr__pfet_01v8_hvt m=1 w=0.42u l=0.15u mult=1 sa=0.265
+ sb=0.265 sd=0.28 area=0.063 perim=1.14
MMP3 y D net59 VNB sky130_fd_pr__pfet_01v8_hvt m=1 w=0.42u l=0.15u mult=1 sa=0.265
+ sb=0.265 sd=0.28 area=0.063 perim=1.14
MMIP0 A A_N net59 VNB sky130_fd_pr__pfet_01v8_hvt m=1 w=0.42u l=0.15u mult=1 sa=0.265
+ sb=0.265 sd=0.28 area=0.063 perim=1.14
MMIP1 B B_N net59 VNB sky130_fd_pr__pfet_01v8_hvt m=1 w=0.42u l=0.15u mult=1 sa=0.265
+ sb=0.265 sd=0.28 area=0.063 perim=1.14
MMIP2 X y net59 VNB sky130_fd_pr__pfet_01v8_hvt m=1 w=1.0u l=0.15u mult=1 sa=0.265
+ sb=0.265 sd=0.28 area=0.063 perim=1.14
MMN0 y A sndA VNB sky130_fd_pr__nfet_01v8 m=1 w=0.42u l=0.15u mult=1 sa=0.265 sb=0.265
+ sd=0.28 area=0.063 perim=1.14
MMN1 sndA B sndB VNB sky130_fd_pr__nfet_01v8 m=1 w=0.42u l=0.15u mult=1 sa=0.265
+ sb=0.265 sd=0.28 area=0.063 perim=1.14
MMN2 sndB C sndC VNB sky130_fd_pr__nfet_01v8 m=1 w=0.42u l=0.15u mult=1 sa=0.265
+ sb=0.265 sd=0.28 area=0.063 perim=1.14
MMN3 sndC D VGND VNB sky130_fd_pr__nfet_01v8 m=1 w=0.42u l=0.15u mult=1 sa=0.265
+ sb=0.265 sd=0.28 area=0.063 perim=1.14
MMIN0 A A_N VGND VNB sky130_fd_pr__nfet_01v8 m=1 w=0.42u l=0.15u mult=1 sa=0.265
+ sb=0.265 sd=0.28 area=0.063 perim=1.14
MMIN1 B B_N VGND VNB sky130_fd_pr__nfet_01v8 m=1 w=0.42u l=0.15u mult=1 sa=0.265
+ sb=0.265 sd=0.28 area=0.063 perim=1.14
MMIN2 X y VGND VNB sky130_fd_pr__nfet_01v8 m=1 w=0.65u l=0.15u mult=1 sa=0.265
+ sb=0.265 sd=0.28 area=0.063 perim=1.14
.ENDS sky130_fd_sc_hd__and4bb_1
* Copyright 2020 The SkyWater PDK Authors
*
* Licensed under the Apache License, Version 2.0 (the "License");
* you may not use this file except in compliance with the License.
* You may obtain a copy of the License at
*
*     https:  www.apache.org licenses LICENSE-2.0
*
* Unless required by applicable law or agreed to in writing, software
* distributed under the License is distributed on an "AS IS" BASIS,
* WITHOUT WARRANTIES OR CONDITIONS OF ANY KIND, either express or implied.
* See the License for the specific language governing permissions and
* limitations under the License.
*
* SPDX-License-Identifier: Apache-2.0

.SUBCKT sky130_fd_sc_hd__and4bb_2 A_N B_N C D VGND VNB VNB net59 X
*.PININFO A_N:I B_N:I C:I D:I VGND:I VNB:I VNB:I net59:I X:O
MMP0 y A net59 VNB sky130_fd_pr__pfet_01v8_hvt m=1 w=0.42u l=0.15u mult=1 sa=0.265
+ sb=0.265 sd=0.28 area=0.063 perim=1.14
MMP1 y B net59 VNB sky130_fd_pr__pfet_01v8_hvt m=1 w=0.42u l=0.15u mult=1 sa=0.265
+ sb=0.265 sd=0.28 area=0.063 perim=1.14
MMP2 y C net59 VNB sky130_fd_pr__pfet_01v8_hvt m=1 w=0.42u l=0.15u mult=1 sa=0.265
+ sb=0.265 sd=0.28 area=0.063 perim=1.14
MMP3 y D net59 VNB sky130_fd_pr__pfet_01v8_hvt m=1 w=0.42u l=0.15u mult=1 sa=0.265
+ sb=0.265 sd=0.28 area=0.063 perim=1.14
MMIP0 A A_N net59 VNB sky130_fd_pr__pfet_01v8_hvt m=1 w=0.42u l=0.15u mult=1 sa=0.265
+ sb=0.265 sd=0.28 area=0.063 perim=1.14
MMIP1 B B_N net59 VNB sky130_fd_pr__pfet_01v8_hvt m=1 w=0.42u l=0.15u mult=1 sa=0.265
+ sb=0.265 sd=0.28 area=0.063 perim=1.14
MMIP2 X y net59 VNB sky130_fd_pr__pfet_01v8_hvt m=2 w=1.0u l=0.15u mult=1 sa=0.265
+ sb=0.265 sd=0.28 area=0.063 perim=1.14
MMN0 y A sndA VNB sky130_fd_pr__nfet_01v8 m=1 w=0.42u l=0.15u mult=1 sa=0.265 sb=0.265
+ sd=0.28 area=0.063 perim=1.14
MMN1 sndA B sndB VNB sky130_fd_pr__nfet_01v8 m=1 w=0.42u l=0.15u mult=1 sa=0.265
+ sb=0.265 sd=0.28 area=0.063 perim=1.14
MMN2 sndB C sndC VNB sky130_fd_pr__nfet_01v8 m=1 w=0.42u l=0.15u mult=1 sa=0.265
+ sb=0.265 sd=0.28 area=0.063 perim=1.14
MMN3 sndC D VGND VNB sky130_fd_pr__nfet_01v8 m=1 w=0.42u l=0.15u mult=1 sa=0.265
+ sb=0.265 sd=0.28 area=0.063 perim=1.14
MMIN0 A A_N VGND VNB sky130_fd_pr__nfet_01v8 m=1 w=0.42u l=0.15u mult=1 sa=0.265
+ sb=0.265 sd=0.28 area=0.063 perim=1.14
MMIN1 B B_N VGND VNB sky130_fd_pr__nfet_01v8 m=1 w=0.42u l=0.15u mult=1 sa=0.265
+ sb=0.265 sd=0.28 area=0.063 perim=1.14
MMIN2 X y VGND VNB sky130_fd_pr__nfet_01v8 m=2 w=0.65u l=0.15u mult=1 sa=0.265
+ sb=0.265 sd=0.28 area=0.063 perim=1.14
.ENDS sky130_fd_sc_hd__and4bb_2
* Copyright 2020 The SkyWater PDK Authors
*
* Licensed under the Apache License, Version 2.0 (the "License");
* you may not use this file except in compliance with the License.
* You may obtain a copy of the License at
*
*     https:  www.apache.org licenses LICENSE-2.0
*
* Unless required by applicable law or agreed to in writing, software
* distributed under the License is distributed on an "AS IS" BASIS,
* WITHOUT WARRANTIES OR CONDITIONS OF ANY KIND, either express or implied.
* See the License for the specific language governing permissions and
* limitations under the License.
*
* SPDX-License-Identifier: Apache-2.0

.SUBCKT sky130_fd_sc_hd__and4bb_4 A_N B_N C D VGND VNB VNB net59 X
*.PININFO A_N:I B_N:I C:I D:I VGND:I VNB:I VNB:I net59:I X:O
MMP0 y A net59 VNB sky130_fd_pr__pfet_01v8_hvt m=1 w=1.0u l=0.15u mult=1 sa=0.265
+ sb=0.265 sd=0.28 area=0.063 perim=1.14
MMP1 y B net59 VNB sky130_fd_pr__pfet_01v8_hvt m=1 w=1.0u l=0.15u mult=1 sa=0.265
+ sb=0.265 sd=0.28 area=0.063 perim=1.14
MMP2 y C net59 VNB sky130_fd_pr__pfet_01v8_hvt m=1 w=1.0u l=0.15u mult=1 sa=0.265
+ sb=0.265 sd=0.28 area=0.063 perim=1.14
MMP3 y D net59 VNB sky130_fd_pr__pfet_01v8_hvt m=1 w=1.0u l=0.15u mult=1 sa=0.265
+ sb=0.265 sd=0.28 area=0.063 perim=1.14
MMIP0 A A_N net59 VNB sky130_fd_pr__pfet_01v8_hvt m=1 w=0.42u l=0.15u mult=1 sa=0.265
+ sb=0.265 sd=0.28 area=0.063 perim=1.14
MMIP1 B B_N net59 VNB sky130_fd_pr__pfet_01v8_hvt m=1 w=0.42u l=0.15u mult=1 sa=0.265
+ sb=0.265 sd=0.28 area=0.063 perim=1.14
MMIP2 X y net59 VNB sky130_fd_pr__pfet_01v8_hvt m=4 w=1.0u l=0.15u mult=1 sa=0.265
+ sb=0.265 sd=0.28 area=0.063 perim=1.14
MMN0 y A sndA VNB sky130_fd_pr__nfet_01v8 m=1 w=0.65u l=0.15u mult=1 sa=0.265 sb=0.265
+ sd=0.28 area=0.063 perim=1.14
MMN1 sndA B sndB VNB sky130_fd_pr__nfet_01v8 m=1 w=0.65u l=0.15u mult=1 sa=0.265
+ sb=0.265 sd=0.28 area=0.063 perim=1.14
MMN2 sndB C sndC VNB sky130_fd_pr__nfet_01v8 m=1 w=0.65u l=0.15u mult=1 sa=0.265
+ sb=0.265 sd=0.28 area=0.063 perim=1.14
MMN3 sndC D VGND VNB sky130_fd_pr__nfet_01v8 m=1 w=0.65u l=0.15u mult=1 sa=0.265
+ sb=0.265 sd=0.28 area=0.063 perim=1.14
MMIN0 A A_N VGND VNB sky130_fd_pr__nfet_01v8 m=1 w=0.42u l=0.15u mult=1 sa=0.265
+ sb=0.265 sd=0.28 area=0.063 perim=1.14
MMIN1 B B_N VGND VNB sky130_fd_pr__nfet_01v8 m=1 w=0.42u l=0.15u mult=1 sa=0.265
+ sb=0.265 sd=0.28 area=0.063 perim=1.14
MMIN2 X y VGND VNB sky130_fd_pr__nfet_01v8 m=4 w=0.65u l=0.15u mult=1 sa=0.265
+ sb=0.265 sd=0.28 area=0.063 perim=1.14
.ENDS sky130_fd_sc_hd__and4bb_4
* Copyright 2020 The SkyWater PDK Authors
*
* Licensed under the Apache License, Version 2.0 (the "License");
* you may not use this file except in compliance with the License.
* You may obtain a copy of the License at
*
*     https:  www.apache.org licenses LICENSE-2.0
*
* Unless required by applicable law or agreed to in writing, software
* distributed under the License is distributed on an "AS IS" BASIS,
* WITHOUT WARRANTIES OR CONDITIONS OF ANY KIND, either express or implied.
* See the License for the specific language governing permissions and
* limitations under the License.
*
* SPDX-License-Identifier: Apache-2.0

.SUBCKT sky130_fd_sc_hd__buf_1 A VGND VNB VNB net59 X
*.PININFO A:I VGND:I VNB:I VNB:I net59:I X:O
MMIN1 Ab A VGND VNB sky130_fd_pr__nfet_01v8 m=1 w=0.52u l=0.15u mult=1 sa=0.265
+ sb=0.265 sd=0.28 area=0.063 perim=1.14
MMIN2 X Ab VGND VNB sky130_fd_pr__nfet_01v8 m=1 w=0.52u l=0.15u mult=1 sa=0.265
+ sb=0.265 sd=0.28 area=0.063 perim=1.14
MMIP1 Ab A net59 VNB sky130_fd_pr__pfet_01v8_hvt m=1 w=0.79u l=0.15u mult=1 sa=0.265
+ sb=0.265 sd=0.28 area=0.063 perim=1.14
MMIP2 X Ab net59 VNB sky130_fd_pr__pfet_01v8_hvt m=1 w=0.79u l=0.15u mult=1 sa=0.265
+ sb=0.265 sd=0.28 area=0.063 perim=1.14
.ENDS sky130_fd_sc_hd__buf_1
* Copyright 2020 The SkyWater PDK Authors
*
* Licensed under the Apache License, Version 2.0 (the "License");
* you may not use this file except in compliance with the License.
* You may obtain a copy of the License at
*
*     https:  www.apache.org licenses LICENSE-2.0
*
* Unless required by applicable law or agreed to in writing, software
* distributed under the License is distributed on an "AS IS" BASIS,
* WITHOUT WARRANTIES OR CONDITIONS OF ANY KIND, either express or implied.
* See the License for the specific language governing permissions and
* limitations under the License.
*
* SPDX-License-Identifier: Apache-2.0

.SUBCKT sky130_fd_sc_hd__buf_12 A VGND VNB VNB net59 X
*.PININFO A:I VGND:I VNB:I VNB:I net59:I X:O
MMIN1 Ab A VGND VNB sky130_fd_pr__nfet_01v8 m=4 w=0.65u l=0.15u mult=1 sa=0.265
+ sb=0.265 sd=0.28 area=0.063 perim=1.14
MMIN2 X Ab VGND VNB sky130_fd_pr__nfet_01v8 m=12 w=0.65u l=0.15u mult=1 sa=0.265
+ sb=0.265 sd=0.28 area=0.063 perim=1.14
MMIP1 Ab A net59 VNB sky130_fd_pr__pfet_01v8_hvt m=4 w=1.0u l=0.15u mult=1 sa=0.265
+ sb=0.265 sd=0.28 area=0.063 perim=1.14
MMIP2 X Ab net59 VNB sky130_fd_pr__pfet_01v8_hvt m=12 w=1.0u l=0.15u mult=1 sa=0.265
+ sb=0.265 sd=0.28 area=0.063 perim=1.14
.ENDS sky130_fd_sc_hd__buf_12
* Copyright 2020 The SkyWater PDK Authors
*
* Licensed under the Apache License, Version 2.0 (the "License");
* you may not use this file except in compliance with the License.
* You may obtain a copy of the License at
*
*     https:  www.apache.org licenses LICENSE-2.0
*
* Unless required by applicable law or agreed to in writing, software
* distributed under the License is distributed on an "AS IS" BASIS,
* WITHOUT WARRANTIES OR CONDITIONS OF ANY KIND, either express or implied.
* See the License for the specific language governing permissions and
* limitations under the License.
*
* SPDX-License-Identifier: Apache-2.0

.SUBCKT sky130_fd_sc_hd__buf_16 A VGND VNB VNB net59 X
*.PININFO A:I VGND:I VNB:I VNB:I net59:I X:O
MMIN1 Ab A VGND VNB sky130_fd_pr__nfet_01v8 m=6 w=0.65u l=0.15u mult=1 sa=0.265
+ sb=0.265 sd=0.28 area=0.063 perim=1.14
MMIN2 X Ab VGND VNB sky130_fd_pr__nfet_01v8 m=16 w=0.65u l=0.15u mult=1 sa=0.265
+ sb=0.265 sd=0.28 area=0.063 perim=1.14
MMIP1 Ab A net59 VNB sky130_fd_pr__pfet_01v8_hvt m=6 w=1.0u l=0.15u mult=1 sa=0.265
+ sb=0.265 sd=0.28 area=0.063 perim=1.14
MMIP2 X Ab net59 VNB sky130_fd_pr__pfet_01v8_hvt m=16 w=1.0u l=0.15u mult=1 sa=0.265
+ sb=0.265 sd=0.28 area=0.063 perim=1.14
.ENDS sky130_fd_sc_hd__buf_16
* Copyright 2020 The SkyWater PDK Authors
*
* Licensed under the Apache License, Version 2.0 (the "License");
* you may not use this file except in compliance with the License.
* You may obtain a copy of the License at
*
*     https:  www.apache.org licenses LICENSE-2.0
*
* Unless required by applicable law or agreed to in writing, software
* distributed under the License is distributed on an "AS IS" BASIS,
* WITHOUT WARRANTIES OR CONDITIONS OF ANY KIND, either express or implied.
* See the License for the specific language governing permissions and
* limitations under the License.
*
* SPDX-License-Identifier: Apache-2.0

.SUBCKT sky130_fd_sc_hd__buf_2 A VGND VNB VNB net59 X
*.PININFO A:I VGND:I VNB:I VNB:I net59:I X:O
MMIN1 Ab A VGND VNB sky130_fd_pr__nfet_01v8 m=1 w=0.42u l=0.15u mult=1 sa=0.265
+ sb=0.265 sd=0.28 area=0.063 perim=1.14
MMIN2 X Ab VGND VNB sky130_fd_pr__nfet_01v8 m=2 w=0.65u l=0.15u mult=1 sa=0.265
+ sb=0.265 sd=0.28 area=0.063 perim=1.14
MMIP1 Ab A net59 VNB sky130_fd_pr__pfet_01v8_hvt m=1 w=0.64u l=0.15u mult=1 sa=0.265
+ sb=0.265 sd=0.28 area=0.063 perim=1.14
MMIP2 X Ab net59 VNB sky130_fd_pr__pfet_01v8_hvt m=2 w=1.0u l=0.15u mult=1 sa=0.265
+ sb=0.265 sd=0.28 area=0.063 perim=1.14
.ENDS sky130_fd_sc_hd__buf_2
* Copyright 2020 The SkyWater PDK Authors
*
* Licensed under the Apache License, Version 2.0 (the "License");
* you may not use this file except in compliance with the License.
* You may obtain a copy of the License at
*
*     https:  www.apache.org licenses LICENSE-2.0
*
* Unless required by applicable law or agreed to in writing, software
* distributed under the License is distributed on an "AS IS" BASIS,
* WITHOUT WARRANTIES OR CONDITIONS OF ANY KIND, either express or implied.
* See the License for the specific language governing permissions and
* limitations under the License.
*
* SPDX-License-Identifier: Apache-2.0

.SUBCKT sky130_fd_sc_hd__buf_4 A VGND VNB VNB net59 X
*.PININFO A:I VGND:I VNB:I VNB:I net59:I X:O
MMIN1 Ab A VGND VNB sky130_fd_pr__nfet_01v8 m=1 w=0.65u l=0.15u mult=1 sa=0.265
+ sb=0.265 sd=0.28 area=0.063 perim=1.14
MMIN2 X Ab VGND VNB sky130_fd_pr__nfet_01v8 m=4 w=0.65u l=0.15u mult=1 sa=0.265
+ sb=0.265 sd=0.28 area=0.063 perim=1.14
MMIP1 Ab A net59 VNB sky130_fd_pr__pfet_01v8_hvt m=1 w=1.0u l=0.15u mult=1 sa=0.265
+ sb=0.265 sd=0.28 area=0.063 perim=1.14
MMIP2 X Ab net59 VNB sky130_fd_pr__pfet_01v8_hvt m=4 w=1.0u l=0.15u mult=1 sa=0.265
+ sb=0.265 sd=0.28 area=0.063 perim=1.14
.ENDS sky130_fd_sc_hd__buf_4
* Copyright 2020 The SkyWater PDK Authors
*
* Licensed under the Apache License, Version 2.0 (the "License");
* you may not use this file except in compliance with the License.
* You may obtain a copy of the License at
*
*     https:  www.apache.org licenses LICENSE-2.0
*
* Unless required by applicable law or agreed to in writing, software
* distributed under the License is distributed on an "AS IS" BASIS,
* WITHOUT WARRANTIES OR CONDITIONS OF ANY KIND, either express or implied.
* See the License for the specific language governing permissions and
* limitations under the License.
*
* SPDX-License-Identifier: Apache-2.0

.SUBCKT sky130_fd_sc_hd__buf_6 A VGND VNB VNB net59 X
*.PININFO A:I VGND:I VNB:I VNB:I net59:I X:O
MMIN1 Ab A VGND VNB sky130_fd_pr__nfet_01v8 m=2 w=0.65u l=0.15u mult=1 sa=0.265
+ sb=0.265 sd=0.28 area=0.063 perim=1.14
MMIN2 X Ab VGND VNB sky130_fd_pr__nfet_01v8 m=6 w=0.65u l=0.15u mult=1 sa=0.265
+ sb=0.265 sd=0.28 area=0.063 perim=1.14
MMIP1 Ab A net59 VNB sky130_fd_pr__pfet_01v8_hvt m=2 w=1.0u l=0.15u mult=1 sa=0.265
+ sb=0.265 sd=0.28 area=0.063 perim=1.14
MMIP2 X Ab net59 VNB sky130_fd_pr__pfet_01v8_hvt m=6 w=1.0u l=0.15u mult=1 sa=0.265
+ sb=0.265 sd=0.28 area=0.063 perim=1.14
.ENDS sky130_fd_sc_hd__buf_6
* Copyright 2020 The SkyWater PDK Authors
*
* Licensed under the Apache License, Version 2.0 (the "License");
* you may not use this file except in compliance with the License.
* You may obtain a copy of the License at
*
*     https:  www.apache.org licenses LICENSE-2.0
*
* Unless required by applicable law or agreed to in writing, software
* distributed under the License is distributed on an "AS IS" BASIS,
* WITHOUT WARRANTIES OR CONDITIONS OF ANY KIND, either express or implied.
* See the License for the specific language governing permissions and
* limitations under the License.
*
* SPDX-License-Identifier: Apache-2.0

.SUBCKT sky130_fd_sc_hd__buf_8 A VGND VNB VNB net59 X
*.PININFO A:I VGND:I VNB:I VNB:I net59:I X:O
MMIN1 Ab A VGND VNB sky130_fd_pr__nfet_01v8 m=3 w=0.65u l=0.15u mult=1 sa=0.265
+ sb=0.265 sd=0.28 area=0.063 perim=1.14
MMIN2 X Ab VGND VNB sky130_fd_pr__nfet_01v8 m=8 w=0.65u l=0.15u mult=1 sa=0.265
+ sb=0.265 sd=0.28 area=0.063 perim=1.14
MMIP1 Ab A net59 VNB sky130_fd_pr__pfet_01v8_hvt m=3 w=1.0u l=0.15u mult=1 sa=0.265
+ sb=0.265 sd=0.28 area=0.063 perim=1.14
MMIP2 X Ab net59 VNB sky130_fd_pr__pfet_01v8_hvt m=8 w=1.0u l=0.15u mult=1 sa=0.265
+ sb=0.265 sd=0.28 area=0.063 perim=1.14
.ENDS sky130_fd_sc_hd__buf_8
* Copyright 2020 The SkyWater PDK Authors
*
* Licensed under the Apache License, Version 2.0 (the "License");
* you may not use this file except in compliance with the License.
* You may obtain a copy of the License at
*
*     https:  www.apache.org licenses LICENSE-2.0
*
* Unless required by applicable law or agreed to in writing, software
* distributed under the License is distributed on an "AS IS" BASIS,
* WITHOUT WARRANTIES OR CONDITIONS OF ANY KIND, either express or implied.
* See the License for the specific language governing permissions and
* limitations under the License.
*
* SPDX-License-Identifier: Apache-2.0

.SUBCKT sky130_fd_sc_hd__bufbuf_16 A VGND VNB VNB net59 X
*.PININFO A:I VGND:I VNB:I VNB:I net59:I X:O
MMIN1 Ab A VGND VNB sky130_fd_pr__nfet_01v8 m=1 w=0.65u l=0.15u mult=1 sa=0.265
+ sb=0.265 sd=0.28 area=0.063 perim=1.14
MMIN2 Abb Ab VGND VNB sky130_fd_pr__nfet_01v8 m=3 w=0.65u l=0.15u mult=1 sa=0.265
+ sb=0.265 sd=0.28 area=0.063 perim=1.14
MMIN3 Abbb Abb VGND VNB sky130_fd_pr__nfet_01v8 m=6 w=0.65u l=0.15u mult=1 sa=0.265
+ sb=0.265 sd=0.28 area=0.063 perim=1.14
MMIN4 X Abbb VGND VNB sky130_fd_pr__nfet_01v8 m=16 w=0.65u l=0.15u mult=1 sa=0.265
+ sb=0.265 sd=0.28 area=0.063 perim=1.14
MMIP4 X Abbb net59 VNB sky130_fd_pr__pfet_01v8_hvt m=16 w=1.0u l=0.15u mult=1 sa=0.265
+ sb=0.265 sd=0.28 area=0.063 perim=1.14
MMIP1 Ab A net59 VNB sky130_fd_pr__pfet_01v8_hvt m=1 w=1.0u l=0.15u mult=1 sa=0.265
+ sb=0.265 sd=0.28 area=0.063 perim=1.14
MMIP2 Abb Ab net59 VNB sky130_fd_pr__pfet_01v8_hvt m=3 w=1.0u l=0.15u mult=1 sa=0.265
+ sb=0.265 sd=0.28 area=0.063 perim=1.14
MI5 Abbb Abb net59 VNB sky130_fd_pr__pfet_01v8_hvt m=6 w=1.0u l=0.15u mult=1 sa=0.265
+ sb=0.265 sd=0.28 area=0.063 perim=1.14
.ENDS sky130_fd_sc_hd__bufbuf_16
* Copyright 2020 The SkyWater PDK Authors
*
* Licensed under the Apache License, Version 2.0 (the "License");
* you may not use this file except in compliance with the License.
* You may obtain a copy of the License at
*
*     https:  www.apache.org licenses LICENSE-2.0
*
* Unless required by applicable law or agreed to in writing, software
* distributed under the License is distributed on an "AS IS" BASIS,
* WITHOUT WARRANTIES OR CONDITIONS OF ANY KIND, either express or implied.
* See the License for the specific language governing permissions and
* limitations under the License.
*
* SPDX-License-Identifier: Apache-2.0

.SUBCKT sky130_fd_sc_hd__bufbuf_8 A VGND VNB VNB net59 X
*.PININFO A:I VGND:I VNB:I VNB:I net59:I X:O
MMIN1 Ab A VGND VNB sky130_fd_pr__nfet_01v8 m=1 w=0.42u l=0.15u mult=1 sa=0.265
+ sb=0.265 sd=0.28 area=0.063 perim=1.14
MMIN2 Abb Ab VGND VNB sky130_fd_pr__nfet_01v8 m=1 w=0.65u l=0.15u mult=1 sa=0.265
+ sb=0.265 sd=0.28 area=0.063 perim=1.14
MMIN3 Abbb Abb VGND VNB sky130_fd_pr__nfet_01v8 m=3 w=0.65u l=0.15u mult=1 sa=0.265
+ sb=0.265 sd=0.28 area=0.063 perim=1.14
MMIN4 X Abbb VGND VNB sky130_fd_pr__nfet_01v8 m=8 w=0.65u l=0.15u mult=1 sa=0.265
+ sb=0.265 sd=0.28 area=0.063 perim=1.14
MMIP4 X Abbb net59 VNB sky130_fd_pr__pfet_01v8_hvt m=8 w=1.0u l=0.15u mult=1 sa=0.265
+ sb=0.265 sd=0.28 area=0.063 perim=1.14
MMIP1 Ab A net59 VNB sky130_fd_pr__pfet_01v8_hvt m=1 w=0.64u l=0.15u mult=1 sa=0.265
+ sb=0.265 sd=0.28 area=0.063 perim=1.14
MMIP2 Abb Ab net59 VNB sky130_fd_pr__pfet_01v8_hvt m=1 w=1.0u l=0.15u mult=1 sa=0.265
+ sb=0.265 sd=0.28 area=0.063 perim=1.14
MI5 Abbb Abb net59 VNB sky130_fd_pr__pfet_01v8_hvt m=3 w=1.0u l=0.15u mult=1 sa=0.265
+ sb=0.265 sd=0.28 area=0.063 perim=1.14
.ENDS sky130_fd_sc_hd__bufbuf_8
* Copyright 2020 The SkyWater PDK Authors
*
* Licensed under the Apache License, Version 2.0 (the "License");
* you may not use this file except in compliance with the License.
* You may obtain a copy of the License at
*
*     https:  www.apache.org licenses LICENSE-2.0
*
* Unless required by applicable law or agreed to in writing, software
* distributed under the License is distributed on an "AS IS" BASIS,
* WITHOUT WARRANTIES OR CONDITIONS OF ANY KIND, either express or implied.
* See the License for the specific language governing permissions and
* limitations under the License.
*
* SPDX-License-Identifier: Apache-2.0

.SUBCKT sky130_fd_sc_hd__bufinv_16 A VGND VNB VNB net59 Y
*.PININFO A:I VGND:I VNB:I VNB:I net59:I Y:O
MMIN1 Ab A VGND VNB sky130_fd_pr__nfet_01v8 m=3 w=0.65u l=0.15u mult=1 sa=0.265
+ sb=0.265 sd=0.28 area=0.063 perim=1.14
MMIN2 Abb Ab VGND VNB sky130_fd_pr__nfet_01v8 m=6 w=0.65u l=0.15u mult=1 sa=0.265
+ sb=0.265 sd=0.28 area=0.063 perim=1.14
MMIN3 Y Abb VGND VNB sky130_fd_pr__nfet_01v8 m=16 w=0.65u l=0.15u mult=1 sa=0.265
+ sb=0.265 sd=0.28 area=0.063 perim=1.14
MMIP1 Ab A net59 VNB sky130_fd_pr__pfet_01v8_hvt m=3 w=1.0u l=0.15u mult=1 sa=0.265
+ sb=0.265 sd=0.28 area=0.063 perim=1.14
MMIP2 Abb Ab net59 VNB sky130_fd_pr__pfet_01v8_hvt m=6 w=1.0u l=0.15u mult=1 sa=0.265
+ sb=0.265 sd=0.28 area=0.063 perim=1.14
MMIP3 Y Abb net59 VNB sky130_fd_pr__pfet_01v8_hvt m=16 w=1.0u l=0.15u mult=1 sa=0.265
+ sb=0.265 sd=0.28 area=0.063 perim=1.14
.ENDS sky130_fd_sc_hd__bufinv_16
* Copyright 2020 The SkyWater PDK Authors
*
* Licensed under the Apache License, Version 2.0 (the "License");
* you may not use this file except in compliance with the License.
* You may obtain a copy of the License at
*
*     https:  www.apache.org licenses LICENSE-2.0
*
* Unless required by applicable law or agreed to in writing, software
* distributed under the License is distributed on an "AS IS" BASIS,
* WITHOUT WARRANTIES OR CONDITIONS OF ANY KIND, either express or implied.
* See the License for the specific language governing permissions and
* limitations under the License.
*
* SPDX-License-Identifier: Apache-2.0

.SUBCKT sky130_fd_sc_hd__bufinv_8 A VGND VNB VNB net59 Y
*.PININFO A:I VGND:I VNB:I VNB:I net59:I Y:O
MMIN1 Ab A VGND VNB sky130_fd_pr__nfet_01v8 m=1 w=0.65u l=0.15u mult=1 sa=0.265
+ sb=0.265 sd=0.28 area=0.063 perim=1.14
MMIN2 Abb Ab VGND VNB sky130_fd_pr__nfet_01v8 m=3 w=0.65u l=0.15u mult=1 sa=0.265
+ sb=0.265 sd=0.28 area=0.063 perim=1.14
MMIN3 Y Abb VGND VNB sky130_fd_pr__nfet_01v8 m=8 w=0.65u l=0.15u mult=1 sa=0.265
+ sb=0.265 sd=0.28 area=0.063 perim=1.14
MMIP1 Ab A net59 VNB sky130_fd_pr__pfet_01v8_hvt m=1 w=1.0u l=0.15u mult=1 sa=0.265
+ sb=0.265 sd=0.28 area=0.063 perim=1.14
MMIP2 Abb Ab net59 VNB sky130_fd_pr__pfet_01v8_hvt m=3 w=1.0u l=0.15u mult=1 sa=0.265
+ sb=0.265 sd=0.28 area=0.063 perim=1.14
MMIP3 Y Abb net59 VNB sky130_fd_pr__pfet_01v8_hvt m=8 w=1.0u l=0.15u mult=1 sa=0.265
+ sb=0.265 sd=0.28 area=0.063 perim=1.14
.ENDS sky130_fd_sc_hd__bufinv_8
* Copyright 2020 The SkyWater PDK Authors
*
* Licensed under the Apache License, Version 2.0 (the "License");
* you may not use this file except in compliance with the License.
* You may obtain a copy of the License at
*
*     https:  www.apache.org licenses LICENSE-2.0
*
* Unless required by applicable law or agreed to in writing, software
* distributed under the License is distributed on an "AS IS" BASIS,
* WITHOUT WARRANTIES OR CONDITIONS OF ANY KIND, either express or implied.
* See the License for the specific language governing permissions and
* limitations under the License.
*
* SPDX-License-Identifier: Apache-2.0

.SUBCKT sky130_fd_sc_hd__clkbuf_1 A VGND VNB VNB net59 X
*.PININFO A:I VGND:I VNB:I VNB:I net59:I X:O
MMIN0 Ab A VGND VNB sky130_fd_pr__nfet_01v8 m=1 w=0.52u l=0.15u mult=1 sa=0.265
+ sb=0.265 sd=0.28 area=0.063 perim=1.14
MMIN1 X Ab VGND VNB sky130_fd_pr__nfet_01v8 m=1 w=0.52u l=0.15u mult=1 sa=0.265
+ sb=0.265 sd=0.28 area=0.063 perim=1.14
MMIP0 Ab A net59 VNB sky130_fd_pr__pfet_01v8_hvt m=1 w=0.79u l=0.15u mult=1 sa=0.265
+ sb=0.265 sd=0.28 area=0.063 perim=1.14
MMIP1 X Ab net59 VNB sky130_fd_pr__pfet_01v8_hvt m=1 w=0.79u l=0.15u mult=1 sa=0.265
+ sb=0.265 sd=0.28 area=0.063 perim=1.14
.ENDS sky130_fd_sc_hd__clkbuf_1
* Copyright 2020 The SkyWater PDK Authors
*
* Licensed under the Apache License, Version 2.0 (the "License");
* you may not use this file except in compliance with the License.
* You may obtain a copy of the License at
*
*     https:  www.apache.org licenses LICENSE-2.0
*
* Unless required by applicable law or agreed to in writing, software
* distributed under the License is distributed on an "AS IS" BASIS,
* WITHOUT WARRANTIES OR CONDITIONS OF ANY KIND, either express or implied.
* See the License for the specific language governing permissions and
* limitations under the License.
*
* SPDX-License-Identifier: Apache-2.0

.SUBCKT sky130_fd_sc_hd__clkbuf_16 A VGND VNB VNB net59 X
*.PININFO A:I VGND:I VNB:I VNB:I net59:I X:O
MMIN0 Ab A VGND VNB sky130_fd_pr__nfet_01v8 m=4 w=0.42u l=0.15u mult=1 sa=0.265
+ sb=0.265 sd=0.28 area=0.063 perim=1.14
MMIN1 X Ab VGND VNB sky130_fd_pr__nfet_01v8 m=16 w=0.42u l=0.15u mult=1 sa=0.265
+ sb=0.265 sd=0.28 area=0.063 perim=1.14
MMIP0 Ab A net59 VNB sky130_fd_pr__pfet_01v8_hvt m=4 w=1.0u l=0.15u mult=1 sa=0.265
+ sb=0.265 sd=0.28 area=0.063 perim=1.14
MMIP1 X Ab net59 VNB sky130_fd_pr__pfet_01v8_hvt m=16 w=1.0u l=0.15u mult=1 sa=0.265
+ sb=0.265 sd=0.28 area=0.063 perim=1.14
.ENDS sky130_fd_sc_hd__clkbuf_16
* Copyright 2020 The SkyWater PDK Authors
*
* Licensed under the Apache License, Version 2.0 (the "License");
* you may not use this file except in compliance with the License.
* You may obtain a copy of the License at
*
*     https:  www.apache.org licenses LICENSE-2.0
*
* Unless required by applicable law or agreed to in writing, software
* distributed under the License is distributed on an "AS IS" BASIS,
* WITHOUT WARRANTIES OR CONDITIONS OF ANY KIND, either express or implied.
* See the License for the specific language governing permissions and
* limitations under the License.
*
* SPDX-License-Identifier: Apache-2.0

.SUBCKT sky130_fd_sc_hd__clkbuf_2 A VGND VNB VNB net59 X
*.PININFO A:I VGND:I VNB:I VNB:I net59:I X:O
MMIN0 Ab A VGND VNB sky130_fd_pr__nfet_01v8 m=1 w=0.42u l=0.15u mult=1 sa=0.265
+ sb=0.265 sd=0.28 area=0.063 perim=1.14
MMIN1 X Ab VGND VNB sky130_fd_pr__nfet_01v8 m=2 w=0.42u l=0.15u mult=1 sa=0.265
+ sb=0.265 sd=0.28 area=0.063 perim=1.14
MMIP0 Ab A net59 VNB sky130_fd_pr__pfet_01v8_hvt m=1 w=1.0u l=0.15u mult=1 sa=0.265
+ sb=0.265 sd=0.28 area=0.063 perim=1.14
MMIP1 X Ab net59 VNB sky130_fd_pr__pfet_01v8_hvt m=2 w=1.0u l=0.15u mult=1 sa=0.265
+ sb=0.265 sd=0.28 area=0.063 perim=1.14
.ENDS sky130_fd_sc_hd__clkbuf_2
* Copyright 2020 The SkyWater PDK Authors
*
* Licensed under the Apache License, Version 2.0 (the "License");
* you may not use this file except in compliance with the License.
* You may obtain a copy of the License at
*
*     https:  www.apache.org licenses LICENSE-2.0
*
* Unless required by applicable law or agreed to in writing, software
* distributed under the License is distributed on an "AS IS" BASIS,
* WITHOUT WARRANTIES OR CONDITIONS OF ANY KIND, either express or implied.
* See the License for the specific language governing permissions and
* limitations under the License.
*
* SPDX-License-Identifier: Apache-2.0

.SUBCKT sky130_fd_sc_hd__clkbuf_4 A VGND VNB VNB net59 X
*.PININFO A:I VGND:I VNB:I VNB:I net59:I X:O
MMIN0 Ab A VGND VNB sky130_fd_pr__nfet_01v8 m=1 w=0.42u l=0.15u mult=1 sa=0.265
+ sb=0.265 sd=0.28 area=0.063 perim=1.14
MMIN1 X Ab VGND VNB sky130_fd_pr__nfet_01v8 m=4 w=0.42u l=0.15u mult=1 sa=0.265
+ sb=0.265 sd=0.28 area=0.063 perim=1.14
MMIP0 Ab A net59 VNB sky130_fd_pr__pfet_01v8_hvt m=1 w=1.0u l=0.15u mult=1 sa=0.265
+ sb=0.265 sd=0.28 area=0.063 perim=1.14
MMIP1 X Ab net59 VNB sky130_fd_pr__pfet_01v8_hvt m=4 w=1.0u l=0.15u mult=1 sa=0.265
+ sb=0.265 sd=0.28 area=0.063 perim=1.14
.ENDS sky130_fd_sc_hd__clkbuf_4
* Copyright 2020 The SkyWater PDK Authors
*
* Licensed under the Apache License, Version 2.0 (the "License");
* you may not use this file except in compliance with the License.
* You may obtain a copy of the License at
*
*     https:  www.apache.org licenses LICENSE-2.0
*
* Unless required by applicable law or agreed to in writing, software
* distributed under the License is distributed on an "AS IS" BASIS,
* WITHOUT WARRANTIES OR CONDITIONS OF ANY KIND, either express or implied.
* See the License for the specific language governing permissions and
* limitations under the License.
*
* SPDX-License-Identifier: Apache-2.0

.SUBCKT sky130_fd_sc_hd__clkbuf_8 A VGND VNB VNB net59 X
*.PININFO A:I VGND:I VNB:I VNB:I net59:I X:O
MMIN0 Ab A VGND VNB sky130_fd_pr__nfet_01v8 m=2 w=0.42u l=0.15u mult=1 sa=0.265
+ sb=0.265 sd=0.28 area=0.063 perim=1.14
MMIN1 X Ab VGND VNB sky130_fd_pr__nfet_01v8 m=8 w=0.42u l=0.15u mult=1 sa=0.265
+ sb=0.265 sd=0.28 area=0.063 perim=1.14
MMIP0 Ab A net59 VNB sky130_fd_pr__pfet_01v8_hvt m=2 w=1.0u l=0.15u mult=1 sa=0.265
+ sb=0.265 sd=0.28 area=0.063 perim=1.14
MMIP1 X Ab net59 VNB sky130_fd_pr__pfet_01v8_hvt m=8 w=1.0u l=0.15u mult=1 sa=0.265
+ sb=0.265 sd=0.28 area=0.063 perim=1.14
.ENDS sky130_fd_sc_hd__clkbuf_8
* Copyright 2020 The SkyWater PDK Authors
*
* Licensed under the Apache License, Version 2.0 (the "License");
* you may not use this file except in compliance with the License.
* You may obtain a copy of the License at
*
*     https:  www.apache.org licenses LICENSE-2.0
*
* Unless required by applicable law or agreed to in writing, software
* distributed under the License is distributed on an "AS IS" BASIS,
* WITHOUT WARRANTIES OR CONDITIONS OF ANY KIND, either express or implied.
* See the License for the specific language governing permissions and
* limitations under the License.
*
* SPDX-License-Identifier: Apache-2.0

.SUBCKT sky130_fd_sc_hd__clkdlybuf4s15_1 A VGND VNB VNB net59 X
*.PININFO A:I VGND:I VNB:I VNB:I net59:I X:O
MMIN1 Ab A VGND VNB sky130_fd_pr__nfet_01v8 m=1 w=0.42u l=0.15u mult=1 sa=0.265
+ sb=0.265 sd=0.28 area=0.063 perim=1.14
MMIN2 A2 Ab VGND VNB sky130_fd_pr__nfet_01v8 m=1 w=0.65u l=0.15u mult=1 sa=0.265
+ sb=0.265 sd=0.28 area=0.063 perim=1.14
MI5 Ab2 A2 VGND VNB sky130_fd_pr__nfet_01v8 m=1 w=0.65u l=0.15u mult=1 sa=0.265
+ sb=0.265 sd=0.28 area=0.063 perim=1.14
MI4 X Ab2 VGND VNB sky130_fd_pr__nfet_01v8 m=1 w=0.42u l=0.15u mult=1 sa=0.265
+ sb=0.265 sd=0.28 area=0.063 perim=1.14
MMIP1 Ab A net59 VNB sky130_fd_pr__pfet_01v8_hvt m=1 w=1.0u l=0.15u mult=1 sa=0.265
+ sb=0.265 sd=0.28 area=0.063 perim=1.14
MMIP2 A2 Ab net59 VNB sky130_fd_pr__pfet_01v8_hvt m=1 w=0.82u l=0.15u mult=1 sa=0.265
+ sb=0.265 sd=0.28 area=0.063 perim=1.14
MI7 Ab2 A2 net59 VNB sky130_fd_pr__pfet_01v8_hvt m=1 w=0.82u l=0.15u mult=1 sa=0.265
+ sb=0.265 sd=0.28 area=0.063 perim=1.14
MI6 X Ab2 net59 VNB sky130_fd_pr__pfet_01v8_hvt m=1 w=1.0u l=0.15u mult=1 sa=0.265
+ sb=0.265 sd=0.28 area=0.063 perim=1.14
.ENDS sky130_fd_sc_hd__clkdlybuf4s15_1
* Copyright 2020 The SkyWater PDK Authors
*
* Licensed under the Apache License, Version 2.0 (the "License");
* you may not use this file except in compliance with the License.
* You may obtain a copy of the License at
*
*     https:  www.apache.org licenses LICENSE-2.0
*
* Unless required by applicable law or agreed to in writing, software
* distributed under the License is distributed on an "AS IS" BASIS,
* WITHOUT WARRANTIES OR CONDITIONS OF ANY KIND, either express or implied.
* See the License for the specific language governing permissions and
* limitations under the License.
*
* SPDX-License-Identifier: Apache-2.0

.SUBCKT sky130_fd_sc_hd__clkdlybuf4s15_2 A VGND VNB VNB net59 X
*.PININFO A:I VGND:I VNB:I VNB:I net59:I X:O
MMIN1 Ab A VGND VNB sky130_fd_pr__nfet_01v8 m=1 w=0.42u l=0.15u mult=1 sa=0.265
+ sb=0.265 sd=0.28 area=0.063 perim=1.14
MMIN2 A2 Ab VGND VNB sky130_fd_pr__nfet_01v8 m=1 w=0.65u l=0.15u mult=1 sa=0.265
+ sb=0.265 sd=0.28 area=0.063 perim=1.14
MI5 Ab2 A2 VGND VNB sky130_fd_pr__nfet_01v8 m=1 w=0.65u l=0.15u mult=1 sa=0.265
+ sb=0.265 sd=0.28 area=0.063 perim=1.14
MI4 X Ab2 VGND VNB sky130_fd_pr__nfet_01v8 m=2 w=0.42u l=0.15u mult=1 sa=0.265
+ sb=0.265 sd=0.28 area=0.063 perim=1.14
MMIP1 Ab A net59 VNB sky130_fd_pr__pfet_01v8_hvt m=1 w=1.0u l=0.15u mult=1 sa=0.265
+ sb=0.265 sd=0.28 area=0.063 perim=1.14
MMIP2 A2 Ab net59 VNB sky130_fd_pr__pfet_01v8_hvt m=1 w=0.82u l=0.15u mult=1 sa=0.265
+ sb=0.265 sd=0.28 area=0.063 perim=1.14
MI7 Ab2 A2 net59 VNB sky130_fd_pr__pfet_01v8_hvt m=1 w=0.82u l=0.15u mult=1 sa=0.265
+ sb=0.265 sd=0.28 area=0.063 perim=1.14
MI6 X Ab2 net59 VNB sky130_fd_pr__pfet_01v8_hvt m=2 w=1.0u l=0.15u mult=1 sa=0.265
+ sb=0.265 sd=0.28 area=0.063 perim=1.14
.ENDS sky130_fd_sc_hd__clkdlybuf4s15_2
* Copyright 2020 The SkyWater PDK Authors
*
* Licensed under the Apache License, Version 2.0 (the "License");
* you may not use this file except in compliance with the License.
* You may obtain a copy of the License at
*
*     https:  www.apache.org licenses LICENSE-2.0
*
* Unless required by applicable law or agreed to in writing, software
* distributed under the License is distributed on an "AS IS" BASIS,
* WITHOUT WARRANTIES OR CONDITIONS OF ANY KIND, either express or implied.
* See the License for the specific language governing permissions and
* limitations under the License.
*
* SPDX-License-Identifier: Apache-2.0

.SUBCKT sky130_fd_sc_hd__clkdlybuf4s18_1 A VGND VNB VNB net59 X
*.PININFO A:I VGND:I VNB:I VNB:I net59:I X:O
MMIN1 Ab A VGND VNB sky130_fd_pr__nfet_01v8 m=1 w=0.42u l=0.15u mult=1 sa=0.265
+ sb=0.265 sd=0.28 area=0.063 perim=1.14
MMIN2 A2 Ab VGND VNB sky130_fd_pr__nfet_01v8 m=1 w=0.65u l=0.18u mult=1 sa=0.265
+ sb=0.265 sd=0.28 area=0.063 perim=1.14
MI5 Ab2 A2 VGND VNB sky130_fd_pr__nfet_01v8 m=1 w=0.65u l=0.18u mult=1 sa=0.265
+ sb=0.265 sd=0.28 area=0.063 perim=1.14
MI4 X Ab2 VGND VNB sky130_fd_pr__nfet_01v8 m=1 w=0.42u l=0.15u mult=1 sa=0.265
+ sb=0.265 sd=0.28 area=0.063 perim=1.14
MMIP1 Ab A net59 VNB sky130_fd_pr__pfet_01v8_hvt m=1 w=1.0u l=0.15u mult=1 sa=0.265
+ sb=0.265 sd=0.28 area=0.063 perim=1.14
MMIP2 A2 Ab net59 VNB sky130_fd_pr__pfet_01v8_hvt m=1 w=0.82u l=0.18u mult=1 sa=0.265
+ sb=0.265 sd=0.28 area=0.063 perim=1.14
MI7 Ab2 A2 net59 VNB sky130_fd_pr__pfet_01v8_hvt m=1 w=0.82u l=0.18u mult=1 sa=0.265
+ sb=0.265 sd=0.28 area=0.063 perim=1.14
MI6 X Ab2 net59 VNB sky130_fd_pr__pfet_01v8_hvt m=1 w=1.0u l=0.15u mult=1 sa=0.265
+ sb=0.265 sd=0.28 area=0.063 perim=1.14
.ENDS sky130_fd_sc_hd__clkdlybuf4s18_1
* Copyright 2020 The SkyWater PDK Authors
*
* Licensed under the Apache License, Version 2.0 (the "License");
* you may not use this file except in compliance with the License.
* You may obtain a copy of the License at
*
*     https:  www.apache.org licenses LICENSE-2.0
*
* Unless required by applicable law or agreed to in writing, software
* distributed under the License is distributed on an "AS IS" BASIS,
* WITHOUT WARRANTIES OR CONDITIONS OF ANY KIND, either express or implied.
* See the License for the specific language governing permissions and
* limitations under the License.
*
* SPDX-License-Identifier: Apache-2.0

.SUBCKT sky130_fd_sc_hd__clkdlybuf4s18_2 A VGND VNB VNB net59 X
*.PININFO A:I VGND:I VNB:I VNB:I net59:I X:O
MMIN1 Ab A VGND VNB sky130_fd_pr__nfet_01v8 m=1 w=0.42u l=0.15u mult=1 sa=0.265
+ sb=0.265 sd=0.28 area=0.063 perim=1.14
MMIN2 A2 Ab VGND VNB sky130_fd_pr__nfet_01v8 m=1 w=0.65u l=0.18u mult=1 sa=0.265
+ sb=0.265 sd=0.28 area=0.063 perim=1.14
MI5 Ab2 A2 VGND VNB sky130_fd_pr__nfet_01v8 m=1 w=0.65u l=0.18u mult=1 sa=0.265
+ sb=0.265 sd=0.28 area=0.063 perim=1.14
MI4 X Ab2 VGND VNB sky130_fd_pr__nfet_01v8 m=2 w=0.42u l=0.15u mult=1 sa=0.265
+ sb=0.265 sd=0.28 area=0.063 perim=1.14
MMIP1 Ab A net59 VNB sky130_fd_pr__pfet_01v8_hvt m=1 w=1.0u l=0.15u mult=1 sa=0.265
+ sb=0.265 sd=0.28 area=0.063 perim=1.14
MMIP2 A2 Ab net59 VNB sky130_fd_pr__pfet_01v8_hvt m=1 w=0.82u l=0.18u mult=1 sa=0.265
+ sb=0.265 sd=0.28 area=0.063 perim=1.14
MI7 Ab2 A2 net59 VNB sky130_fd_pr__pfet_01v8_hvt m=1 w=0.82u l=0.18u mult=1 sa=0.265
+ sb=0.265 sd=0.28 area=0.063 perim=1.14
MI6 X Ab2 net59 VNB sky130_fd_pr__pfet_01v8_hvt m=2 w=1.0u l=0.15u mult=1 sa=0.265
+ sb=0.265 sd=0.28 area=0.063 perim=1.14
.ENDS sky130_fd_sc_hd__clkdlybuf4s18_2
* Copyright 2020 The SkyWater PDK Authors
*
* Licensed under the Apache License, Version 2.0 (the "License");
* you may not use this file except in compliance with the License.
* You may obtain a copy of the License at
*
*     https:  www.apache.org licenses LICENSE-2.0
*
* Unless required by applicable law or agreed to in writing, software
* distributed under the License is distributed on an "AS IS" BASIS,
* WITHOUT WARRANTIES OR CONDITIONS OF ANY KIND, either express or implied.
* See the License for the specific language governing permissions and
* limitations under the License.
*
* SPDX-License-Identifier: Apache-2.0

.SUBCKT sky130_fd_sc_hd__clkdlybuf4s25_1 A VGND VNB VNB net59 X
*.PININFO A:I VGND:I VNB:I VNB:I net59:I X:O
MMIN1 Ab A VGND VNB sky130_fd_pr__nfet_01v8 m=1 w=0.42u l=0.15u mult=1 sa=0.265
+ sb=0.265 sd=0.28 area=0.063 perim=1.14
MMIN2 A2 Ab VGND VNB sky130_fd_pr__nfet_01v8 m=1 w=0.65u l=0.25u mult=1 sa=0.265
+ sb=0.265 sd=0.28 area=0.063 perim=1.14
MI5 Ab2 A2 VGND VNB sky130_fd_pr__nfet_01v8 m=1 w=0.65u l=0.25u mult=1 sa=0.265
+ sb=0.265 sd=0.28 area=0.063 perim=1.14
MI4 X Ab2 VGND VNB sky130_fd_pr__nfet_01v8 m=1 w=0.42u l=0.15u mult=1 sa=0.265
+ sb=0.265 sd=0.28 area=0.063 perim=1.14
MMIP1 Ab A net59 VNB sky130_fd_pr__pfet_01v8_hvt m=1 w=1.0u l=0.15u mult=1 sa=0.265
+ sb=0.265 sd=0.28 area=0.063 perim=1.14
MMIP2 A2 Ab net59 VNB sky130_fd_pr__pfet_01v8_hvt m=1 w=0.82u l=0.25u mult=1 sa=0.265
+ sb=0.265 sd=0.28 area=0.063 perim=1.14
MI7 Ab2 A2 net59 VNB sky130_fd_pr__pfet_01v8_hvt m=1 w=0.82u l=0.25u mult=1 sa=0.265
+ sb=0.265 sd=0.28 area=0.063 perim=1.14
MI6 X Ab2 net59 VNB sky130_fd_pr__pfet_01v8_hvt m=1 w=1.0u l=0.15u mult=1 sa=0.265
+ sb=0.265 sd=0.28 area=0.063 perim=1.14
.ENDS sky130_fd_sc_hd__clkdlybuf4s25_1
* Copyright 2020 The SkyWater PDK Authors
*
* Licensed under the Apache License, Version 2.0 (the "License");
* you may not use this file except in compliance with the License.
* You may obtain a copy of the License at
*
*     https:  www.apache.org licenses LICENSE-2.0
*
* Unless required by applicable law or agreed to in writing, software
* distributed under the License is distributed on an "AS IS" BASIS,
* WITHOUT WARRANTIES OR CONDITIONS OF ANY KIND, either express or implied.
* See the License for the specific language governing permissions and
* limitations under the License.
*
* SPDX-License-Identifier: Apache-2.0

.SUBCKT sky130_fd_sc_hd__clkdlybuf4s25_2 A VGND VNB VNB net59 X
*.PININFO A:I VGND:I VNB:I VNB:I net59:I X:O
MMIN1 Ab A VGND VNB sky130_fd_pr__nfet_01v8 m=1 w=0.42u l=0.15u mult=1 sa=0.265
+ sb=0.265 sd=0.28 area=0.063 perim=1.14
MMIN2 A2 Ab VGND VNB sky130_fd_pr__nfet_01v8 m=1 w=0.65u l=0.25u mult=1 sa=0.265
+ sb=0.265 sd=0.28 area=0.063 perim=1.14
MI5 Ab2 A2 VGND VNB sky130_fd_pr__nfet_01v8 m=1 w=0.65u l=0.25u mult=1 sa=0.265
+ sb=0.265 sd=0.28 area=0.063 perim=1.14
MI4 X Ab2 VGND VNB sky130_fd_pr__nfet_01v8 m=2 w=0.42u l=0.15u mult=1 sa=0.265
+ sb=0.265 sd=0.28 area=0.063 perim=1.14
MMIP1 Ab A net59 VNB sky130_fd_pr__pfet_01v8_hvt m=1 w=1.0u l=0.15u mult=1 sa=0.265
+ sb=0.265 sd=0.28 area=0.063 perim=1.14
MMIP2 A2 Ab net59 VNB sky130_fd_pr__pfet_01v8_hvt m=1 w=0.82u l=0.25u mult=1 sa=0.265
+ sb=0.265 sd=0.28 area=0.063 perim=1.14
MI7 Ab2 A2 net59 VNB sky130_fd_pr__pfet_01v8_hvt m=1 w=0.82u l=0.25u mult=1 sa=0.265
+ sb=0.265 sd=0.28 area=0.063 perim=1.14
MI6 X Ab2 net59 VNB sky130_fd_pr__pfet_01v8_hvt m=2 w=1.0u l=0.15u mult=1 sa=0.265
+ sb=0.265 sd=0.28 area=0.063 perim=1.14
.ENDS sky130_fd_sc_hd__clkdlybuf4s25_2
* Copyright 2020 The SkyWater PDK Authors
*
* Licensed under the Apache License, Version 2.0 (the "License");
* you may not use this file except in compliance with the License.
* You may obtain a copy of the License at
*
*     https:  www.apache.org licenses LICENSE-2.0
*
* Unless required by applicable law or agreed to in writing, software
* distributed under the License is distributed on an "AS IS" BASIS,
* WITHOUT WARRANTIES OR CONDITIONS OF ANY KIND, either express or implied.
* See the License for the specific language governing permissions and
* limitations under the License.
*
* SPDX-License-Identifier: Apache-2.0

.SUBCKT sky130_fd_sc_hd__clkdlybuf4s50_1 A VGND VNB VNB net59 X
*.PININFO A:I VGND:I VNB:I VNB:I net59:I X:O
MMIN1 Ab A VGND VNB sky130_fd_pr__nfet_01v8 m=1 w=0.42u l=0.15u mult=1 sa=0.265
+ sb=0.265 sd=0.28 area=0.063 perim=1.14
MMIN2 A2 Ab VGND VNB sky130_fd_pr__nfet_01v8 m=1 w=0.65u l=0.5u mult=1 sa=0.265
+ sb=0.265 sd=0.28 area=0.063 perim=1.14
MI5 Ab2 A2 VGND VNB sky130_fd_pr__nfet_01v8 m=1 w=0.65u l=0.5u mult=1 sa=0.265
+ sb=0.265 sd=0.28 area=0.063 perim=1.14
MI4 X Ab2 VGND VNB sky130_fd_pr__nfet_01v8 m=1 w=0.42u l=0.15u mult=1 sa=0.265
+ sb=0.265 sd=0.28 area=0.063 perim=1.14
MMIP1 Ab A net59 VNB sky130_fd_pr__pfet_01v8_hvt m=1 w=1.0u l=0.15u mult=1 sa=0.265
+ sb=0.265 sd=0.28 area=0.063 perim=1.14
MMIP2 A2 Ab net59 VNB sky130_fd_pr__pfet_01v8_hvt m=1 w=0.82u l=0.5u mult=1 sa=0.265
+ sb=0.265 sd=0.28 area=0.063 perim=1.14
MI7 Ab2 A2 net59 VNB sky130_fd_pr__pfet_01v8_hvt m=1 w=0.82u l=0.5u mult=1 sa=0.265
+ sb=0.265 sd=0.28 area=0.063 perim=1.14
MI6 X Ab2 net59 VNB sky130_fd_pr__pfet_01v8_hvt m=1 w=1.0u l=0.15u mult=1 sa=0.265
+ sb=0.265 sd=0.28 area=0.063 perim=1.14
.ENDS sky130_fd_sc_hd__clkdlybuf4s50_1
* Copyright 2020 The SkyWater PDK Authors
*
* Licensed under the Apache License, Version 2.0 (the "License");
* you may not use this file except in compliance with the License.
* You may obtain a copy of the License at
*
*     https:  www.apache.org licenses LICENSE-2.0
*
* Unless required by applicable law or agreed to in writing, software
* distributed under the License is distributed on an "AS IS" BASIS,
* WITHOUT WARRANTIES OR CONDITIONS OF ANY KIND, either express or implied.
* See the License for the specific language governing permissions and
* limitations under the License.
*
* SPDX-License-Identifier: Apache-2.0

.SUBCKT sky130_fd_sc_hd__clkdlybuf4s50_2 A VGND VNB VNB net59 X
*.PININFO A:I VGND:I VNB:I VNB:I net59:I X:O
MMIN1 Ab A VGND VNB sky130_fd_pr__nfet_01v8 m=1 w=0.42u l=0.15u mult=1 sa=0.265
+ sb=0.265 sd=0.28 area=0.063 perim=1.14
MMIN2 A2 Ab VGND VNB sky130_fd_pr__nfet_01v8 m=1 w=0.65u l=0.5u mult=1 sa=0.265
+ sb=0.265 sd=0.28 area=0.063 perim=1.14
MI5 Ab2 A2 VGND VNB sky130_fd_pr__nfet_01v8 m=1 w=0.65u l=0.5u mult=1 sa=0.265
+ sb=0.265 sd=0.28 area=0.063 perim=1.14
MI4 X Ab2 VGND VNB sky130_fd_pr__nfet_01v8 m=2 w=0.42u l=0.15u mult=1 sa=0.265
+ sb=0.265 sd=0.28 area=0.063 perim=1.14
MMIP1 Ab A net59 VNB sky130_fd_pr__pfet_01v8_hvt m=1 w=1.0u l=0.15u mult=1 sa=0.265
+ sb=0.265 sd=0.28 area=0.063 perim=1.14
MMIP2 A2 Ab net59 VNB sky130_fd_pr__pfet_01v8_hvt m=1 w=0.82u l=0.5u mult=1 sa=0.265
+ sb=0.265 sd=0.28 area=0.063 perim=1.14
MI7 Ab2 A2 net59 VNB sky130_fd_pr__pfet_01v8_hvt m=1 w=0.82u l=0.5u mult=1 sa=0.265
+ sb=0.265 sd=0.28 area=0.063 perim=1.14
MI6 X Ab2 net59 VNB sky130_fd_pr__pfet_01v8_hvt m=2 w=1.0u l=0.15u mult=1 sa=0.265
+ sb=0.265 sd=0.28 area=0.063 perim=1.14
.ENDS sky130_fd_sc_hd__clkdlybuf4s50_2
* Copyright 2020 The SkyWater PDK Authors
*
* Licensed under the Apache License, Version 2.0 (the "License");
* you may not use this file except in compliance with the License.
* You may obtain a copy of the License at
*
*     https:  www.apache.org licenses LICENSE-2.0
*
* Unless required by applicable law or agreed to in writing, software
* distributed under the License is distributed on an "AS IS" BASIS,
* WITHOUT WARRANTIES OR CONDITIONS OF ANY KIND, either express or implied.
* See the License for the specific language governing permissions and
* limitations under the License.
*
* SPDX-License-Identifier: Apache-2.0

.SUBCKT sky130_fd_sc_hd__clkinv_1 A VGND VNB VNB net59 Y
*.PININFO A:I VGND:I VNB:I VNB:I net59:I Y:O
MMIN0 Y A VGND VNB sky130_fd_pr__nfet_01v8 m=1 w=0.42u l=0.15u mult=1 sa=0.265
+ sb=0.265 sd=0.28 area=0.063 perim=1.14
MMIP0 Y A net59 VNB sky130_fd_pr__pfet_01v8_hvt m=2 w=0.84u l=0.15u mult=1 sa=0.265
+ sb=0.265 sd=0.28 area=0.063 perim=1.14
.ENDS sky130_fd_sc_hd__clkinv_1
* Copyright 2020 The SkyWater PDK Authors
*
* Licensed under the Apache License, Version 2.0 (the "License");
* you may not use this file except in compliance with the License.
* You may obtain a copy of the License at
*
*     https:  www.apache.org licenses LICENSE-2.0
*
* Unless required by applicable law or agreed to in writing, software
* distributed under the License is distributed on an "AS IS" BASIS,
* WITHOUT WARRANTIES OR CONDITIONS OF ANY KIND, either express or implied.
* See the License for the specific language governing permissions and
* limitations under the License.
*
* SPDX-License-Identifier: Apache-2.0

.SUBCKT sky130_fd_sc_hd__clkinv_16 A VGND VNB VNB net59 Y
*.PININFO A:I VGND:I VNB:I VNB:I net59:I Y:O
MMIN0 Y A VGND VNB sky130_fd_pr__nfet_01v8 m=16 w=0.42u l=0.15u mult=1 sa=0.265
+ sb=0.265 sd=0.28 area=0.063 perim=1.14
MMIP0 Y A net59 VNB sky130_fd_pr__pfet_01v8_hvt m=24 w=1.0u l=0.15u mult=1 sa=0.265
+ sb=0.265 sd=0.28 area=0.063 perim=1.14
.ENDS sky130_fd_sc_hd__clkinv_16
* Copyright 2020 The SkyWater PDK Authors
*
* Licensed under the Apache License, Version 2.0 (the "License");
* you may not use this file except in compliance with the License.
* You may obtain a copy of the License at
*
*     https:  www.apache.org licenses LICENSE-2.0
*
* Unless required by applicable law or agreed to in writing, software
* distributed under the License is distributed on an "AS IS" BASIS,
* WITHOUT WARRANTIES OR CONDITIONS OF ANY KIND, either express or implied.
* See the License for the specific language governing permissions and
* limitations under the License.
*
* SPDX-License-Identifier: Apache-2.0

.SUBCKT sky130_fd_sc_hd__clkinv_2 A VGND VNB VNB net59 Y
*.PININFO A:I VGND:I VNB:I VNB:I net59:I Y:O
MMIN0 Y A VGND VNB sky130_fd_pr__nfet_01v8 m=2 w=0.42u l=0.15u mult=1 sa=0.265
+ sb=0.265 sd=0.28 area=0.063 perim=1.14
MMIP0 Y A net59 VNB sky130_fd_pr__pfet_01v8_hvt m=3 w=1.0u l=0.15u mult=1 sa=0.265
+ sb=0.265 sd=0.28 area=0.063 perim=1.14
.ENDS sky130_fd_sc_hd__clkinv_2
* Copyright 2020 The SkyWater PDK Authors
*
* Licensed under the Apache License, Version 2.0 (the "License");
* you may not use this file except in compliance with the License.
* You may obtain a copy of the License at
*
*     https:  www.apache.org licenses LICENSE-2.0
*
* Unless required by applicable law or agreed to in writing, software
* distributed under the License is distributed on an "AS IS" BASIS,
* WITHOUT WARRANTIES OR CONDITIONS OF ANY KIND, either express or implied.
* See the License for the specific language governing permissions and
* limitations under the License.
*
* SPDX-License-Identifier: Apache-2.0

.SUBCKT sky130_fd_sc_hd__clkinv_4 A VGND VNB VNB net59 Y
*.PININFO A:I VGND:I VNB:I VNB:I net59:I Y:O
MMIN0 Y A VGND VNB sky130_fd_pr__nfet_01v8 m=4 w=0.42u l=0.15u mult=1 sa=0.265
+ sb=0.265 sd=0.28 area=0.063 perim=1.14
MMIP0 Y A net59 VNB sky130_fd_pr__pfet_01v8_hvt m=6 w=1.0u l=0.15u mult=1 sa=0.265
+ sb=0.265 sd=0.28 area=0.063 perim=1.14
.ENDS sky130_fd_sc_hd__clkinv_4
* Copyright 2020 The SkyWater PDK Authors
*
* Licensed under the Apache License, Version 2.0 (the "License");
* you may not use this file except in compliance with the License.
* You may obtain a copy of the License at
*
*     https:  www.apache.org licenses LICENSE-2.0
*
* Unless required by applicable law or agreed to in writing, software
* distributed under the License is distributed on an "AS IS" BASIS,
* WITHOUT WARRANTIES OR CONDITIONS OF ANY KIND, either express or implied.
* See the License for the specific language governing permissions and
* limitations under the License.
*
* SPDX-License-Identifier: Apache-2.0

.SUBCKT sky130_fd_sc_hd__clkinv_8 A VGND VNB VNB net59 Y
*.PININFO A:I VGND:I VNB:I VNB:I net59:I Y:O
MMIN0 Y A VGND VNB sky130_fd_pr__nfet_01v8 m=8 w=0.42u l=0.15u mult=1 sa=0.265
+ sb=0.265 sd=0.28 area=0.063 perim=1.14
MMIP0 Y A net59 VNB sky130_fd_pr__pfet_01v8_hvt m=12 w=1.0u l=0.15u mult=1 sa=0.265
+ sb=0.265 sd=0.28 area=0.063 perim=1.14
.ENDS sky130_fd_sc_hd__clkinv_8
* Copyright 2020 The SkyWater PDK Authors
*
* Licensed under the Apache License, Version 2.0 (the "License");
* you may not use this file except in compliance with the License.
* You may obtain a copy of the License at
*
*     https:  www.apache.org licenses LICENSE-2.0
*
* Unless required by applicable law or agreed to in writing, software
* distributed under the License is distributed on an "AS IS" BASIS,
* WITHOUT WARRANTIES OR CONDITIONS OF ANY KIND, either express or implied.
* See the License for the specific language governing permissions and
* limitations under the License.
*
* SPDX-License-Identifier: Apache-2.0

.SUBCKT sky130_fd_sc_hd__clkinvlp_2 A VGND VNB VNB net59 Y
*.PININFO A:I VGND:I VNB:I VNB:I net59:I Y:O
MMIP0 Y A net59 VNB sky130_fd_pr__pfet_01v8_hvt m=2 w=1.0u l=0.25u mult=1 sa=0.265
+ sb=0.265 sd=0.28 area=0.063 perim=1.14
MI5 net36 A VGND VNB sky130_fd_pr__nfet_01v8 m=1 w=0.55u l=0.15u mult=1 sa=0.265
+ sb=0.265 sd=0.28 area=0.063 perim=1.14
MMIN0 Y A net36 VNB sky130_fd_pr__nfet_01v8 m=1 w=0.55u l=0.15u mult=1 sa=0.265
+ sb=0.265 sd=0.28 area=0.063 perim=1.14
.ENDS sky130_fd_sc_hd__clkinvlp_2
* Copyright 2020 The SkyWater PDK Authors
*
* Licensed under the Apache License, Version 2.0 (the "License");
* you may not use this file except in compliance with the License.
* You may obtain a copy of the License at
*
*     https:  www.apache.org licenses LICENSE-2.0
*
* Unless required by applicable law or agreed to in writing, software
* distributed under the License is distributed on an "AS IS" BASIS,
* WITHOUT WARRANTIES OR CONDITIONS OF ANY KIND, either express or implied.
* See the License for the specific language governing permissions and
* limitations under the License.
*
* SPDX-License-Identifier: Apache-2.0

.SUBCKT sky130_fd_sc_hd__clkinvlp_4 A VGND VNB VNB net59 Y
*.PININFO A:I VGND:I VNB:I VNB:I net59:I Y:O
MMIP0 Y A net59 VNB sky130_fd_pr__pfet_01v8_hvt m=4 w=1.0u l=0.25u mult=1 sa=0.265
+ sb=0.265 sd=0.28 area=0.063 perim=1.14
MMIN0 Y A net31 VNB sky130_fd_pr__nfet_01v8 m=1 w=0.55u l=0.15u mult=1 sa=0.265
+ sb=0.265 sd=0.28 area=0.063 perim=1.14
MI7 net35 A VGND VNB sky130_fd_pr__nfet_01v8 m=1 w=0.55u l=0.15u mult=1 sa=0.265
+ sb=0.265 sd=0.28 area=0.063 perim=1.14
MI6 net31 A VGND VNB sky130_fd_pr__nfet_01v8 m=1 w=0.55u l=0.15u mult=1 sa=0.265
+ sb=0.265 sd=0.28 area=0.063 perim=1.14
MI5 Y A net35 VNB sky130_fd_pr__nfet_01v8 m=1 w=0.55u l=0.15u mult=1 sa=0.265 sb=0.265
+ sd=0.28 area=0.063 perim=1.14
.ENDS sky130_fd_sc_hd__clkinvlp_4
* Copyright 2020 The SkyWater PDK Authors
*
* Licensed under the Apache License, Version 2.0 (the "License");
* you may not use this file except in compliance with the License.
* You may obtain a copy of the License at
*
*     https:  www.apache.org licenses LICENSE-2.0
*
* Unless required by applicable law or agreed to in writing, software
* distributed under the License is distributed on an "AS IS" BASIS,
* WITHOUT WARRANTIES OR CONDITIONS OF ANY KIND, either express or implied.
* See the License for the specific language governing permissions and
* limitations under the License.
*
* SPDX-License-Identifier: Apache-2.0

.SUBCKT sky130_fd_sc_hd__conb_1 VGND VNB VNB net59 HI LO
*.PININFO VGND:I VNB:I VNB:I net59:I HI:O LO:O
.connect  VGND LO
.connect  HI net59
.ENDS sky130_fd_sc_hd__conb_1
* Copyright 2020 The SkyWater PDK Authors
*
* Licensed under the Apache License, Version 2.0 (the "License");
* you may not use this file except in compliance with the License.
* You may obtain a copy of the License at
*
*     https:  www.apache.org licenses LICENSE-2.0
*
* Unless required by applicable law or agreed to in writing, software
* distributed under the License is distributed on an "AS IS" BASIS,
* WITHOUT WARRANTIES OR CONDITIONS OF ANY KIND, either express or implied.
* See the License for the specific language governing permissions and
* limitations under the License.
*
* SPDX-License-Identifier: Apache-2.0

.SUBCKT sky130_fd_sc_hd__decap_12 VGND VNB VNB net59
*.PININFO VGND:I VNB:I VNB:I net59:I
MI1 VGND net59 VGND VNB sky130_fd_pr__nfet_01v8 m=1 w=0.55u l=4.73u mult=1 sa=0.265
+ sb=0.265 sd=0.28 area=0.063 perim=1.14
MI2 net59 VGND net59 VNB sky130_fd_pr__pfet_01v8_hvt m=1 w=0.87u l=4.73u mult=1 sa=0.265
+ sb=0.265 sd=0.28 area=0.063 perim=1.14
.ENDS sky130_fd_sc_hd__decap_12
* Copyright 2020 The SkyWater PDK Authors
*
* Licensed under the Apache License, Version 2.0 (the "License");
* you may not use this file except in compliance with the License.
* You may obtain a copy of the License at
*
*     https:  www.apache.org licenses LICENSE-2.0
*
* Unless required by applicable law or agreed to in writing, software
* distributed under the License is distributed on an "AS IS" BASIS,
* WITHOUT WARRANTIES OR CONDITIONS OF ANY KIND, either express or implied.
* See the License for the specific language governing permissions and
* limitations under the License.
*
* SPDX-License-Identifier: Apache-2.0

.SUBCKT sky130_fd_sc_hd__decap_3 VGND VNB VNB net59
*.PININFO VGND:I VNB:I VNB:I net59:I
MI1 VGND net59 VGND VNB sky130_fd_pr__nfet_01v8 m=1 w=0.55u l=0.59u mult=1 sa=0.265
+ sb=0.265 sd=0.28 area=0.063 perim=1.14
MI2 net59 VGND net59 VNB sky130_fd_pr__pfet_01v8_hvt m=1 w=0.87u l=0.59u mult=1 sa=0.265
+ sb=0.265 sd=0.28 area=0.063 perim=1.14
.ENDS sky130_fd_sc_hd__decap_3
* Copyright 2020 The SkyWater PDK Authors
*
* Licensed under the Apache License, Version 2.0 (the "License");
* you may not use this file except in compliance with the License.
* You may obtain a copy of the License at
*
*     https:  www.apache.org licenses LICENSE-2.0
*
* Unless required by applicable law or agreed to in writing, software
* distributed under the License is distributed on an "AS IS" BASIS,
* WITHOUT WARRANTIES OR CONDITIONS OF ANY KIND, either express or implied.
* See the License for the specific language governing permissions and
* limitations under the License.
*
* SPDX-License-Identifier: Apache-2.0

.SUBCKT sky130_fd_sc_hd__decap_4 VGND VNB VNB net59
*.PININFO VGND:I VNB:I VNB:I net59:I
MI2 net59 VGND net59 VNB sky130_fd_pr__pfet_01v8_hvt m=1 w=0.87u l=1.05u mult=1 sa=0.265
+ sb=0.265 sd=0.28 area=0.063 perim=1.14
MI1 VGND net59 VGND VNB sky130_fd_pr__nfet_01v8 m=1 w=0.55u l=1.05u mult=1 sa=0.265
+ sb=0.265 sd=0.28 area=0.063 perim=1.14
.ENDS sky130_fd_sc_hd__decap_4
* Copyright 2020 The SkyWater PDK Authors
*
* Licensed under the Apache License, Version 2.0 (the "License");
* you may not use this file except in compliance with the License.
* You may obtain a copy of the License at
*
*     https:  www.apache.org licenses LICENSE-2.0
*
* Unless required by applicable law or agreed to in writing, software
* distributed under the License is distributed on an "AS IS" BASIS,
* WITHOUT WARRANTIES OR CONDITIONS OF ANY KIND, either express or implied.
* See the License for the specific language governing permissions and
* limitations under the License.
*
* SPDX-License-Identifier: Apache-2.0

.SUBCKT sky130_fd_sc_hd__decap_6 VGND VNB VNB net59
*.PININFO VGND:I VNB:I VNB:I net59:I
MI1 VGND net59 VGND VNB sky130_fd_pr__nfet_01v8 m=1 w=0.55u l=1.97u mult=1 sa=0.265
+ sb=0.265 sd=0.28 area=0.063 perim=1.14
MI2 net59 VGND net59 VNB sky130_fd_pr__pfet_01v8_hvt m=1 w=0.87u l=1.97u mult=1 sa=0.265
+ sb=0.265 sd=0.28 area=0.063 perim=1.14
.ENDS sky130_fd_sc_hd__decap_6
* Copyright 2020 The SkyWater PDK Authors
*
* Licensed under the Apache License, Version 2.0 (the "License");
* you may not use this file except in compliance with the License.
* You may obtain a copy of the License at
*
*     https:  www.apache.org licenses LICENSE-2.0
*
* Unless required by applicable law or agreed to in writing, software
* distributed under the License is distributed on an "AS IS" BASIS,
* WITHOUT WARRANTIES OR CONDITIONS OF ANY KIND, either express or implied.
* See the License for the specific language governing permissions and
* limitations under the License.
*
* SPDX-License-Identifier: Apache-2.0

.SUBCKT sky130_fd_sc_hd__decap_8 VGND VNB VNB net59
*.PININFO VGND:I VNB:I VNB:I net59:I
MI1 VGND net59 VGND VNB sky130_fd_pr__nfet_01v8 m=1 w=0.55u l=2.89u mult=1 sa=0.265
+ sb=0.265 sd=0.28 area=0.063 perim=1.14
MI2 net59 VGND net59 VNB sky130_fd_pr__pfet_01v8_hvt m=1 w=0.87u l=2.89u mult=1 sa=0.265
+ sb=0.265 sd=0.28 area=0.063 perim=1.14
.ENDS sky130_fd_sc_hd__decap_8
* Copyright 2020 The SkyWater PDK Authors
*
* Licensed under the Apache License, Version 2.0 (the "License");
* you may not use this file except in compliance with the License.
* You may obtain a copy of the License at
*
*     https:  www.apache.org licenses LICENSE-2.0
*
* Unless required by applicable law or agreed to in writing, software
* distributed under the License is distributed on an "AS IS" BASIS,
* WITHOUT WARRANTIES OR CONDITIONS OF ANY KIND, either express or implied.
* See the License for the specific language governing permissions and
* limitations under the License.
*
* SPDX-License-Identifier: Apache-2.0

.SUBCKT sky130_fd_sc_hd__dfbbn_1 CLK_N D RESET_B SET_B VGND VNB VNB net59 Q Q_N
*.PININFO CLK_N:I D:I RESET_B:I SET_B:I VGND:I VNB:I VNB:I net59:I Q:O
*.PININFO Q_N:O
MI46 clkneg clkpos VGND VNB sky130_fd_pr__nfet_01v8 m=1 w=0.42u l=0.15u mult=1
+ sa=0.265 sb=0.265 sd=0.28 area=0.063 perim=1.14
MI659 db D VGND VNB sky130_fd_pr__nfet_01v8 m=1 w=0.42u l=0.15u mult=1 sa=0.265
+ sb=0.265 sd=0.28 area=0.063 perim=1.14
MI642 RESET RESET_B VGND VNB sky130_fd_pr__nfet_01v8 m=1 w=0.42u l=0.15u mult=1
+ sa=0.265 sb=0.265 sd=0.28 area=0.063 perim=1.14
MI676 M1 M0 net141 VNB sky130_fd_pr__nfet_01v8 m=1 w=0.64u l=0.15u mult=1 sa=0.265
+ sb=0.265 sd=0.28 area=0.063 perim=1.14
MI675 net141 SET_B VGND VNB sky130_fd_pr__nfet_01v8 m=1 w=0.42u l=0.15u mult=1
+ sa=0.265 sb=0.265 sd=0.28 area=0.063 perim=1.14
MI653 Q net162 VGND VNB sky130_fd_pr__nfet_01v8 m=1 w=0.65u l=0.15u mult=1 sa=0.265
+ sb=0.265 sd=0.28 area=0.063 perim=1.14
MI677 M1 RESET net141 VNB sky130_fd_pr__nfet_01v8 m=1 w=0.64u l=0.15u mult=1 sa=0.265
+ sb=0.265 sd=0.28 area=0.063 perim=1.14
MI648 M0 clkpos net125 VNB sky130_fd_pr__nfet_01v8 m=1 w=0.36u l=0.15u mult=1 sa=0.265
+ sb=0.265 sd=0.28 area=0.063 perim=1.14
MI44 clkpos CLK_N VGND VNB sky130_fd_pr__nfet_01v8 m=1 w=0.42u l=0.15u mult=1 sa=0.265
+ sb=0.265 sd=0.28 area=0.063 perim=1.14
MI649 net125 M1 VGND VNB sky130_fd_pr__nfet_01v8 m=1 w=0.42u l=0.15u mult=1 sa=0.265
+ sb=0.265 sd=0.28 area=0.063 perim=1.14
MI655 S0 clkneg net110 VNB sky130_fd_pr__nfet_01v8 m=1 w=0.36u l=0.15u mult=1 sa=0.265
+ sb=0.265 sd=0.28 area=0.063 perim=1.14
MI654 net110 net82 VGND VNB sky130_fd_pr__nfet_01v8 m=1 w=0.42u l=0.15u mult=1
+ sa=0.265 sb=0.265 sd=0.28 area=0.063 perim=1.14
MI651 Q_N net82 VGND VNB sky130_fd_pr__nfet_01v8 m=1 w=0.65u l=0.15u mult=1 sa=0.265
+ sb=0.265 sd=0.28 area=0.063 perim=1.14
MI652 net162 net82 VGND VNB sky130_fd_pr__nfet_01v8 m=1 w=0.42u l=0.15u mult=1
+ sa=0.265 sb=0.265 sd=0.28 area=0.063 perim=1.14
MI42 db clkneg M0 VNB sky130_fd_pr__nfet_01v8 m=1 w=0.36u l=0.15u mult=1 sa=0.265
+ sb=0.265 sd=0.28 area=0.063 perim=1.14
MI668 S0 clkpos net93 VNB sky130_fd_pr__nfet_01v8 m=1 w=0.36u l=0.15u mult=1 sa=0.265
+ sb=0.265 sd=0.28 area=0.063 perim=1.14
MI667 net93 M1 VGND VNB sky130_fd_pr__nfet_01v8 m=1 w=0.64u l=0.15u mult=1 sa=0.265
+ sb=0.265 sd=0.28 area=0.063 perim=1.14
MI630 net82 RESET net81 VNB sky130_fd_pr__nfet_01v8 m=1 w=0.64u l=0.15u mult=1
+ sa=0.265 sb=0.265 sd=0.28 area=0.063 perim=1.14
MI3 net82 S0 net81 VNB sky130_fd_pr__nfet_01v8 m=1 w=0.64u l=0.15u mult=1 sa=0.265
+ sb=0.265 sd=0.28 area=0.063 perim=1.14
MI7 net81 SET_B VGND VNB sky130_fd_pr__nfet_01v8 m=1 w=0.42u l=0.15u mult=1 sa=0.265
+ sb=0.265 sd=0.28 area=0.063 perim=1.14
MI679 M1 SET_B net59 VNB sky130_fd_pr__pfet_01v8_hvt m=1 w=0.42u l=0.15u mult=1
+ sa=0.265 sb=0.265 sd=0.28 area=0.063 perim=1.14
MI669 S0 clkneg net218 VNB sky130_fd_pr__pfet_01v8_hvt m=1 w=0.42u l=0.15u mult=1
+ sa=0.265 sb=0.265 sd=0.28 area=0.063 perim=1.14
MI660 Q net162 net59 VNB sky130_fd_pr__pfet_01v8_hvt m=1 w=1.0u l=0.15u mult=1 sa=0.265
+ sb=0.265 sd=0.28 area=0.063 perim=1.14
MI9 net82 S0 net221 VNB sky130_fd_pr__pfet_01v8_hvt m=1 w=0.84u l=0.15u mult=1
+ sa=0.265 sb=0.265 sd=0.28 area=0.063 perim=1.14
MI670 net218 M1 net59 VNB sky130_fd_pr__pfet_01v8_hvt m=1 w=0.84u l=0.15u mult=1
+ sa=0.265 sb=0.265 sd=0.28 area=0.063 perim=1.14
MI678 net165 RESET net59 VNB sky130_fd_pr__pfet_01v8_hvt m=1 w=0.84u l=0.15u mult=1
+ sa=0.265 sb=0.265 sd=0.28 area=0.063 perim=1.14
MI662 net210 net82 net59 VNB sky130_fd_pr__pfet_01v8_hvt m=1 w=0.42u l=0.15u mult=1
+ sa=0.265 sb=0.265 sd=0.28 area=0.063 perim=1.14
MI664 S0 clkpos net210 VNB sky130_fd_pr__pfet_01v8_hvt m=1 w=0.42u l=0.15u mult=1
+ sa=0.265 sb=0.265 sd=0.28 area=0.063 perim=1.14
MI10 net82 SET_B net59 VNB sky130_fd_pr__pfet_01v8_hvt m=1 w=0.42u l=0.15u mult=1
+ sa=0.265 sb=0.265 sd=0.28 area=0.063 perim=1.14
MI11 net221 RESET net59 VNB sky130_fd_pr__pfet_01v8_hvt m=1 w=0.84u l=0.15u mult=1
+ sa=0.265 sb=0.265 sd=0.28 area=0.063 perim=1.14
MI650 net194 M1 net59 VNB sky130_fd_pr__pfet_01v8_hvt m=1 w=0.42u l=0.15u mult=1
+ sa=0.265 sb=0.265 sd=0.28 area=0.063 perim=1.14
MI665 db D net59 VNB sky130_fd_pr__pfet_01v8_hvt m=1 w=0.42u l=0.15u mult=1 sa=0.265
+ sb=0.265 sd=0.28 area=0.063 perim=1.14
MI43 db clkpos M0 VNB sky130_fd_pr__pfet_01v8_hvt m=1 w=0.42u l=0.15u mult=1 sa=0.265
+ sb=0.265 sd=0.28 area=0.063 perim=1.14
MI656 M0 clkneg net194 VNB sky130_fd_pr__pfet_01v8_hvt m=1 w=0.42u l=0.15u mult=1
+ sa=0.265 sb=0.265 sd=0.28 area=0.063 perim=1.14
MI643 RESET RESET_B net59 VNB sky130_fd_pr__pfet_01v8_hvt m=1 w=0.64u l=0.15u mult=1
+ sa=0.265 sb=0.265 sd=0.28 area=0.063 perim=1.14
MI47 clkneg clkpos net59 VNB sky130_fd_pr__pfet_01v8_hvt m=1 w=0.64u l=0.15u mult=1
+ sa=0.265 sb=0.265 sd=0.28 area=0.063 perim=1.14
MI45 clkpos CLK_N net59 VNB sky130_fd_pr__pfet_01v8_hvt m=1 w=0.64u l=0.15u mult=1
+ sa=0.265 sb=0.265 sd=0.28 area=0.063 perim=1.14
MI680 M1 M0 net165 VNB sky130_fd_pr__pfet_01v8_hvt m=1 w=0.84u l=0.15u mult=1 sa=0.265
+ sb=0.265 sd=0.28 area=0.063 perim=1.14
MI663 net162 net82 net59 VNB sky130_fd_pr__pfet_01v8_hvt m=1 w=0.64u l=0.15u mult=1
+ sa=0.265 sb=0.265 sd=0.28 area=0.063 perim=1.14
MI661 Q_N net82 net59 VNB sky130_fd_pr__pfet_01v8_hvt m=1 w=1.0u l=0.15u mult=1
+ sa=0.265 sb=0.265 sd=0.28 area=0.063 perim=1.14
.ENDS sky130_fd_sc_hd__dfbbn_1
* Copyright 2020 The SkyWater PDK Authors
*
* Licensed under the Apache License, Version 2.0 (the "License");
* you may not use this file except in compliance with the License.
* You may obtain a copy of the License at
*
*     https:  www.apache.org licenses LICENSE-2.0
*
* Unless required by applicable law or agreed to in writing, software
* distributed under the License is distributed on an "AS IS" BASIS,
* WITHOUT WARRANTIES OR CONDITIONS OF ANY KIND, either express or implied.
* See the License for the specific language governing permissions and
* limitations under the License.
*
* SPDX-License-Identifier: Apache-2.0

.SUBCKT sky130_fd_sc_hd__dfbbn_2 CLK_N D RESET_B SET_B VGND VNB VNB net59 Q Q_N
*.PININFO CLK_N:I D:I RESET_B:I SET_B:I VGND:I VNB:I VNB:I net59:I Q:O
*.PININFO Q_N:O
MI46 clkneg clkpos VGND VNB sky130_fd_pr__nfet_01v8 m=1 w=0.42u l=0.15u mult=1
+ sa=0.265 sb=0.265 sd=0.28 area=0.063 perim=1.14
MI659 db D VGND VNB sky130_fd_pr__nfet_01v8 m=1 w=0.42u l=0.15u mult=1 sa=0.265
+ sb=0.265 sd=0.28 area=0.063 perim=1.14
MI642 RESET RESET_B VGND VNB sky130_fd_pr__nfet_01v8 m=1 w=0.42u l=0.15u mult=1
+ sa=0.265 sb=0.265 sd=0.28 area=0.063 perim=1.14
MI676 M1 M0 net141 VNB sky130_fd_pr__nfet_01v8 m=1 w=0.64u l=0.15u mult=1 sa=0.265
+ sb=0.265 sd=0.28 area=0.063 perim=1.14
MI675 net141 SET_B VGND VNB sky130_fd_pr__nfet_01v8 m=1 w=0.42u l=0.15u mult=1
+ sa=0.265 sb=0.265 sd=0.28 area=0.063 perim=1.14
MI653 Q net162 VGND VNB sky130_fd_pr__nfet_01v8 m=2 w=0.65u l=0.15u mult=1 sa=0.265
+ sb=0.265 sd=0.28 area=0.063 perim=1.14
MI677 M1 RESET net141 VNB sky130_fd_pr__nfet_01v8 m=1 w=0.64u l=0.15u mult=1 sa=0.265
+ sb=0.265 sd=0.28 area=0.063 perim=1.14
MI648 M0 clkpos net125 VNB sky130_fd_pr__nfet_01v8 m=1 w=0.36u l=0.15u mult=1 sa=0.265
+ sb=0.265 sd=0.28 area=0.063 perim=1.14
MI44 clkpos CLK_N VGND VNB sky130_fd_pr__nfet_01v8 m=1 w=0.42u l=0.15u mult=1 sa=0.265
+ sb=0.265 sd=0.28 area=0.063 perim=1.14
MI649 net125 M1 VGND VNB sky130_fd_pr__nfet_01v8 m=1 w=0.42u l=0.15u mult=1 sa=0.265
+ sb=0.265 sd=0.28 area=0.063 perim=1.14
MI655 S0 clkneg net110 VNB sky130_fd_pr__nfet_01v8 m=1 w=0.36u l=0.15u mult=1 sa=0.265
+ sb=0.265 sd=0.28 area=0.063 perim=1.14
MI654 net110 net82 VGND VNB sky130_fd_pr__nfet_01v8 m=1 w=0.42u l=0.15u mult=1
+ sa=0.265 sb=0.265 sd=0.28 area=0.063 perim=1.14
MI651 Q_N net82 VGND VNB sky130_fd_pr__nfet_01v8 m=2 w=0.65u l=0.15u mult=1 sa=0.265
+ sb=0.265 sd=0.28 area=0.063 perim=1.14
MI652 net162 net82 VGND VNB sky130_fd_pr__nfet_01v8 m=1 w=0.42u l=0.15u mult=1
+ sa=0.265 sb=0.265 sd=0.28 area=0.063 perim=1.14
MI42 db clkneg M0 VNB sky130_fd_pr__nfet_01v8 m=1 w=0.36u l=0.15u mult=1 sa=0.265
+ sb=0.265 sd=0.28 area=0.063 perim=1.14
MI668 S0 clkpos net93 VNB sky130_fd_pr__nfet_01v8 m=1 w=0.36u l=0.15u mult=1 sa=0.265
+ sb=0.265 sd=0.28 area=0.063 perim=1.14
MI667 net93 M1 VGND VNB sky130_fd_pr__nfet_01v8 m=1 w=0.64u l=0.15u mult=1 sa=0.265
+ sb=0.265 sd=0.28 area=0.063 perim=1.14
MI630 net82 RESET net81 VNB sky130_fd_pr__nfet_01v8 m=1 w=0.64u l=0.15u mult=1
+ sa=0.265 sb=0.265 sd=0.28 area=0.063 perim=1.14
MI3 net82 S0 net81 VNB sky130_fd_pr__nfet_01v8 m=1 w=0.64u l=0.15u mult=1 sa=0.265
+ sb=0.265 sd=0.28 area=0.063 perim=1.14
MI7 net81 SET_B VGND VNB sky130_fd_pr__nfet_01v8 m=1 w=0.42u l=0.15u mult=1 sa=0.265
+ sb=0.265 sd=0.28 area=0.063 perim=1.14
MI679 M1 SET_B net59 VNB sky130_fd_pr__pfet_01v8_hvt m=1 w=0.42u l=0.15u mult=1
+ sa=0.265 sb=0.265 sd=0.28 area=0.063 perim=1.14
MI669 S0 clkneg net218 VNB sky130_fd_pr__pfet_01v8_hvt m=1 w=0.42u l=0.15u mult=1
+ sa=0.265 sb=0.265 sd=0.28 area=0.063 perim=1.14
MI660 Q net162 net59 VNB sky130_fd_pr__pfet_01v8_hvt m=2 w=1.0u l=0.15u mult=1 sa=0.265
+ sb=0.265 sd=0.28 area=0.063 perim=1.14
MI9 net82 S0 net221 VNB sky130_fd_pr__pfet_01v8_hvt m=1 w=0.84u l=0.15u mult=1
+ sa=0.265 sb=0.265 sd=0.28 area=0.063 perim=1.14
MI670 net218 M1 net59 VNB sky130_fd_pr__pfet_01v8_hvt m=1 w=0.84u l=0.15u mult=1
+ sa=0.265 sb=0.265 sd=0.28 area=0.063 perim=1.14
MI678 net165 RESET net59 VNB sky130_fd_pr__pfet_01v8_hvt m=1 w=0.84u l=0.15u mult=1
+ sa=0.265 sb=0.265 sd=0.28 area=0.063 perim=1.14
MI662 net210 net82 net59 VNB sky130_fd_pr__pfet_01v8_hvt m=1 w=0.42u l=0.15u mult=1
+ sa=0.265 sb=0.265 sd=0.28 area=0.063 perim=1.14
MI664 S0 clkpos net210 VNB sky130_fd_pr__pfet_01v8_hvt m=1 w=0.42u l=0.15u mult=1
+ sa=0.265 sb=0.265 sd=0.28 area=0.063 perim=1.14
MI10 net82 SET_B net59 VNB sky130_fd_pr__pfet_01v8_hvt m=1 w=0.42u l=0.15u mult=1
+ sa=0.265 sb=0.265 sd=0.28 area=0.063 perim=1.14
MI11 net221 RESET net59 VNB sky130_fd_pr__pfet_01v8_hvt m=1 w=0.84u l=0.15u mult=1
+ sa=0.265 sb=0.265 sd=0.28 area=0.063 perim=1.14
MI650 net194 M1 net59 VNB sky130_fd_pr__pfet_01v8_hvt m=1 w=0.42u l=0.15u mult=1
+ sa=0.265 sb=0.265 sd=0.28 area=0.063 perim=1.14
MI665 db D net59 VNB sky130_fd_pr__pfet_01v8_hvt m=1 w=0.42u l=0.15u mult=1 sa=0.265
+ sb=0.265 sd=0.28 area=0.063 perim=1.14
MI43 db clkpos M0 VNB sky130_fd_pr__pfet_01v8_hvt m=1 w=0.42u l=0.15u mult=1 sa=0.265
+ sb=0.265 sd=0.28 area=0.063 perim=1.14
MI656 M0 clkneg net194 VNB sky130_fd_pr__pfet_01v8_hvt m=1 w=0.42u l=0.15u mult=1
+ sa=0.265 sb=0.265 sd=0.28 area=0.063 perim=1.14
MI643 RESET RESET_B net59 VNB sky130_fd_pr__pfet_01v8_hvt m=1 w=0.64u l=0.15u mult=1
+ sa=0.265 sb=0.265 sd=0.28 area=0.063 perim=1.14
MI47 clkneg clkpos net59 VNB sky130_fd_pr__pfet_01v8_hvt m=1 w=0.64u l=0.15u mult=1
+ sa=0.265 sb=0.265 sd=0.28 area=0.063 perim=1.14
MI45 clkpos CLK_N net59 VNB sky130_fd_pr__pfet_01v8_hvt m=1 w=0.64u l=0.15u mult=1
+ sa=0.265 sb=0.265 sd=0.28 area=0.063 perim=1.14
MI680 M1 M0 net165 VNB sky130_fd_pr__pfet_01v8_hvt m=1 w=0.84u l=0.15u mult=1 sa=0.265
+ sb=0.265 sd=0.28 area=0.063 perim=1.14
MI663 net162 net82 net59 VNB sky130_fd_pr__pfet_01v8_hvt m=1 w=0.64u l=0.15u mult=1
+ sa=0.265 sb=0.265 sd=0.28 area=0.063 perim=1.14
MI661 Q_N net82 net59 VNB sky130_fd_pr__pfet_01v8_hvt m=2 w=1.0u l=0.15u mult=1
+ sa=0.265 sb=0.265 sd=0.28 area=0.063 perim=1.14
.ENDS sky130_fd_sc_hd__dfbbn_2
* Copyright 2020 The SkyWater PDK Authors
*
* Licensed under the Apache License, Version 2.0 (the "License");
* you may not use this file except in compliance with the License.
* You may obtain a copy of the License at
*
*     https:  www.apache.org licenses LICENSE-2.0
*
* Unless required by applicable law or agreed to in writing, software
* distributed under the License is distributed on an "AS IS" BASIS,
* WITHOUT WARRANTIES OR CONDITIONS OF ANY KIND, either express or implied.
* See the License for the specific language governing permissions and
* limitations under the License.
*
* SPDX-License-Identifier: Apache-2.0

.SUBCKT sky130_fd_sc_hd__dfbbp_1 CLK D RESET_B SET_B VGND VNB VNB net59 Q Q_N
*.PININFO CLK:I D:I RESET_B:I SET_B:I VGND:I VNB:I VNB:I net59:I Q:O
*.PININFO Q_N:O
MI46 clkpos clkneg VGND VNB sky130_fd_pr__nfet_01v8 m=1 w=0.42u l=0.15u mult=1
+ sa=0.265 sb=0.265 sd=0.28 area=0.063 perim=1.14
MI659 db D VGND VNB sky130_fd_pr__nfet_01v8 m=1 w=0.42u l=0.15u mult=1 sa=0.265
+ sb=0.265 sd=0.28 area=0.063 perim=1.14
MI642 RESET RESET_B VGND VNB sky130_fd_pr__nfet_01v8 m=1 w=0.42u l=0.15u mult=1
+ sa=0.265 sb=0.265 sd=0.28 area=0.063 perim=1.14
MI676 M1 M0 net141 VNB sky130_fd_pr__nfet_01v8 m=1 w=0.64u l=0.15u mult=1 sa=0.265
+ sb=0.265 sd=0.28 area=0.063 perim=1.14
MI675 net141 SET_B VGND VNB sky130_fd_pr__nfet_01v8 m=1 w=0.42u l=0.15u mult=1
+ sa=0.265 sb=0.265 sd=0.28 area=0.063 perim=1.14
MI653 Q net162 VGND VNB sky130_fd_pr__nfet_01v8 m=1 w=0.65u l=0.15u mult=1 sa=0.265
+ sb=0.265 sd=0.28 area=0.063 perim=1.14
MI677 M1 RESET net141 VNB sky130_fd_pr__nfet_01v8 m=1 w=0.64u l=0.15u mult=1 sa=0.265
+ sb=0.265 sd=0.28 area=0.063 perim=1.14
MI648 M0 clkpos net118 VNB sky130_fd_pr__nfet_01v8 m=1 w=0.36u l=0.15u mult=1 sa=0.265
+ sb=0.265 sd=0.28 area=0.063 perim=1.14
MI44 clkneg CLK VGND VNB sky130_fd_pr__nfet_01v8 m=1 w=0.42u l=0.15u mult=1 sa=0.265
+ sb=0.265 sd=0.28 area=0.063 perim=1.14
MI649 net118 M1 VGND VNB sky130_fd_pr__nfet_01v8 m=1 w=0.42u l=0.15u mult=1 sa=0.265
+ sb=0.265 sd=0.28 area=0.063 perim=1.14
MI655 S0 clkneg net110 VNB sky130_fd_pr__nfet_01v8 m=1 w=0.36u l=0.15u mult=1 sa=0.265
+ sb=0.265 sd=0.28 area=0.063 perim=1.14
MI654 net110 net82 VGND VNB sky130_fd_pr__nfet_01v8 m=1 w=0.42u l=0.15u mult=1
+ sa=0.265 sb=0.265 sd=0.28 area=0.063 perim=1.14
MI651 Q_N net82 VGND VNB sky130_fd_pr__nfet_01v8 m=1 w=0.65u l=0.15u mult=1 sa=0.265
+ sb=0.265 sd=0.28 area=0.063 perim=1.14
MI652 net162 net82 VGND VNB sky130_fd_pr__nfet_01v8 m=1 w=0.42u l=0.15u mult=1
+ sa=0.265 sb=0.265 sd=0.28 area=0.063 perim=1.14
MI42 db clkneg M0 VNB sky130_fd_pr__nfet_01v8 m=1 w=0.36u l=0.15u mult=1 sa=0.265
+ sb=0.265 sd=0.28 area=0.063 perim=1.14
MI668 S0 clkpos net93 VNB sky130_fd_pr__nfet_01v8 m=1 w=0.36u l=0.15u mult=1 sa=0.265
+ sb=0.265 sd=0.28 area=0.063 perim=1.14
MI667 net93 M1 VGND VNB sky130_fd_pr__nfet_01v8 m=1 w=0.64u l=0.15u mult=1 sa=0.265
+ sb=0.265 sd=0.28 area=0.063 perim=1.14
MI630 net82 RESET net81 VNB sky130_fd_pr__nfet_01v8 m=1 w=0.64u l=0.15u mult=1
+ sa=0.265 sb=0.265 sd=0.28 area=0.063 perim=1.14
MI3 net82 S0 net81 VNB sky130_fd_pr__nfet_01v8 m=1 w=0.64u l=0.15u mult=1 sa=0.265
+ sb=0.265 sd=0.28 area=0.063 perim=1.14
MI7 net81 SET_B VGND VNB sky130_fd_pr__nfet_01v8 m=1 w=0.42u l=0.15u mult=1 sa=0.265
+ sb=0.265 sd=0.28 area=0.063 perim=1.14
MI679 M1 SET_B net59 VNB sky130_fd_pr__pfet_01v8_hvt m=1 w=0.42u l=0.15u mult=1
+ sa=0.265 sb=0.265 sd=0.28 area=0.063 perim=1.14
MI669 S0 clkneg net218 VNB sky130_fd_pr__pfet_01v8_hvt m=1 w=0.42u l=0.15u mult=1
+ sa=0.265 sb=0.265 sd=0.28 area=0.063 perim=1.14
MI660 Q net162 net59 VNB sky130_fd_pr__pfet_01v8_hvt m=1 w=1.0u l=0.15u mult=1 sa=0.265
+ sb=0.265 sd=0.28 area=0.063 perim=1.14
MI9 net82 S0 net221 VNB sky130_fd_pr__pfet_01v8_hvt m=1 w=0.84u l=0.15u mult=1
+ sa=0.265 sb=0.265 sd=0.28 area=0.063 perim=1.14
MI670 net218 M1 net59 VNB sky130_fd_pr__pfet_01v8_hvt m=1 w=0.84u l=0.15u mult=1
+ sa=0.265 sb=0.265 sd=0.28 area=0.063 perim=1.14
MI678 net165 RESET net59 VNB sky130_fd_pr__pfet_01v8_hvt m=1 w=0.84u l=0.15u mult=1
+ sa=0.265 sb=0.265 sd=0.28 area=0.063 perim=1.14
MI662 net210 net82 net59 VNB sky130_fd_pr__pfet_01v8_hvt m=1 w=0.42u l=0.15u mult=1
+ sa=0.265 sb=0.265 sd=0.28 area=0.063 perim=1.14
MI664 S0 clkpos net210 VNB sky130_fd_pr__pfet_01v8_hvt m=1 w=0.42u l=0.15u mult=1
+ sa=0.265 sb=0.265 sd=0.28 area=0.063 perim=1.14
MI10 net82 SET_B net59 VNB sky130_fd_pr__pfet_01v8_hvt m=1 w=0.42u l=0.15u mult=1
+ sa=0.265 sb=0.265 sd=0.28 area=0.063 perim=1.14
MI11 net221 RESET net59 VNB sky130_fd_pr__pfet_01v8_hvt m=1 w=0.84u l=0.15u mult=1
+ sa=0.265 sb=0.265 sd=0.28 area=0.063 perim=1.14
MI650 net194 M1 net59 VNB sky130_fd_pr__pfet_01v8_hvt m=1 w=0.42u l=0.15u mult=1
+ sa=0.265 sb=0.265 sd=0.28 area=0.063 perim=1.14
MI665 db D net59 VNB sky130_fd_pr__pfet_01v8_hvt m=1 w=0.42u l=0.15u mult=1 sa=0.265
+ sb=0.265 sd=0.28 area=0.063 perim=1.14
MI43 db clkpos M0 VNB sky130_fd_pr__pfet_01v8_hvt m=1 w=0.42u l=0.15u mult=1 sa=0.265
+ sb=0.265 sd=0.28 area=0.063 perim=1.14
MI656 M0 clkneg net194 VNB sky130_fd_pr__pfet_01v8_hvt m=1 w=0.42u l=0.15u mult=1
+ sa=0.265 sb=0.265 sd=0.28 area=0.063 perim=1.14
MI643 RESET RESET_B net59 VNB sky130_fd_pr__pfet_01v8_hvt m=1 w=0.64u l=0.15u mult=1
+ sa=0.265 sb=0.265 sd=0.28 area=0.063 perim=1.14
MI47 clkpos clkneg net59 VNB sky130_fd_pr__pfet_01v8_hvt m=1 w=0.64u l=0.15u mult=1
+ sa=0.265 sb=0.265 sd=0.28 area=0.063 perim=1.14
MI45 clkneg CLK net59 VNB sky130_fd_pr__pfet_01v8_hvt m=1 w=0.64u l=0.15u mult=1
+ sa=0.265 sb=0.265 sd=0.28 area=0.063 perim=1.14
MI680 M1 M0 net165 VNB sky130_fd_pr__pfet_01v8_hvt m=1 w=0.84u l=0.15u mult=1 sa=0.265
+ sb=0.265 sd=0.28 area=0.063 perim=1.14
MI663 net162 net82 net59 VNB sky130_fd_pr__pfet_01v8_hvt m=1 w=0.64u l=0.15u mult=1
+ sa=0.265 sb=0.265 sd=0.28 area=0.063 perim=1.14
MI661 Q_N net82 net59 VNB sky130_fd_pr__pfet_01v8_hvt m=1 w=1.0u l=0.15u mult=1
+ sa=0.265 sb=0.265 sd=0.28 area=0.063 perim=1.14
.ENDS sky130_fd_sc_hd__dfbbp_1
* Copyright 2020 The SkyWater PDK Authors
*
* Licensed under the Apache License, Version 2.0 (the "License");
* you may not use this file except in compliance with the License.
* You may obtain a copy of the License at
*
*     https:  www.apache.org licenses LICENSE-2.0
*
* Unless required by applicable law or agreed to in writing, software
* distributed under the License is distributed on an "AS IS" BASIS,
* WITHOUT WARRANTIES OR CONDITIONS OF ANY KIND, either express or implied.
* See the License for the specific language governing permissions and
* limitations under the License.
*
* SPDX-License-Identifier: Apache-2.0

.SUBCKT sky130_fd_sc_hd__dfrbp_1 CLK D RESET_B VGND VNB VNB net59 Q Q_N
*.PININFO CLK:I D:I RESET_B:I VGND:I VNB:I VNB:I net59:I Q:O Q_N:O
MI46 clkpos clkneg VGND VNB sky130_fd_pr__nfet_01v8 m=1 w=0.42u l=0.15u mult=1
+ sa=0.265 sb=0.265 sd=0.28 area=0.063 perim=1.14
MI42 db clkneg M0 VNB sky130_fd_pr__nfet_01v8 m=1 w=0.36u l=0.15u mult=1 sa=0.265
+ sb=0.265 sd=0.28 area=0.063 perim=1.14
MI656 net99 s0 net125 VNB sky130_fd_pr__nfet_01v8 m=1 w=0.42u l=0.15u mult=1 sa=0.265
+ sb=0.265 sd=0.28 area=0.063 perim=1.14
MI657 net125 RESET_B VGND VNB sky130_fd_pr__nfet_01v8 m=1 w=0.42u l=0.15u mult=1
+ sa=0.265 sb=0.265 sd=0.28 area=0.063 perim=1.14
MI33 net118 RESET_B VGND VNB sky130_fd_pr__nfet_01v8 m=1 w=0.42u l=0.15u mult=1
+ sa=0.265 sb=0.265 sd=0.28 area=0.063 perim=1.14
MI4 M0 clkpos net110 VNB sky130_fd_pr__nfet_01v8 m=1 w=0.36u l=0.15u mult=1 sa=0.265
+ sb=0.265 sd=0.28 area=0.063 perim=1.14
MI34 net110 M1 net118 VNB sky130_fd_pr__nfet_01v8 m=1 w=0.42u l=0.15u mult=1 sa=0.265
+ sb=0.265 sd=0.28 area=0.063 perim=1.14
MI655 s0 clkneg net98 VNB sky130_fd_pr__nfet_01v8 m=1 w=0.36u l=0.15u mult=1 sa=0.265
+ sb=0.265 sd=0.28 area=0.063 perim=1.14
MI653 Q net99 VGND VNB sky130_fd_pr__nfet_01v8 m=1 w=0.65u l=0.15u mult=1 sa=0.265
+ sb=0.265 sd=0.28 area=0.063 perim=1.14
MI654 net98 net99 VGND VNB sky130_fd_pr__nfet_01v8 m=1 w=0.42u l=0.15u mult=1 sa=0.265
+ sb=0.265 sd=0.28 area=0.063 perim=1.14
MI44 clkneg CLK VGND VNB sky130_fd_pr__nfet_01v8 m=1 w=0.42u l=0.15u mult=1 sa=0.265
+ sb=0.265 sd=0.28 area=0.063 perim=1.14
MI647 M1 M0 VGND VNB sky130_fd_pr__nfet_01v8 m=1 w=0.64u l=0.15u mult=1 sa=0.265
+ sb=0.265 sd=0.28 area=0.063 perim=1.14
MI39 db D VGND VNB sky130_fd_pr__nfet_01v8 m=1 w=0.42u l=0.15u mult=1 sa=0.265
+ sb=0.265 sd=0.28 area=0.063 perim=1.14
MI649 M1 clkpos s0 VNB sky130_fd_pr__nfet_01v8 m=1 w=0.36u l=0.15u mult=1 sa=0.265
+ sb=0.265 sd=0.28 area=0.063 perim=1.14
MI53 net142 net99 VGND VNB sky130_fd_pr__nfet_01v8 m=1 w=0.42u l=0.15u mult=1 sa=0.265
+ sb=0.265 sd=0.28 area=0.063 perim=1.14
MI50 Q_N net142 VGND VNB sky130_fd_pr__nfet_01v8 m=1 w=0.65u l=0.15u mult=1 sa=0.265
+ sb=0.265 sd=0.28 area=0.063 perim=1.14
MI47 clkpos clkneg net59 VNB sky130_fd_pr__pfet_01v8_hvt m=1 w=0.64u l=0.15u mult=1
+ sa=0.265 sb=0.265 sd=0.28 area=0.063 perim=1.14
MI43 db clkpos M0 VNB sky130_fd_pr__pfet_01v8_hvt m=1 w=0.42u l=0.15u mult=1 sa=0.265
+ sb=0.265 sd=0.28 area=0.063 perim=1.14
MI662 net190 net99 net59 VNB sky130_fd_pr__pfet_01v8_hvt m=1 w=0.42u l=0.15u mult=1
+ sa=0.265 sb=0.265 sd=0.28 area=0.063 perim=1.14
MI659 net99 RESET_B net59 VNB sky130_fd_pr__pfet_01v8_hvt m=1 w=0.42u l=0.15u mult=1
+ sa=0.265 sb=0.265 sd=0.28 area=0.063 perim=1.14
MI664 s0 clkpos net190 VNB sky130_fd_pr__pfet_01v8_hvt m=1 w=0.42u l=0.15u mult=1
+ sa=0.265 sb=0.265 sd=0.28 area=0.063 perim=1.14
MI658 net99 s0 net59 VNB sky130_fd_pr__pfet_01v8_hvt m=1 w=0.42u l=0.15u mult=1
+ sa=0.265 sb=0.265 sd=0.28 area=0.063 perim=1.14
MI30 net169 M1 net59 VNB sky130_fd_pr__pfet_01v8_hvt m=1 w=0.42u l=0.15u mult=1
+ sa=0.265 sb=0.265 sd=0.28 area=0.063 perim=1.14
MI31 M0 clkneg net169 VNB sky130_fd_pr__pfet_01v8_hvt m=1 w=0.42u l=0.15u mult=1
+ sa=0.265 sb=0.265 sd=0.28 area=0.063 perim=1.14
MI32 net169 RESET_B net59 VNB sky130_fd_pr__pfet_01v8_hvt m=1 w=0.42u l=0.15u mult=1
+ sa=0.265 sb=0.265 sd=0.28 area=0.063 perim=1.14
MI660 Q net99 net59 VNB sky130_fd_pr__pfet_01v8_hvt m=1 w=1.0u l=0.15u mult=1 sa=0.265
+ sb=0.265 sd=0.28 area=0.063 perim=1.14
MI45 clkneg CLK net59 VNB sky130_fd_pr__pfet_01v8_hvt m=1 w=0.64u l=0.15u mult=1
+ sa=0.265 sb=0.265 sd=0.28 area=0.063 perim=1.14
MI648 M1 M0 net59 VNB sky130_fd_pr__pfet_01v8_hvt m=1 w=0.84u l=0.15u mult=1 sa=0.265
+ sb=0.265 sd=0.28 area=0.063 perim=1.14
MI40 db D net59 VNB sky130_fd_pr__pfet_01v8_hvt m=1 w=0.42u l=0.15u mult=1 sa=0.265
+ sb=0.265 sd=0.28 area=0.063 perim=1.14
MI650 M1 clkneg s0 VNB sky130_fd_pr__pfet_01v8_hvt m=1 w=0.42u l=0.15u mult=1 sa=0.265
+ sb=0.265 sd=0.28 area=0.063 perim=1.14
MI52 net142 net99 net59 VNB sky130_fd_pr__pfet_01v8_hvt m=1 w=0.64u l=0.15u mult=1
+ sa=0.265 sb=0.265 sd=0.28 area=0.063 perim=1.14
MI51 Q_N net142 net59 VNB sky130_fd_pr__pfet_01v8_hvt m=1 w=1.0u l=0.15u mult=1
+ sa=0.265 sb=0.265 sd=0.28 area=0.063 perim=1.14
.ENDS sky130_fd_sc_hd__dfrbp_1
* Copyright 2020 The SkyWater PDK Authors
*
* Licensed under the Apache License, Version 2.0 (the "License");
* you may not use this file except in compliance with the License.
* You may obtain a copy of the License at
*
*     https:  www.apache.org licenses LICENSE-2.0
*
* Unless required by applicable law or agreed to in writing, software
* distributed under the License is distributed on an "AS IS" BASIS,
* WITHOUT WARRANTIES OR CONDITIONS OF ANY KIND, either express or implied.
* See the License for the specific language governing permissions and
* limitations under the License.
*
* SPDX-License-Identifier: Apache-2.0

.SUBCKT sky130_fd_sc_hd__dfrbp_2 CLK D RESET_B VGND VNB VNB net59 Q Q_N
*.PININFO CLK:I D:I RESET_B:I VGND:I VNB:I VNB:I net59:I Q:O Q_N:O
MI46 clkpos clkneg VGND VNB sky130_fd_pr__nfet_01v8 m=1 w=0.42u l=0.15u mult=1
+ sa=0.265 sb=0.265 sd=0.28 area=0.063 perim=1.14
MI42 db clkneg M0 VNB sky130_fd_pr__nfet_01v8 m=1 w=0.36u l=0.15u mult=1 sa=0.265
+ sb=0.265 sd=0.28 area=0.063 perim=1.14
MI656 net99 s0 net125 VNB sky130_fd_pr__nfet_01v8 m=1 w=0.42u l=0.15u mult=1 sa=0.265
+ sb=0.265 sd=0.28 area=0.063 perim=1.14
MI657 net125 RESET_B VGND VNB sky130_fd_pr__nfet_01v8 m=1 w=0.42u l=0.15u mult=1
+ sa=0.265 sb=0.265 sd=0.28 area=0.063 perim=1.14
MI33 net118 RESET_B VGND VNB sky130_fd_pr__nfet_01v8 m=1 w=0.42u l=0.15u mult=1
+ sa=0.265 sb=0.265 sd=0.28 area=0.063 perim=1.14
MI4 M0 clkpos net110 VNB sky130_fd_pr__nfet_01v8 m=1 w=0.36u l=0.15u mult=1 sa=0.265
+ sb=0.265 sd=0.28 area=0.063 perim=1.14
MI34 net110 M1 net118 VNB sky130_fd_pr__nfet_01v8 m=1 w=0.42u l=0.15u mult=1 sa=0.265
+ sb=0.265 sd=0.28 area=0.063 perim=1.14
MI655 s0 clkneg net98 VNB sky130_fd_pr__nfet_01v8 m=1 w=0.36u l=0.15u mult=1 sa=0.265
+ sb=0.265 sd=0.28 area=0.063 perim=1.14
MI653 Q net99 VGND VNB sky130_fd_pr__nfet_01v8 m=2 w=0.65u l=0.15u mult=1 sa=0.265
+ sb=0.265 sd=0.28 area=0.063 perim=1.14
MI654 net98 net99 VGND VNB sky130_fd_pr__nfet_01v8 m=1 w=0.42u l=0.15u mult=1 sa=0.265
+ sb=0.265 sd=0.28 area=0.063 perim=1.14
MI44 clkneg CLK VGND VNB sky130_fd_pr__nfet_01v8 m=1 w=0.42u l=0.15u mult=1 sa=0.265
+ sb=0.265 sd=0.28 area=0.063 perim=1.14
MI647 M1 M0 VGND VNB sky130_fd_pr__nfet_01v8 m=1 w=0.64u l=0.15u mult=1 sa=0.265
+ sb=0.265 sd=0.28 area=0.063 perim=1.14
MI39 db D VGND VNB sky130_fd_pr__nfet_01v8 m=1 w=0.42u l=0.15u mult=1 sa=0.265
+ sb=0.265 sd=0.28 area=0.063 perim=1.14
MI649 M1 clkpos s0 VNB sky130_fd_pr__nfet_01v8 m=1 w=0.36u l=0.15u mult=1 sa=0.265
+ sb=0.265 sd=0.28 area=0.063 perim=1.14
MI53 net142 net99 VGND VNB sky130_fd_pr__nfet_01v8 m=1 w=0.42u l=0.15u mult=1 sa=0.265
+ sb=0.265 sd=0.28 area=0.063 perim=1.14
MI50 Q_N net142 VGND VNB sky130_fd_pr__nfet_01v8 m=2 w=0.65u l=0.15u mult=1 sa=0.265
+ sb=0.265 sd=0.28 area=0.063 perim=1.14
MI47 clkpos clkneg net59 VNB sky130_fd_pr__pfet_01v8_hvt m=1 w=0.64u l=0.15u mult=1
+ sa=0.265 sb=0.265 sd=0.28 area=0.063 perim=1.14
MI43 db clkpos M0 VNB sky130_fd_pr__pfet_01v8_hvt m=1 w=0.42u l=0.15u mult=1 sa=0.265
+ sb=0.265 sd=0.28 area=0.063 perim=1.14
MI662 net181 net99 net59 VNB sky130_fd_pr__pfet_01v8_hvt m=1 w=0.42u l=0.15u mult=1
+ sa=0.265 sb=0.265 sd=0.28 area=0.063 perim=1.14
MI659 net99 RESET_B net59 VNB sky130_fd_pr__pfet_01v8_hvt m=1 w=0.42u l=0.15u mult=1
+ sa=0.265 sb=0.265 sd=0.28 area=0.063 perim=1.14
MI664 s0 clkpos net181 VNB sky130_fd_pr__pfet_01v8_hvt m=1 w=0.42u l=0.15u mult=1
+ sa=0.265 sb=0.265 sd=0.28 area=0.063 perim=1.14
MI658 net99 s0 net59 VNB sky130_fd_pr__pfet_01v8_hvt m=1 w=0.42u l=0.15u mult=1
+ sa=0.265 sb=0.265 sd=0.28 area=0.063 perim=1.14
MI30 net169 M1 net59 VNB sky130_fd_pr__pfet_01v8_hvt m=1 w=0.42u l=0.15u mult=1
+ sa=0.265 sb=0.265 sd=0.28 area=0.063 perim=1.14
MI31 M0 clkneg net169 VNB sky130_fd_pr__pfet_01v8_hvt m=1 w=0.42u l=0.15u mult=1
+ sa=0.265 sb=0.265 sd=0.28 area=0.063 perim=1.14
MI32 net169 RESET_B net59 VNB sky130_fd_pr__pfet_01v8_hvt m=1 w=0.42u l=0.15u mult=1
+ sa=0.265 sb=0.265 sd=0.28 area=0.063 perim=1.14
MI660 Q net99 net59 VNB sky130_fd_pr__pfet_01v8_hvt m=2 w=1.0u l=0.15u mult=1 sa=0.265
+ sb=0.265 sd=0.28 area=0.063 perim=1.14
MI45 clkneg CLK net59 VNB sky130_fd_pr__pfet_01v8_hvt m=1 w=0.64u l=0.15u mult=1
+ sa=0.265 sb=0.265 sd=0.28 area=0.063 perim=1.14
MI648 M1 M0 net59 VNB sky130_fd_pr__pfet_01v8_hvt m=1 w=0.84u l=0.15u mult=1 sa=0.265
+ sb=0.265 sd=0.28 area=0.063 perim=1.14
MI40 db D net59 VNB sky130_fd_pr__pfet_01v8_hvt m=1 w=0.42u l=0.15u mult=1 sa=0.265
+ sb=0.265 sd=0.28 area=0.063 perim=1.14
MI650 M1 clkneg s0 VNB sky130_fd_pr__pfet_01v8_hvt m=1 w=0.42u l=0.15u mult=1 sa=0.265
+ sb=0.265 sd=0.28 area=0.063 perim=1.14
MI52 net142 net99 net59 VNB sky130_fd_pr__pfet_01v8_hvt m=1 w=0.64u l=0.15u mult=1
+ sa=0.265 sb=0.265 sd=0.28 area=0.063 perim=1.14
MI51 Q_N net142 net59 VNB sky130_fd_pr__pfet_01v8_hvt m=2 w=1.0u l=0.15u mult=1
+ sa=0.265 sb=0.265 sd=0.28 area=0.063 perim=1.14
.ENDS sky130_fd_sc_hd__dfrbp_2
* Copyright 2020 The SkyWater PDK Authors
*
* Licensed under the Apache License, Version 2.0 (the "License");
* you may not use this file except in compliance with the License.
* You may obtain a copy of the License at
*
*     https:  www.apache.org licenses LICENSE-2.0
*
* Unless required by applicable law or agreed to in writing, software
* distributed under the License is distributed on an "AS IS" BASIS,
* WITHOUT WARRANTIES OR CONDITIONS OF ANY KIND, either express or implied.
* See the License for the specific language governing permissions and
* limitations under the License.
*
* SPDX-License-Identifier: Apache-2.0

.SUBCKT sky130_fd_sc_hd__dfrtn_1 CLK_N D RESET_B VGND VNB VNB net59 Q
*.PININFO CLK_N:I D:I RESET_B:I VGND:I VNB:I VNB:I net59:I Q:O
MI46 clkneg clkpos VGND VNB sky130_fd_pr__nfet_01v8 m=1 w=0.42u l=0.15u mult=1
+ sa=0.265 sb=0.265 sd=0.28 area=0.063 perim=1.14
MI42 db clkneg M0 VNB sky130_fd_pr__nfet_01v8 m=1 w=0.36u l=0.15u mult=1 sa=0.265
+ sb=0.265 sd=0.28 area=0.063 perim=1.14
MI656 net83 net121 net109 VNB sky130_fd_pr__nfet_01v8 m=1 w=0.42u l=0.15u mult=1
+ sa=0.265 sb=0.265 sd=0.28 area=0.063 perim=1.14
MI657 net109 RESET_B VGND VNB sky130_fd_pr__nfet_01v8 m=1 w=0.42u l=0.15u mult=1
+ sa=0.265 sb=0.265 sd=0.28 area=0.063 perim=1.14
MI33 net102 RESET_B VGND VNB sky130_fd_pr__nfet_01v8 m=1 w=0.42u l=0.15u mult=1
+ sa=0.265 sb=0.265 sd=0.28 area=0.063 perim=1.14
MI4 M0 clkpos net94 VNB sky130_fd_pr__nfet_01v8 m=1 w=0.36u l=0.15u mult=1 sa=0.265
+ sb=0.265 sd=0.28 area=0.063 perim=1.14
MI34 net94 M1 net102 VNB sky130_fd_pr__nfet_01v8 m=1 w=0.42u l=0.15u mult=1 sa=0.265
+ sb=0.265 sd=0.28 area=0.063 perim=1.14
MI655 net121 clkneg net82 VNB sky130_fd_pr__nfet_01v8 m=1 w=0.36u l=0.15u mult=1
+ sa=0.265 sb=0.265 sd=0.28 area=0.063 perim=1.14
MI653 Q net83 VGND VNB sky130_fd_pr__nfet_01v8 m=1 w=0.65u l=0.15u mult=1 sa=0.265
+ sb=0.265 sd=0.28 area=0.063 perim=1.14
MI654 net82 net83 VGND VNB sky130_fd_pr__nfet_01v8 m=1 w=0.42u l=0.15u mult=1 sa=0.265
+ sb=0.265 sd=0.28 area=0.063 perim=1.14
MI44 clkpos CLK_N VGND VNB sky130_fd_pr__nfet_01v8 m=1 w=0.42u l=0.15u mult=1 sa=0.265
+ sb=0.265 sd=0.28 area=0.063 perim=1.14
MI647 M1 M0 VGND VNB sky130_fd_pr__nfet_01v8 m=1 w=0.64u l=0.15u mult=1 sa=0.265
+ sb=0.265 sd=0.28 area=0.063 perim=1.14
MI39 db D VGND VNB sky130_fd_pr__nfet_01v8 m=1 w=0.42u l=0.15u mult=1 sa=0.265
+ sb=0.265 sd=0.28 area=0.063 perim=1.14
MI649 M1 clkpos net121 VNB sky130_fd_pr__nfet_01v8 m=1 w=0.36u l=0.15u mult=1 sa=0.265
+ sb=0.265 sd=0.28 area=0.063 perim=1.14
MI47 clkneg clkpos net59 VNB sky130_fd_pr__pfet_01v8_hvt m=1 w=0.64u l=0.15u mult=1
+ sa=0.265 sb=0.265 sd=0.28 area=0.063 perim=1.14
MI43 db clkpos M0 VNB sky130_fd_pr__pfet_01v8_hvt m=1 w=0.42u l=0.15u mult=1 sa=0.265
+ sb=0.265 sd=0.28 area=0.063 perim=1.14
MI662 net166 net83 net59 VNB sky130_fd_pr__pfet_01v8_hvt m=1 w=0.42u l=0.15u mult=1
+ sa=0.265 sb=0.265 sd=0.28 area=0.063 perim=1.14
MI659 net83 RESET_B net59 VNB sky130_fd_pr__pfet_01v8_hvt m=1 w=0.42u l=0.15u mult=1
+ sa=0.265 sb=0.265 sd=0.28 area=0.063 perim=1.14
MI664 net121 clkpos net166 VNB sky130_fd_pr__pfet_01v8_hvt m=1 w=0.42u l=0.15u mult=1
+ sa=0.265 sb=0.265 sd=0.28 area=0.063 perim=1.14
MI658 net83 net121 net59 VNB sky130_fd_pr__pfet_01v8_hvt m=1 w=0.42u l=0.15u mult=1
+ sa=0.265 sb=0.265 sd=0.28 area=0.063 perim=1.14
MI30 net145 M1 net59 VNB sky130_fd_pr__pfet_01v8_hvt m=1 w=0.42u l=0.15u mult=1
+ sa=0.265 sb=0.265 sd=0.28 area=0.063 perim=1.14
MI31 M0 clkneg net145 VNB sky130_fd_pr__pfet_01v8_hvt m=1 w=0.42u l=0.15u mult=1
+ sa=0.265 sb=0.265 sd=0.28 area=0.063 perim=1.14
MI32 net145 RESET_B net59 VNB sky130_fd_pr__pfet_01v8_hvt m=1 w=0.42u l=0.15u mult=1
+ sa=0.265 sb=0.265 sd=0.28 area=0.063 perim=1.14
MI660 Q net83 net59 VNB sky130_fd_pr__pfet_01v8_hvt m=1 w=1.0u l=0.15u mult=1 sa=0.265
+ sb=0.265 sd=0.28 area=0.063 perim=1.14
MI45 clkpos CLK_N net59 VNB sky130_fd_pr__pfet_01v8_hvt m=1 w=0.64u l=0.15u mult=1
+ sa=0.265 sb=0.265 sd=0.28 area=0.063 perim=1.14
MI648 M1 M0 net59 VNB sky130_fd_pr__pfet_01v8_hvt m=1 w=0.84u l=0.15u mult=1 sa=0.265
+ sb=0.265 sd=0.28 area=0.063 perim=1.14
MI40 db D net59 VNB sky130_fd_pr__pfet_01v8_hvt m=1 w=0.42u l=0.15u mult=1 sa=0.265
+ sb=0.265 sd=0.28 area=0.063 perim=1.14
MI650 M1 clkneg net121 VNB sky130_fd_pr__pfet_01v8_hvt m=1 w=0.42u l=0.15u mult=1
+ sa=0.265 sb=0.265 sd=0.28 area=0.063 perim=1.14
.ENDS sky130_fd_sc_hd__dfrtn_1
* Copyright 2020 The SkyWater PDK Authors
*
* Licensed under the Apache License, Version 2.0 (the "License");
* you may not use this file except in compliance with the License.
* You may obtain a copy of the License at
*
*     https:  www.apache.org licenses LICENSE-2.0
*
* Unless required by applicable law or agreed to in writing, software
* distributed under the License is distributed on an "AS IS" BASIS,
* WITHOUT WARRANTIES OR CONDITIONS OF ANY KIND, either express or implied.
* See the License for the specific language governing permissions and
* limitations under the License.
*
* SPDX-License-Identifier: Apache-2.0

.SUBCKT sky130_fd_sc_hd__dfrtp_1 CLK D RESET_B VGND VNB VNB net59 Q
*.PININFO CLK:I D:I RESET_B:I VGND:I VNB:I VNB:I net59:I Q:O
MI46 clkpos clkneg VGND VNB sky130_fd_pr__nfet_01v8 m=1 w=0.42u l=0.15u mult=1
+ sa=0.265 sb=0.265 sd=0.28 area=0.063 perim=1.14
MI42 db clkneg M0 VNB sky130_fd_pr__nfet_01v8 m=1 w=0.36u l=0.15u mult=1 sa=0.265
+ sb=0.265 sd=0.28 area=0.063 perim=1.14
MI656 net82 s0 net108 VNB sky130_fd_pr__nfet_01v8 m=1 w=0.42u l=0.15u mult=1 sa=0.265
+ sb=0.265 sd=0.28 area=0.063 perim=1.14
MI657 net108 RESET_B VGND VNB sky130_fd_pr__nfet_01v8 m=1 w=0.42u l=0.15u mult=1
+ sa=0.265 sb=0.265 sd=0.28 area=0.063 perim=1.14
MI33 net101 RESET_B VGND VNB sky130_fd_pr__nfet_01v8 m=1 w=0.42u l=0.15u mult=1
+ sa=0.265 sb=0.265 sd=0.28 area=0.063 perim=1.14
MI4 M0 clkpos net93 VNB sky130_fd_pr__nfet_01v8 m=1 w=0.36u l=0.15u mult=1 sa=0.265
+ sb=0.265 sd=0.28 area=0.063 perim=1.14
MI34 net93 M1 net101 VNB sky130_fd_pr__nfet_01v8 m=1 w=0.42u l=0.15u mult=1 sa=0.265
+ sb=0.265 sd=0.28 area=0.063 perim=1.14
MI655 s0 clkneg net81 VNB sky130_fd_pr__nfet_01v8 m=1 w=0.36u l=0.15u mult=1 sa=0.265
+ sb=0.265 sd=0.28 area=0.063 perim=1.14
MI653 Q net82 VGND VNB sky130_fd_pr__nfet_01v8 m=1 w=0.65u l=0.15u mult=1 sa=0.265
+ sb=0.265 sd=0.28 area=0.063 perim=1.14
MI654 net81 net82 VGND VNB sky130_fd_pr__nfet_01v8 m=1 w=0.42u l=0.15u mult=1 sa=0.265
+ sb=0.265 sd=0.28 area=0.063 perim=1.14
MI44 clkneg CLK VGND VNB sky130_fd_pr__nfet_01v8 m=1 w=0.42u l=0.15u mult=1 sa=0.265
+ sb=0.265 sd=0.28 area=0.063 perim=1.14
MI647 M1 M0 VGND VNB sky130_fd_pr__nfet_01v8 m=1 w=0.64u l=0.15u mult=1 sa=0.265
+ sb=0.265 sd=0.28 area=0.063 perim=1.14
MI39 db D VGND VNB sky130_fd_pr__nfet_01v8 m=1 w=0.42u l=0.15u mult=1 sa=0.265
+ sb=0.265 sd=0.28 area=0.063 perim=1.14
MI649 M1 clkpos s0 VNB sky130_fd_pr__nfet_01v8 m=1 w=0.36u l=0.15u mult=1 sa=0.265
+ sb=0.265 sd=0.28 area=0.063 perim=1.14
MI47 clkpos clkneg net59 VNB sky130_fd_pr__pfet_01v8_hvt m=1 w=0.64u l=0.15u mult=1
+ sa=0.265 sb=0.265 sd=0.28 area=0.063 perim=1.14
MI43 db clkpos M0 VNB sky130_fd_pr__pfet_01v8_hvt m=1 w=0.42u l=0.15u mult=1 sa=0.265
+ sb=0.265 sd=0.28 area=0.063 perim=1.14
MI662 net165 net82 net59 VNB sky130_fd_pr__pfet_01v8_hvt m=1 w=0.42u l=0.15u mult=1
+ sa=0.265 sb=0.265 sd=0.28 area=0.063 perim=1.14
MI659 net82 RESET_B net59 VNB sky130_fd_pr__pfet_01v8_hvt m=1 w=0.42u l=0.15u mult=1
+ sa=0.265 sb=0.265 sd=0.28 area=0.063 perim=1.14
MI664 s0 clkpos net165 VNB sky130_fd_pr__pfet_01v8_hvt m=1 w=0.42u l=0.15u mult=1
+ sa=0.265 sb=0.265 sd=0.28 area=0.063 perim=1.14
MI658 net82 s0 net59 VNB sky130_fd_pr__pfet_01v8_hvt m=1 w=0.42u l=0.15u mult=1
+ sa=0.265 sb=0.265 sd=0.28 area=0.063 perim=1.14
MI30 net144 M1 net59 VNB sky130_fd_pr__pfet_01v8_hvt m=1 w=0.42u l=0.15u mult=1
+ sa=0.265 sb=0.265 sd=0.28 area=0.063 perim=1.14
MI31 M0 clkneg net144 VNB sky130_fd_pr__pfet_01v8_hvt m=1 w=0.42u l=0.15u mult=1
+ sa=0.265 sb=0.265 sd=0.28 area=0.063 perim=1.14
MI32 net144 RESET_B net59 VNB sky130_fd_pr__pfet_01v8_hvt m=1 w=0.42u l=0.15u mult=1
+ sa=0.265 sb=0.265 sd=0.28 area=0.063 perim=1.14
MI660 Q net82 net59 VNB sky130_fd_pr__pfet_01v8_hvt m=1 w=1.0u l=0.15u mult=1 sa=0.265
+ sb=0.265 sd=0.28 area=0.063 perim=1.14
MI45 clkneg CLK net59 VNB sky130_fd_pr__pfet_01v8_hvt m=1 w=0.64u l=0.15u mult=1
+ sa=0.265 sb=0.265 sd=0.28 area=0.063 perim=1.14
MI648 M1 M0 net59 VNB sky130_fd_pr__pfet_01v8_hvt m=1 w=0.84u l=0.15u mult=1 sa=0.265
+ sb=0.265 sd=0.28 area=0.063 perim=1.14
MI40 db D net59 VNB sky130_fd_pr__pfet_01v8_hvt m=1 w=0.42u l=0.15u mult=1 sa=0.265
+ sb=0.265 sd=0.28 area=0.063 perim=1.14
MI650 M1 clkneg s0 VNB sky130_fd_pr__pfet_01v8_hvt m=1 w=0.42u l=0.15u mult=1 sa=0.265
+ sb=0.265 sd=0.28 area=0.063 perim=1.14
.ENDS sky130_fd_sc_hd__dfrtp_1
* Copyright 2020 The SkyWater PDK Authors
*
* Licensed under the Apache License, Version 2.0 (the "License");
* you may not use this file except in compliance with the License.
* You may obtain a copy of the License at
*
*     https:  www.apache.org licenses LICENSE-2.0
*
* Unless required by applicable law or agreed to in writing, software
* distributed under the License is distributed on an "AS IS" BASIS,
* WITHOUT WARRANTIES OR CONDITIONS OF ANY KIND, either express or implied.
* See the License for the specific language governing permissions and
* limitations under the License.
*
* SPDX-License-Identifier: Apache-2.0

.SUBCKT sky130_fd_sc_hd__dfrtp_2 CLK D RESET_B VGND VNB VNB net59 Q
*.PININFO CLK:I D:I RESET_B:I VGND:I VNB:I VNB:I net59:I Q:O
MI46 clkpos clkneg VGND VNB sky130_fd_pr__nfet_01v8 m=1 w=0.42u l=0.15u mult=1
+ sa=0.265 sb=0.265 sd=0.28 area=0.063 perim=1.14
MI42 db clkneg M0 VNB sky130_fd_pr__nfet_01v8 m=1 w=0.36u l=0.15u mult=1 sa=0.265
+ sb=0.265 sd=0.28 area=0.063 perim=1.14
MI656 net82 s0 net108 VNB sky130_fd_pr__nfet_01v8 m=1 w=0.42u l=0.15u mult=1 sa=0.265
+ sb=0.265 sd=0.28 area=0.063 perim=1.14
MI657 net108 RESET_B VGND VNB sky130_fd_pr__nfet_01v8 m=1 w=0.42u l=0.15u mult=1
+ sa=0.265 sb=0.265 sd=0.28 area=0.063 perim=1.14
MI33 net101 RESET_B VGND VNB sky130_fd_pr__nfet_01v8 m=1 w=0.42u l=0.15u mult=1
+ sa=0.265 sb=0.265 sd=0.28 area=0.063 perim=1.14
MI4 M0 clkpos net93 VNB sky130_fd_pr__nfet_01v8 m=1 w=0.36u l=0.15u mult=1 sa=0.265
+ sb=0.265 sd=0.28 area=0.063 perim=1.14
MI34 net93 M1 net101 VNB sky130_fd_pr__nfet_01v8 m=1 w=0.42u l=0.15u mult=1 sa=0.265
+ sb=0.265 sd=0.28 area=0.063 perim=1.14
MI655 s0 clkneg net81 VNB sky130_fd_pr__nfet_01v8 m=1 w=0.36u l=0.15u mult=1 sa=0.265
+ sb=0.265 sd=0.28 area=0.063 perim=1.14
MI653 Q net82 VGND VNB sky130_fd_pr__nfet_01v8 m=2 w=0.65u l=0.15u mult=1 sa=0.265
+ sb=0.265 sd=0.28 area=0.063 perim=1.14
MI654 net81 net82 VGND VNB sky130_fd_pr__nfet_01v8 m=1 w=0.42u l=0.15u mult=1 sa=0.265
+ sb=0.265 sd=0.28 area=0.063 perim=1.14
MI44 clkneg CLK VGND VNB sky130_fd_pr__nfet_01v8 m=1 w=0.42u l=0.15u mult=1 sa=0.265
+ sb=0.265 sd=0.28 area=0.063 perim=1.14
MI647 M1 M0 VGND VNB sky130_fd_pr__nfet_01v8 m=1 w=0.64u l=0.15u mult=1 sa=0.265
+ sb=0.265 sd=0.28 area=0.063 perim=1.14
MI39 db D VGND VNB sky130_fd_pr__nfet_01v8 m=1 w=0.42u l=0.15u mult=1 sa=0.265
+ sb=0.265 sd=0.28 area=0.063 perim=1.14
MI649 M1 clkpos s0 VNB sky130_fd_pr__nfet_01v8 m=1 w=0.36u l=0.15u mult=1 sa=0.265
+ sb=0.265 sd=0.28 area=0.063 perim=1.14
MI47 clkpos clkneg net59 VNB sky130_fd_pr__pfet_01v8_hvt m=1 w=0.64u l=0.15u mult=1
+ sa=0.265 sb=0.265 sd=0.28 area=0.063 perim=1.14
MI43 db clkpos M0 VNB sky130_fd_pr__pfet_01v8_hvt m=1 w=0.42u l=0.15u mult=1 sa=0.265
+ sb=0.265 sd=0.28 area=0.063 perim=1.14
MI662 net156 net82 net59 VNB sky130_fd_pr__pfet_01v8_hvt m=1 w=0.42u l=0.15u mult=1
+ sa=0.265 sb=0.265 sd=0.28 area=0.063 perim=1.14
MI659 net82 RESET_B net59 VNB sky130_fd_pr__pfet_01v8_hvt m=1 w=0.42u l=0.15u mult=1
+ sa=0.265 sb=0.265 sd=0.28 area=0.063 perim=1.14
MI664 s0 clkpos net156 VNB sky130_fd_pr__pfet_01v8_hvt m=1 w=0.42u l=0.15u mult=1
+ sa=0.265 sb=0.265 sd=0.28 area=0.063 perim=1.14
MI658 net82 s0 net59 VNB sky130_fd_pr__pfet_01v8_hvt m=1 w=0.42u l=0.15u mult=1
+ sa=0.265 sb=0.265 sd=0.28 area=0.063 perim=1.14
MI30 net144 M1 net59 VNB sky130_fd_pr__pfet_01v8_hvt m=1 w=0.42u l=0.15u mult=1
+ sa=0.265 sb=0.265 sd=0.28 area=0.063 perim=1.14
MI31 M0 clkneg net144 VNB sky130_fd_pr__pfet_01v8_hvt m=1 w=0.42u l=0.15u mult=1
+ sa=0.265 sb=0.265 sd=0.28 area=0.063 perim=1.14
MI32 net144 RESET_B net59 VNB sky130_fd_pr__pfet_01v8_hvt m=1 w=0.42u l=0.15u mult=1
+ sa=0.265 sb=0.265 sd=0.28 area=0.063 perim=1.14
MI660 Q net82 net59 VNB sky130_fd_pr__pfet_01v8_hvt m=2 w=1.0u l=0.15u mult=1 sa=0.265
+ sb=0.265 sd=0.28 area=0.063 perim=1.14
MI45 clkneg CLK net59 VNB sky130_fd_pr__pfet_01v8_hvt m=1 w=0.64u l=0.15u mult=1
+ sa=0.265 sb=0.265 sd=0.28 area=0.063 perim=1.14
MI648 M1 M0 net59 VNB sky130_fd_pr__pfet_01v8_hvt m=1 w=0.84u l=0.15u mult=1 sa=0.265
+ sb=0.265 sd=0.28 area=0.063 perim=1.14
MI40 db D net59 VNB sky130_fd_pr__pfet_01v8_hvt m=1 w=0.42u l=0.15u mult=1 sa=0.265
+ sb=0.265 sd=0.28 area=0.063 perim=1.14
MI650 M1 clkneg s0 VNB sky130_fd_pr__pfet_01v8_hvt m=1 w=0.42u l=0.15u mult=1 sa=0.265
+ sb=0.265 sd=0.28 area=0.063 perim=1.14
.ENDS sky130_fd_sc_hd__dfrtp_2
* Copyright 2020 The SkyWater PDK Authors
*
* Licensed under the Apache License, Version 2.0 (the "License");
* you may not use this file except in compliance with the License.
* You may obtain a copy of the License at
*
*     https:  www.apache.org licenses LICENSE-2.0
*
* Unless required by applicable law or agreed to in writing, software
* distributed under the License is distributed on an "AS IS" BASIS,
* WITHOUT WARRANTIES OR CONDITIONS OF ANY KIND, either express or implied.
* See the License for the specific language governing permissions and
* limitations under the License.
*
* SPDX-License-Identifier: Apache-2.0

.SUBCKT sky130_fd_sc_hd__dfrtp_4 CLK D RESET_B VGND VNB VNB net59 Q
*.PININFO CLK:I D:I RESET_B:I VGND:I VNB:I VNB:I net59:I Q:O
MI46 clkpos clkneg VGND VNB sky130_fd_pr__nfet_01v8 m=1 w=0.42u l=0.15u mult=1
+ sa=0.265 sb=0.265 sd=0.28 area=0.063 perim=1.14
MI42 db clkneg M0 VNB sky130_fd_pr__nfet_01v8 m=1 w=0.36u l=0.15u mult=1 sa=0.265
+ sb=0.265 sd=0.28 area=0.063 perim=1.14
MI656 net82 s0 net108 VNB sky130_fd_pr__nfet_01v8 m=1 w=0.42u l=0.15u mult=1 sa=0.265
+ sb=0.265 sd=0.28 area=0.063 perim=1.14
MI657 net108 RESET_B VGND VNB sky130_fd_pr__nfet_01v8 m=1 w=0.42u l=0.15u mult=1
+ sa=0.265 sb=0.265 sd=0.28 area=0.063 perim=1.14
MI33 net101 RESET_B VGND VNB sky130_fd_pr__nfet_01v8 m=1 w=0.42u l=0.15u mult=1
+ sa=0.265 sb=0.265 sd=0.28 area=0.063 perim=1.14
MI4 M0 clkpos net93 VNB sky130_fd_pr__nfet_01v8 m=1 w=0.36u l=0.15u mult=1 sa=0.265
+ sb=0.265 sd=0.28 area=0.063 perim=1.14
MI34 net93 M1 net101 VNB sky130_fd_pr__nfet_01v8 m=1 w=0.42u l=0.15u mult=1 sa=0.265
+ sb=0.265 sd=0.28 area=0.063 perim=1.14
MI655 s0 clkneg net81 VNB sky130_fd_pr__nfet_01v8 m=1 w=0.36u l=0.15u mult=1 sa=0.265
+ sb=0.265 sd=0.28 area=0.063 perim=1.14
MI653 Q net82 VGND VNB sky130_fd_pr__nfet_01v8 m=4 w=0.65u l=0.15u mult=1 sa=0.265
+ sb=0.265 sd=0.28 area=0.063 perim=1.14
MI654 net81 net82 VGND VNB sky130_fd_pr__nfet_01v8 m=1 w=0.42u l=0.15u mult=1 sa=0.265
+ sb=0.265 sd=0.28 area=0.063 perim=1.14
MI44 clkneg CLK VGND VNB sky130_fd_pr__nfet_01v8 m=1 w=0.42u l=0.15u mult=1 sa=0.265
+ sb=0.265 sd=0.28 area=0.063 perim=1.14
MI647 M1 M0 VGND VNB sky130_fd_pr__nfet_01v8 m=1 w=0.64u l=0.15u mult=1 sa=0.265
+ sb=0.265 sd=0.28 area=0.063 perim=1.14
MI39 db D VGND VNB sky130_fd_pr__nfet_01v8 m=1 w=0.42u l=0.15u mult=1 sa=0.265
+ sb=0.265 sd=0.28 area=0.063 perim=1.14
MI649 M1 clkpos s0 VNB sky130_fd_pr__nfet_01v8 m=1 w=0.36u l=0.15u mult=1 sa=0.265
+ sb=0.265 sd=0.28 area=0.063 perim=1.14
MI47 clkpos clkneg net59 VNB sky130_fd_pr__pfet_01v8_hvt m=1 w=0.64u l=0.15u mult=1
+ sa=0.265 sb=0.265 sd=0.28 area=0.063 perim=1.14
MI43 db clkpos M0 VNB sky130_fd_pr__pfet_01v8_hvt m=1 w=0.42u l=0.15u mult=1 sa=0.265
+ sb=0.265 sd=0.28 area=0.063 perim=1.14
MI662 net165 net82 net59 VNB sky130_fd_pr__pfet_01v8_hvt m=1 w=0.42u l=0.15u mult=1
+ sa=0.265 sb=0.265 sd=0.28 area=0.063 perim=1.14
MI659 net82 RESET_B net59 VNB sky130_fd_pr__pfet_01v8_hvt m=1 w=0.42u l=0.15u mult=1
+ sa=0.265 sb=0.265 sd=0.28 area=0.063 perim=1.14
MI664 s0 clkpos net165 VNB sky130_fd_pr__pfet_01v8_hvt m=1 w=0.42u l=0.15u mult=1
+ sa=0.265 sb=0.265 sd=0.28 area=0.063 perim=1.14
MI658 net82 s0 net59 VNB sky130_fd_pr__pfet_01v8_hvt m=1 w=0.42u l=0.15u mult=1
+ sa=0.265 sb=0.265 sd=0.28 area=0.063 perim=1.14
MI30 net144 M1 net59 VNB sky130_fd_pr__pfet_01v8_hvt m=1 w=0.42u l=0.15u mult=1
+ sa=0.265 sb=0.265 sd=0.28 area=0.063 perim=1.14
MI31 M0 clkneg net144 VNB sky130_fd_pr__pfet_01v8_hvt m=1 w=0.42u l=0.15u mult=1
+ sa=0.265 sb=0.265 sd=0.28 area=0.063 perim=1.14
MI32 net144 RESET_B net59 VNB sky130_fd_pr__pfet_01v8_hvt m=1 w=0.42u l=0.15u mult=1
+ sa=0.265 sb=0.265 sd=0.28 area=0.063 perim=1.14
MI660 Q net82 net59 VNB sky130_fd_pr__pfet_01v8_hvt m=4 w=1.0u l=0.15u mult=1 sa=0.265
+ sb=0.265 sd=0.28 area=0.063 perim=1.14
MI45 clkneg CLK net59 VNB sky130_fd_pr__pfet_01v8_hvt m=1 w=0.64u l=0.15u mult=1
+ sa=0.265 sb=0.265 sd=0.28 area=0.063 perim=1.14
MI648 M1 M0 net59 VNB sky130_fd_pr__pfet_01v8_hvt m=1 w=0.84u l=0.15u mult=1 sa=0.265
+ sb=0.265 sd=0.28 area=0.063 perim=1.14
MI40 db D net59 VNB sky130_fd_pr__pfet_01v8_hvt m=1 w=0.42u l=0.15u mult=1 sa=0.265
+ sb=0.265 sd=0.28 area=0.063 perim=1.14
MI650 M1 clkneg s0 VNB sky130_fd_pr__pfet_01v8_hvt m=1 w=0.42u l=0.15u mult=1 sa=0.265
+ sb=0.265 sd=0.28 area=0.063 perim=1.14
.ENDS sky130_fd_sc_hd__dfrtp_4
* Copyright 2020 The SkyWater PDK Authors
*
* Licensed under the Apache License, Version 2.0 (the "License");
* you may not use this file except in compliance with the License.
* You may obtain a copy of the License at
*
*     https:  www.apache.org licenses LICENSE-2.0
*
* Unless required by applicable law or agreed to in writing, software
* distributed under the License is distributed on an "AS IS" BASIS,
* WITHOUT WARRANTIES OR CONDITIONS OF ANY KIND, either express or implied.
* See the License for the specific language governing permissions and
* limitations under the License.
*
* SPDX-License-Identifier: Apache-2.0

.SUBCKT sky130_fd_sc_hd__dfsbp_1 CLK D SET_B VGND VNB VNB net59 Q Q_N
*.PININFO CLK:I D:I SET_B:I VGND:I VNB:I VNB:I net59:I Q:O Q_N:O
MI36 net129 M0 VGND VNB sky130_fd_pr__nfet_01v8 m=1 w=0.42u l=0.15u mult=1 sa=0.265
+ sb=0.265 sd=0.28 area=0.063 perim=1.14
MI42 db clkneg M0 VNB sky130_fd_pr__nfet_01v8 m=1 w=0.36u l=0.15u mult=1 sa=0.265
+ sb=0.265 sd=0.28 area=0.063 perim=1.14
MI44 clkneg CLK VGND VNB sky130_fd_pr__nfet_01v8 m=1 w=0.42u l=0.15u mult=1 sa=0.265
+ sb=0.265 sd=0.28 area=0.063 perim=1.14
MI39 db D VGND VNB sky130_fd_pr__nfet_01v8 m=1 w=0.64u l=0.15u mult=1 sa=0.265
+ sb=0.265 sd=0.28 area=0.063 perim=1.14
MI656 M1 M0 net112 VNB sky130_fd_pr__nfet_01v8 m=1 w=0.42u l=0.15u mult=1 sa=0.265
+ sb=0.265 sd=0.28 area=0.063 perim=1.14
MI654 net80 M1 VGND VNB sky130_fd_pr__nfet_01v8 m=1 w=0.42u l=0.15u mult=1 sa=0.265
+ sb=0.265 sd=0.28 area=0.063 perim=1.14
MI34 S0 clkpos net129 VNB sky130_fd_pr__nfet_01v8 m=1 w=0.42u l=0.15u mult=1 sa=0.265
+ sb=0.265 sd=0.28 area=0.063 perim=1.14
MI46 clkpos clkneg VGND VNB sky130_fd_pr__nfet_01v8 m=1 w=0.42u l=0.15u mult=1
+ sa=0.265 sb=0.265 sd=0.28 area=0.063 perim=1.14
MI25 net97 SET_B VGND VNB sky130_fd_pr__nfet_01v8 m=1 w=0.42u l=0.15u mult=1 sa=0.265
+ sb=0.265 sd=0.28 area=0.063 perim=1.14
MI26 S0 clkneg net89 VNB sky130_fd_pr__nfet_01v8 m=1 w=0.42u l=0.15u mult=1 sa=0.265
+ sb=0.265 sd=0.28 area=0.063 perim=1.14
MI27 net89 S1 net97 VNB sky130_fd_pr__nfet_01v8 m=1 w=0.42u l=0.15u mult=1 sa=0.265
+ sb=0.265 sd=0.28 area=0.063 perim=1.14
MI647 S1 S0 VGND VNB sky130_fd_pr__nfet_01v8 m=1 w=0.54u l=0.15u mult=1 sa=0.265
+ sb=0.265 sd=0.28 area=0.063 perim=1.14
MI655 M0 clkpos net80 VNB sky130_fd_pr__nfet_01v8 m=1 w=0.36u l=0.15u mult=1 sa=0.265
+ sb=0.265 sd=0.28 area=0.063 perim=1.14
MI657 net112 SET_B VGND VNB sky130_fd_pr__nfet_01v8 m=1 w=0.42u l=0.15u mult=1
+ sa=0.265 sb=0.265 sd=0.28 area=0.063 perim=1.14
MI652 net141 S0 VGND VNB sky130_fd_pr__nfet_01v8 m=1 w=0.42u l=0.15u mult=1 sa=0.265
+ sb=0.265 sd=0.28 area=0.063 perim=1.14
MI653 Q net141 VGND VNB sky130_fd_pr__nfet_01v8 m=1 w=0.65u l=0.15u mult=1 sa=0.265
+ sb=0.265 sd=0.28 area=0.063 perim=1.14
MI49 Q_N S0 VGND VNB sky130_fd_pr__nfet_01v8 m=1 w=0.65u l=0.15u mult=1 sa=0.265
+ sb=0.265 sd=0.28 area=0.063 perim=1.14
MI40 db D net59 VNB sky130_fd_pr__pfet_01v8_hvt m=1 w=0.84u l=0.15u mult=1 sa=0.265
+ sb=0.265 sd=0.28 area=0.063 perim=1.14
MI38 S0 clkneg net192 VNB sky130_fd_pr__pfet_01v8_hvt m=1 w=0.42u l=0.15u mult=1
+ sa=0.265 sb=0.265 sd=0.28 area=0.063 perim=1.14
MI37 net192 M0 net59 VNB sky130_fd_pr__pfet_01v8_hvt m=1 w=0.42u l=0.15u mult=1
+ sa=0.265 sb=0.265 sd=0.28 area=0.063 perim=1.14
MI43 db clkpos M0 VNB sky130_fd_pr__pfet_01v8_hvt m=1 w=0.42u l=0.15u mult=1 sa=0.265
+ sb=0.265 sd=0.28 area=0.063 perim=1.14
MI45 clkneg CLK net59 VNB sky130_fd_pr__pfet_01v8_hvt m=1 w=0.64u l=0.15u mult=1
+ sa=0.265 sb=0.265 sd=0.28 area=0.063 perim=1.14
MI47 clkpos clkneg net59 VNB sky130_fd_pr__pfet_01v8_hvt m=1 w=0.64u l=0.15u mult=1
+ sa=0.265 sb=0.265 sd=0.28 area=0.063 perim=1.14
MI659 M1 SET_B net59 VNB sky130_fd_pr__pfet_01v8_hvt m=1 w=0.42u l=0.15u mult=1
+ sa=0.265 sb=0.265 sd=0.28 area=0.063 perim=1.14
MI662 net169 M1 net59 VNB sky130_fd_pr__pfet_01v8_hvt m=1 w=0.42u l=0.15u mult=1
+ sa=0.265 sb=0.265 sd=0.28 area=0.063 perim=1.14
MI664 M0 clkneg net169 VNB sky130_fd_pr__pfet_01v8_hvt m=1 w=0.42u l=0.15u mult=1
+ sa=0.265 sb=0.265 sd=0.28 area=0.063 perim=1.14
MI6 net156 S1 net59 VNB sky130_fd_pr__pfet_01v8_hvt m=1 w=0.42u l=0.15u mult=1 sa=0.265
+ sb=0.265 sd=0.28 area=0.063 perim=1.14
MI5 S0 clkpos net156 VNB sky130_fd_pr__pfet_01v8_hvt m=1 w=0.42u l=0.15u mult=1
+ sa=0.265 sb=0.265 sd=0.28 area=0.063 perim=1.14
MI24 S0 SET_B net59 VNB sky130_fd_pr__pfet_01v8_hvt m=1 w=0.42u l=0.15u mult=1 sa=0.265
+ sb=0.265 sd=0.28 area=0.063 perim=1.14
MI648 S1 S0 net59 VNB sky130_fd_pr__pfet_01v8_hvt m=1 w=0.84u l=0.15u mult=1 sa=0.265
+ sb=0.265 sd=0.28 area=0.063 perim=1.14
MI658 M1 M0 net59 VNB sky130_fd_pr__pfet_01v8_hvt m=1 w=0.42u l=0.15u mult=1 sa=0.265
+ sb=0.265 sd=0.28 area=0.063 perim=1.14
MI663 net141 S0 net59 VNB sky130_fd_pr__pfet_01v8_hvt m=1 w=0.64u l=0.15u mult=1
+ sa=0.265 sb=0.265 sd=0.28 area=0.063 perim=1.14
MI660 Q net141 net59 VNB sky130_fd_pr__pfet_01v8_hvt m=1 w=1.0u l=0.15u mult=1 sa=0.265
+ sb=0.265 sd=0.28 area=0.063 perim=1.14
MI50 Q_N S0 net59 VNB sky130_fd_pr__pfet_01v8_hvt m=1 w=1.0u l=0.15u mult=1 sa=0.265
+ sb=0.265 sd=0.28 area=0.063 perim=1.14
.ENDS sky130_fd_sc_hd__dfsbp_1
* Copyright 2020 The SkyWater PDK Authors
*
* Licensed under the Apache License, Version 2.0 (the "License");
* you may not use this file except in compliance with the License.
* You may obtain a copy of the License at
*
*     https:  www.apache.org licenses LICENSE-2.0
*
* Unless required by applicable law or agreed to in writing, software
* distributed under the License is distributed on an "AS IS" BASIS,
* WITHOUT WARRANTIES OR CONDITIONS OF ANY KIND, either express or implied.
* See the License for the specific language governing permissions and
* limitations under the License.
*
* SPDX-License-Identifier: Apache-2.0

.SUBCKT sky130_fd_sc_hd__dfsbp_2 CLK D SET_B VGND VNB VNB net59 Q Q_N
*.PININFO CLK:I D:I SET_B:I VGND:I VNB:I VNB:I net59:I Q:O Q_N:O
MI36 net128 M0 VGND VNB sky130_fd_pr__nfet_01v8 m=1 w=0.42u l=0.15u mult=1 sa=0.265
+ sb=0.265 sd=0.28 area=0.063 perim=1.14
MI42 db clkneg M0 VNB sky130_fd_pr__nfet_01v8 m=1 w=0.36u l=0.15u mult=1 sa=0.265
+ sb=0.265 sd=0.28 area=0.063 perim=1.14
MI44 clkneg CLK VGND VNB sky130_fd_pr__nfet_01v8 m=1 w=0.42u l=0.15u mult=1 sa=0.265
+ sb=0.265 sd=0.28 area=0.063 perim=1.14
MI39 db D VGND VNB sky130_fd_pr__nfet_01v8 m=1 w=0.64u l=0.15u mult=1 sa=0.265
+ sb=0.265 sd=0.28 area=0.063 perim=1.14
MI656 M1 M0 net111 VNB sky130_fd_pr__nfet_01v8 m=1 w=0.42u l=0.15u mult=1 sa=0.265
+ sb=0.265 sd=0.28 area=0.063 perim=1.14
MI654 net79 M1 VGND VNB sky130_fd_pr__nfet_01v8 m=1 w=0.42u l=0.15u mult=1 sa=0.265
+ sb=0.265 sd=0.28 area=0.063 perim=1.14
MI34 S0 clkpos net128 VNB sky130_fd_pr__nfet_01v8 m=1 w=0.42u l=0.15u mult=1 sa=0.265
+ sb=0.265 sd=0.28 area=0.063 perim=1.14
MI46 clkpos clkneg VGND VNB sky130_fd_pr__nfet_01v8 m=1 w=0.42u l=0.15u mult=1
+ sa=0.265 sb=0.265 sd=0.28 area=0.063 perim=1.14
MI25 net96 SET_B VGND VNB sky130_fd_pr__nfet_01v8 m=1 w=0.42u l=0.15u mult=1 sa=0.265
+ sb=0.265 sd=0.28 area=0.063 perim=1.14
MI26 S0 clkneg net88 VNB sky130_fd_pr__nfet_01v8 m=1 w=0.42u l=0.15u mult=1 sa=0.265
+ sb=0.265 sd=0.28 area=0.063 perim=1.14
MI27 net88 S1 net96 VNB sky130_fd_pr__nfet_01v8 m=1 w=0.42u l=0.15u mult=1 sa=0.265
+ sb=0.265 sd=0.28 area=0.063 perim=1.14
MI647 S1 S0 VGND VNB sky130_fd_pr__nfet_01v8 m=1 w=0.54u l=0.15u mult=1 sa=0.265
+ sb=0.265 sd=0.28 area=0.063 perim=1.14
MI655 M0 clkpos net79 VNB sky130_fd_pr__nfet_01v8 m=1 w=0.36u l=0.15u mult=1 sa=0.265
+ sb=0.265 sd=0.28 area=0.063 perim=1.14
MI657 net111 SET_B VGND VNB sky130_fd_pr__nfet_01v8 m=1 w=0.42u l=0.15u mult=1
+ sa=0.265 sb=0.265 sd=0.28 area=0.063 perim=1.14
MI652 net140 S0 VGND VNB sky130_fd_pr__nfet_01v8 m=1 w=0.65u l=0.15u mult=1 sa=0.265
+ sb=0.265 sd=0.28 area=0.063 perim=1.14
MI653 Q net140 VGND VNB sky130_fd_pr__nfet_01v8 m=2 w=0.65u l=0.15u mult=1 sa=0.265
+ sb=0.265 sd=0.28 area=0.063 perim=1.14
MI49 Q_N S0 VGND VNB sky130_fd_pr__nfet_01v8 m=2 w=0.65u l=0.15u mult=1 sa=0.265
+ sb=0.265 sd=0.28 area=0.063 perim=1.14
MI40 db D net59 VNB sky130_fd_pr__pfet_01v8_hvt m=1 w=0.84u l=0.15u mult=1 sa=0.265
+ sb=0.265 sd=0.28 area=0.063 perim=1.14
MI38 S0 clkneg net191 VNB sky130_fd_pr__pfet_01v8_hvt m=1 w=0.42u l=0.15u mult=1
+ sa=0.265 sb=0.265 sd=0.28 area=0.063 perim=1.14
MI37 net191 M0 net59 VNB sky130_fd_pr__pfet_01v8_hvt m=1 w=0.42u l=0.15u mult=1
+ sa=0.265 sb=0.265 sd=0.28 area=0.063 perim=1.14
MI43 db clkpos M0 VNB sky130_fd_pr__pfet_01v8_hvt m=1 w=0.42u l=0.15u mult=1 sa=0.265
+ sb=0.265 sd=0.28 area=0.063 perim=1.14
MI45 clkneg CLK net59 VNB sky130_fd_pr__pfet_01v8_hvt m=1 w=0.64u l=0.15u mult=1
+ sa=0.265 sb=0.265 sd=0.28 area=0.063 perim=1.14
MI47 clkpos clkneg net59 VNB sky130_fd_pr__pfet_01v8_hvt m=1 w=0.64u l=0.15u mult=1
+ sa=0.265 sb=0.265 sd=0.28 area=0.063 perim=1.14
MI659 M1 SET_B net59 VNB sky130_fd_pr__pfet_01v8_hvt m=1 w=0.42u l=0.15u mult=1
+ sa=0.265 sb=0.265 sd=0.28 area=0.063 perim=1.14
MI662 net168 M1 net59 VNB sky130_fd_pr__pfet_01v8_hvt m=1 w=0.42u l=0.15u mult=1
+ sa=0.265 sb=0.265 sd=0.28 area=0.063 perim=1.14
MI664 M0 clkneg net168 VNB sky130_fd_pr__pfet_01v8_hvt m=1 w=0.42u l=0.15u mult=1
+ sa=0.265 sb=0.265 sd=0.28 area=0.063 perim=1.14
MI6 net155 S1 net59 VNB sky130_fd_pr__pfet_01v8_hvt m=1 w=0.42u l=0.15u mult=1 sa=0.265
+ sb=0.265 sd=0.28 area=0.063 perim=1.14
MI5 S0 clkpos net155 VNB sky130_fd_pr__pfet_01v8_hvt m=1 w=0.42u l=0.15u mult=1
+ sa=0.265 sb=0.265 sd=0.28 area=0.063 perim=1.14
MI24 S0 SET_B net59 VNB sky130_fd_pr__pfet_01v8_hvt m=1 w=0.42u l=0.15u mult=1 sa=0.265
+ sb=0.265 sd=0.28 area=0.063 perim=1.14
MI648 S1 S0 net59 VNB sky130_fd_pr__pfet_01v8_hvt m=1 w=0.84u l=0.15u mult=1 sa=0.265
+ sb=0.265 sd=0.28 area=0.063 perim=1.14
MI658 M1 M0 net59 VNB sky130_fd_pr__pfet_01v8_hvt m=1 w=0.42u l=0.15u mult=1 sa=0.265
+ sb=0.265 sd=0.28 area=0.063 perim=1.14
MI663 net140 S0 net59 VNB sky130_fd_pr__pfet_01v8_hvt m=1 w=1.0u l=0.15u mult=1
+ sa=0.265 sb=0.265 sd=0.28 area=0.063 perim=1.14
MI660 Q net140 net59 VNB sky130_fd_pr__pfet_01v8_hvt m=2 w=1.0u l=0.15u mult=1 sa=0.265
+ sb=0.265 sd=0.28 area=0.063 perim=1.14
MI50 Q_N S0 net59 VNB sky130_fd_pr__pfet_01v8_hvt m=2 w=1.0u l=0.15u mult=1 sa=0.265
+ sb=0.265 sd=0.28 area=0.063 perim=1.14
.ENDS sky130_fd_sc_hd__dfsbp_2
* Copyright 2020 The SkyWater PDK Authors
*
* Licensed under the Apache License, Version 2.0 (the "License");
* you may not use this file except in compliance with the License.
* You may obtain a copy of the License at
*
*     https:  www.apache.org licenses LICENSE-2.0
*
* Unless required by applicable law or agreed to in writing, software
* distributed under the License is distributed on an "AS IS" BASIS,
* WITHOUT WARRANTIES OR CONDITIONS OF ANY KIND, either express or implied.
* See the License for the specific language governing permissions and
* limitations under the License.
*
* SPDX-License-Identifier: Apache-2.0

.SUBCKT sky130_fd_sc_hd__dfstp_1 CLK D SET_B VGND VNB VNB net59 Q
*.PININFO CLK:I D:I SET_B:I VGND:I VNB:I VNB:I net59:I Q:O
MI36 net120 M0 VGND VNB sky130_fd_pr__nfet_01v8 m=1 w=0.42u l=0.15u mult=1 sa=0.265
+ sb=0.265 sd=0.28 area=0.063 perim=1.14
MI42 db clkneg M0 VNB sky130_fd_pr__nfet_01v8 m=1 w=0.36u l=0.15u mult=1 sa=0.265
+ sb=0.265 sd=0.28 area=0.063 perim=1.14
MI44 clkneg CLK VGND VNB sky130_fd_pr__nfet_01v8 m=1 w=0.42u l=0.15u mult=1 sa=0.265
+ sb=0.265 sd=0.28 area=0.063 perim=1.14
MI39 db D VGND VNB sky130_fd_pr__nfet_01v8 m=1 w=0.64u l=0.15u mult=1 sa=0.265
+ sb=0.265 sd=0.28 area=0.063 perim=1.14
MI656 M1 M0 net103 VNB sky130_fd_pr__nfet_01v8 m=1 w=0.42u l=0.15u mult=1 sa=0.265
+ sb=0.265 sd=0.28 area=0.063 perim=1.14
MI654 net71 M1 VGND VNB sky130_fd_pr__nfet_01v8 m=1 w=0.42u l=0.15u mult=1 sa=0.265
+ sb=0.265 sd=0.28 area=0.063 perim=1.14
MI34 S0 clkpos net120 VNB sky130_fd_pr__nfet_01v8 m=1 w=0.42u l=0.15u mult=1 sa=0.265
+ sb=0.265 sd=0.28 area=0.063 perim=1.14
MI46 clkpos clkneg VGND VNB sky130_fd_pr__nfet_01v8 m=1 w=0.42u l=0.15u mult=1
+ sa=0.265 sb=0.265 sd=0.28 area=0.063 perim=1.14
MI25 net88 SET_B VGND VNB sky130_fd_pr__nfet_01v8 m=1 w=0.42u l=0.15u mult=1 sa=0.265
+ sb=0.265 sd=0.28 area=0.063 perim=1.14
MI26 S0 clkneg net80 VNB sky130_fd_pr__nfet_01v8 m=1 w=0.42u l=0.15u mult=1 sa=0.265
+ sb=0.265 sd=0.28 area=0.063 perim=1.14
MI27 net80 S1 net88 VNB sky130_fd_pr__nfet_01v8 m=1 w=0.42u l=0.15u mult=1 sa=0.265
+ sb=0.265 sd=0.28 area=0.063 perim=1.14
MI647 S1 S0 VGND VNB sky130_fd_pr__nfet_01v8 m=1 w=0.54u l=0.15u mult=1 sa=0.265
+ sb=0.265 sd=0.28 area=0.063 perim=1.14
MI655 M0 clkpos net71 VNB sky130_fd_pr__nfet_01v8 m=1 w=0.36u l=0.15u mult=1 sa=0.265
+ sb=0.265 sd=0.28 area=0.063 perim=1.14
MI657 net103 SET_B VGND VNB sky130_fd_pr__nfet_01v8 m=1 w=0.42u l=0.15u mult=1
+ sa=0.265 sb=0.265 sd=0.28 area=0.063 perim=1.14
MI652 net128 S0 VGND VNB sky130_fd_pr__nfet_01v8 m=1 w=0.42u l=0.15u mult=1 sa=0.265
+ sb=0.265 sd=0.28 area=0.063 perim=1.14
MI653 Q net128 VGND VNB sky130_fd_pr__nfet_01v8 m=1 w=0.65u l=0.15u mult=1 sa=0.265
+ sb=0.265 sd=0.28 area=0.063 perim=1.14
MI40 db D net59 VNB sky130_fd_pr__pfet_01v8_hvt m=1 w=0.84u l=0.15u mult=1 sa=0.265
+ sb=0.265 sd=0.28 area=0.063 perim=1.14
MI38 S0 clkneg net179 VNB sky130_fd_pr__pfet_01v8_hvt m=1 w=0.42u l=0.15u mult=1
+ sa=0.265 sb=0.265 sd=0.28 area=0.063 perim=1.14
MI37 net179 M0 net59 VNB sky130_fd_pr__pfet_01v8_hvt m=1 w=0.42u l=0.15u mult=1
+ sa=0.265 sb=0.265 sd=0.28 area=0.063 perim=1.14
MI43 db clkpos M0 VNB sky130_fd_pr__pfet_01v8_hvt m=1 w=0.42u l=0.15u mult=1 sa=0.265
+ sb=0.265 sd=0.28 area=0.063 perim=1.14
MI45 clkneg CLK net59 VNB sky130_fd_pr__pfet_01v8_hvt m=1 w=0.64u l=0.15u mult=1
+ sa=0.265 sb=0.265 sd=0.28 area=0.063 perim=1.14
MI47 clkpos clkneg net59 VNB sky130_fd_pr__pfet_01v8_hvt m=1 w=0.64u l=0.15u mult=1
+ sa=0.265 sb=0.265 sd=0.28 area=0.063 perim=1.14
MI659 M1 SET_B net59 VNB sky130_fd_pr__pfet_01v8_hvt m=1 w=0.42u l=0.15u mult=1
+ sa=0.265 sb=0.265 sd=0.28 area=0.063 perim=1.14
MI662 net156 M1 net59 VNB sky130_fd_pr__pfet_01v8_hvt m=1 w=0.42u l=0.15u mult=1
+ sa=0.265 sb=0.265 sd=0.28 area=0.063 perim=1.14
MI664 M0 clkneg net156 VNB sky130_fd_pr__pfet_01v8_hvt m=1 w=0.42u l=0.15u mult=1
+ sa=0.265 sb=0.265 sd=0.28 area=0.063 perim=1.14
MI6 net143 S1 net59 VNB sky130_fd_pr__pfet_01v8_hvt m=1 w=0.42u l=0.15u mult=1 sa=0.265
+ sb=0.265 sd=0.28 area=0.063 perim=1.14
MI5 S0 clkpos net143 VNB sky130_fd_pr__pfet_01v8_hvt m=1 w=0.42u l=0.15u mult=1
+ sa=0.265 sb=0.265 sd=0.28 area=0.063 perim=1.14
MI24 S0 SET_B net59 VNB sky130_fd_pr__pfet_01v8_hvt m=1 w=0.42u l=0.15u mult=1 sa=0.265
+ sb=0.265 sd=0.28 area=0.063 perim=1.14
MI648 S1 S0 net59 VNB sky130_fd_pr__pfet_01v8_hvt m=1 w=0.84u l=0.15u mult=1 sa=0.265
+ sb=0.265 sd=0.28 area=0.063 perim=1.14
MI658 M1 M0 net59 VNB sky130_fd_pr__pfet_01v8_hvt m=1 w=0.42u l=0.15u mult=1 sa=0.265
+ sb=0.265 sd=0.28 area=0.063 perim=1.14
MI663 net128 S0 net59 VNB sky130_fd_pr__pfet_01v8_hvt m=1 w=0.64u l=0.15u mult=1
+ sa=0.265 sb=0.265 sd=0.28 area=0.063 perim=1.14
MI660 Q net128 net59 VNB sky130_fd_pr__pfet_01v8_hvt m=1 w=1.0u l=0.15u mult=1 sa=0.265
+ sb=0.265 sd=0.28 area=0.063 perim=1.14
.ENDS sky130_fd_sc_hd__dfstp_1
* Copyright 2020 The SkyWater PDK Authors
*
* Licensed under the Apache License, Version 2.0 (the "License");
* you may not use this file except in compliance with the License.
* You may obtain a copy of the License at
*
*     https:  www.apache.org licenses LICENSE-2.0
*
* Unless required by applicable law or agreed to in writing, software
* distributed under the License is distributed on an "AS IS" BASIS,
* WITHOUT WARRANTIES OR CONDITIONS OF ANY KIND, either express or implied.
* See the License for the specific language governing permissions and
* limitations under the License.
*
* SPDX-License-Identifier: Apache-2.0

.SUBCKT sky130_fd_sc_hd__dfstp_2 CLK D SET_B VGND VNB VNB net59 Q
*.PININFO CLK:I D:I SET_B:I VGND:I VNB:I VNB:I net59:I Q:O
MI36 net120 M0 VGND VNB sky130_fd_pr__nfet_01v8 m=1 w=0.42u l=0.15u mult=1 sa=0.265
+ sb=0.265 sd=0.28 area=0.063 perim=1.14
MI42 db clkneg M0 VNB sky130_fd_pr__nfet_01v8 m=1 w=0.36u l=0.15u mult=1 sa=0.265
+ sb=0.265 sd=0.28 area=0.063 perim=1.14
MI44 clkneg CLK VGND VNB sky130_fd_pr__nfet_01v8 m=1 w=0.42u l=0.15u mult=1 sa=0.265
+ sb=0.265 sd=0.28 area=0.063 perim=1.14
MI39 db D VGND VNB sky130_fd_pr__nfet_01v8 m=1 w=0.64u l=0.15u mult=1 sa=0.265
+ sb=0.265 sd=0.28 area=0.063 perim=1.14
MI656 M1 M0 net103 VNB sky130_fd_pr__nfet_01v8 m=1 w=0.42u l=0.15u mult=1 sa=0.265
+ sb=0.265 sd=0.28 area=0.063 perim=1.14
MI654 net71 M1 VGND VNB sky130_fd_pr__nfet_01v8 m=1 w=0.42u l=0.15u mult=1 sa=0.265
+ sb=0.265 sd=0.28 area=0.063 perim=1.14
MI34 S0 clkpos net120 VNB sky130_fd_pr__nfet_01v8 m=1 w=0.42u l=0.15u mult=1 sa=0.265
+ sb=0.265 sd=0.28 area=0.063 perim=1.14
MI46 clkpos clkneg VGND VNB sky130_fd_pr__nfet_01v8 m=1 w=0.42u l=0.15u mult=1
+ sa=0.265 sb=0.265 sd=0.28 area=0.063 perim=1.14
MI25 net88 SET_B VGND VNB sky130_fd_pr__nfet_01v8 m=1 w=0.42u l=0.15u mult=1 sa=0.265
+ sb=0.265 sd=0.28 area=0.063 perim=1.14
MI26 S0 clkneg net80 VNB sky130_fd_pr__nfet_01v8 m=1 w=0.42u l=0.15u mult=1 sa=0.265
+ sb=0.265 sd=0.28 area=0.063 perim=1.14
MI27 net80 S1 net88 VNB sky130_fd_pr__nfet_01v8 m=1 w=0.42u l=0.15u mult=1 sa=0.265
+ sb=0.265 sd=0.28 area=0.063 perim=1.14
MI647 S1 S0 VGND VNB sky130_fd_pr__nfet_01v8 m=1 w=0.54u l=0.15u mult=1 sa=0.265
+ sb=0.265 sd=0.28 area=0.063 perim=1.14
MI655 M0 clkpos net71 VNB sky130_fd_pr__nfet_01v8 m=1 w=0.36u l=0.15u mult=1 sa=0.265
+ sb=0.265 sd=0.28 area=0.063 perim=1.14
MI657 net103 SET_B VGND VNB sky130_fd_pr__nfet_01v8 m=1 w=0.42u l=0.15u mult=1
+ sa=0.265 sb=0.265 sd=0.28 area=0.063 perim=1.14
MI652 net128 S0 VGND VNB sky130_fd_pr__nfet_01v8 m=1 w=0.65u l=0.15u mult=1 sa=0.265
+ sb=0.265 sd=0.28 area=0.063 perim=1.14
MI653 Q net128 VGND VNB sky130_fd_pr__nfet_01v8 m=2 w=0.65u l=0.15u mult=1 sa=0.265
+ sb=0.265 sd=0.28 area=0.063 perim=1.14
MI40 db D net59 VNB sky130_fd_pr__pfet_01v8_hvt m=1 w=0.84u l=0.15u mult=1 sa=0.265
+ sb=0.265 sd=0.28 area=0.063 perim=1.14
MI38 S0 clkneg net179 VNB sky130_fd_pr__pfet_01v8_hvt m=1 w=0.42u l=0.15u mult=1
+ sa=0.265 sb=0.265 sd=0.28 area=0.063 perim=1.14
MI37 net179 M0 net59 VNB sky130_fd_pr__pfet_01v8_hvt m=1 w=0.42u l=0.15u mult=1
+ sa=0.265 sb=0.265 sd=0.28 area=0.063 perim=1.14
MI43 db clkpos M0 VNB sky130_fd_pr__pfet_01v8_hvt m=1 w=0.42u l=0.15u mult=1 sa=0.265
+ sb=0.265 sd=0.28 area=0.063 perim=1.14
MI45 clkneg CLK net59 VNB sky130_fd_pr__pfet_01v8_hvt m=1 w=0.64u l=0.15u mult=1
+ sa=0.265 sb=0.265 sd=0.28 area=0.063 perim=1.14
MI47 clkpos clkneg net59 VNB sky130_fd_pr__pfet_01v8_hvt m=1 w=0.64u l=0.15u mult=1
+ sa=0.265 sb=0.265 sd=0.28 area=0.063 perim=1.14
MI659 M1 SET_B net59 VNB sky130_fd_pr__pfet_01v8_hvt m=1 w=0.42u l=0.15u mult=1
+ sa=0.265 sb=0.265 sd=0.28 area=0.063 perim=1.14
MI662 net156 M1 net59 VNB sky130_fd_pr__pfet_01v8_hvt m=1 w=0.42u l=0.15u mult=1
+ sa=0.265 sb=0.265 sd=0.28 area=0.063 perim=1.14
MI664 M0 clkneg net156 VNB sky130_fd_pr__pfet_01v8_hvt m=1 w=0.42u l=0.15u mult=1
+ sa=0.265 sb=0.265 sd=0.28 area=0.063 perim=1.14
MI6 net143 S1 net59 VNB sky130_fd_pr__pfet_01v8_hvt m=1 w=0.42u l=0.15u mult=1 sa=0.265
+ sb=0.265 sd=0.28 area=0.063 perim=1.14
MI5 S0 clkpos net143 VNB sky130_fd_pr__pfet_01v8_hvt m=1 w=0.42u l=0.15u mult=1
+ sa=0.265 sb=0.265 sd=0.28 area=0.063 perim=1.14
MI24 S0 SET_B net59 VNB sky130_fd_pr__pfet_01v8_hvt m=1 w=0.42u l=0.15u mult=1 sa=0.265
+ sb=0.265 sd=0.28 area=0.063 perim=1.14
MI648 S1 S0 net59 VNB sky130_fd_pr__pfet_01v8_hvt m=1 w=0.84u l=0.15u mult=1 sa=0.265
+ sb=0.265 sd=0.28 area=0.063 perim=1.14
MI658 M1 M0 net59 VNB sky130_fd_pr__pfet_01v8_hvt m=1 w=0.42u l=0.15u mult=1 sa=0.265
+ sb=0.265 sd=0.28 area=0.063 perim=1.14
MI663 net128 S0 net59 VNB sky130_fd_pr__pfet_01v8_hvt m=1 w=1 l=0.15 mult=1 sa=0.265
+ sb=0.265 sd=0.28 area=0.063 perim=1.14
MI660 Q net128 net59 VNB sky130_fd_pr__pfet_01v8_hvt m=2 w=1.0u l=0.15u mult=1 sa=0.265
+ sb=0.265 sd=0.28 area=0.063 perim=1.14
.ENDS sky130_fd_sc_hd__dfstp_2
* Copyright 2020 The SkyWater PDK Authors
*
* Licensed under the Apache License, Version 2.0 (the "License");
* you may not use this file except in compliance with the License.
* You may obtain a copy of the License at
*
*     https:  www.apache.org licenses LICENSE-2.0
*
* Unless required by applicable law or agreed to in writing, software
* distributed under the License is distributed on an "AS IS" BASIS,
* WITHOUT WARRANTIES OR CONDITIONS OF ANY KIND, either express or implied.
* See the License for the specific language governing permissions and
* limitations under the License.
*
* SPDX-License-Identifier: Apache-2.0

.SUBCKT sky130_fd_sc_hd__dfstp_4 CLK D SET_B VGND VNB VNB net59 Q
*.PININFO CLK:I D:I SET_B:I VGND:I VNB:I VNB:I net59:I Q:O
MI36 net120 M0 VGND VNB sky130_fd_pr__nfet_01v8 m=1 w=0.42u l=0.15u mult=1 sa=0.265
+ sb=0.265 sd=0.28 area=0.063 perim=1.14
MI42 db clkneg M0 VNB sky130_fd_pr__nfet_01v8 m=1 w=0.36u l=0.15u mult=1 sa=0.265
+ sb=0.265 sd=0.28 area=0.063 perim=1.14
MI44 clkneg CLK VGND VNB sky130_fd_pr__nfet_01v8 m=1 w=0.42u l=0.15u mult=1 sa=0.265
+ sb=0.265 sd=0.28 area=0.063 perim=1.14
MI39 db D VGND VNB sky130_fd_pr__nfet_01v8 m=1 w=0.64u l=0.15u mult=1 sa=0.265
+ sb=0.265 sd=0.28 area=0.063 perim=1.14
MI656 M1 M0 net103 VNB sky130_fd_pr__nfet_01v8 m=1 w=0.42u l=0.15u mult=1 sa=0.265
+ sb=0.265 sd=0.28 area=0.063 perim=1.14
MI654 net71 M1 VGND VNB sky130_fd_pr__nfet_01v8 m=1 w=0.42u l=0.15u mult=1 sa=0.265
+ sb=0.265 sd=0.28 area=0.063 perim=1.14
MI34 S0 clkpos net120 VNB sky130_fd_pr__nfet_01v8 m=1 w=0.42u l=0.15u mult=1 sa=0.265
+ sb=0.265 sd=0.28 area=0.063 perim=1.14
MI46 clkpos clkneg VGND VNB sky130_fd_pr__nfet_01v8 m=1 w=0.42u l=0.15u mult=1
+ sa=0.265 sb=0.265 sd=0.28 area=0.063 perim=1.14
MI25 net88 SET_B VGND VNB sky130_fd_pr__nfet_01v8 m=1 w=0.42u l=0.15u mult=1 sa=0.265
+ sb=0.265 sd=0.28 area=0.063 perim=1.14
MI26 S0 clkneg net80 VNB sky130_fd_pr__nfet_01v8 m=1 w=0.42u l=0.15u mult=1 sa=0.265
+ sb=0.265 sd=0.28 area=0.063 perim=1.14
MI27 net80 S1 net88 VNB sky130_fd_pr__nfet_01v8 m=1 w=0.42u l=0.15u mult=1 sa=0.265
+ sb=0.265 sd=0.28 area=0.063 perim=1.14
MI647 S1 S0 VGND VNB sky130_fd_pr__nfet_01v8 m=1 w=0.54u l=0.15u mult=1 sa=0.265
+ sb=0.265 sd=0.28 area=0.063 perim=1.14
MI655 M0 clkpos net71 VNB sky130_fd_pr__nfet_01v8 m=1 w=0.36u l=0.15u mult=1 sa=0.265
+ sb=0.265 sd=0.28 area=0.063 perim=1.14
MI657 net103 SET_B VGND VNB sky130_fd_pr__nfet_01v8 m=1 w=0.42u l=0.15u mult=1
+ sa=0.265 sb=0.265 sd=0.28 area=0.063 perim=1.14
MI652 net128 S0 VGND VNB sky130_fd_pr__nfet_01v8 m=1 w=0.42u l=0.15u mult=1 sa=0.265
+ sb=0.265 sd=0.28 area=0.063 perim=1.14
MI653 Q net128 VGND VNB sky130_fd_pr__nfet_01v8 m=5 w=0.65u l=0.15u mult=1 sa=0.265
+ sb=0.265 sd=0.28 area=0.063 perim=1.14
MI40 db D net59 VNB sky130_fd_pr__pfet_01v8_hvt m=1 w=0.84u l=0.15u mult=1 sa=0.265
+ sb=0.265 sd=0.28 area=0.063 perim=1.14
MI38 S0 clkneg net179 VNB sky130_fd_pr__pfet_01v8_hvt m=1 w=0.42u l=0.15u mult=1
+ sa=0.265 sb=0.265 sd=0.28 area=0.063 perim=1.14
MI37 net179 M0 net59 VNB sky130_fd_pr__pfet_01v8_hvt m=1 w=0.42u l=0.15u mult=1
+ sa=0.265 sb=0.265 sd=0.28 area=0.063 perim=1.14
MI43 db clkpos M0 VNB sky130_fd_pr__pfet_01v8_hvt m=1 w=0.42u l=0.15u mult=1 sa=0.265
+ sb=0.265 sd=0.28 area=0.063 perim=1.14
MI45 clkneg CLK net59 VNB sky130_fd_pr__pfet_01v8_hvt m=1 w=0.64u l=0.15u mult=1
+ sa=0.265 sb=0.265 sd=0.28 area=0.063 perim=1.14
MI47 clkpos clkneg net59 VNB sky130_fd_pr__pfet_01v8_hvt m=1 w=0.64u l=0.15u mult=1
+ sa=0.265 sb=0.265 sd=0.28 area=0.063 perim=1.14
MI659 M1 SET_B net59 VNB sky130_fd_pr__pfet_01v8_hvt m=1 w=0.42u l=0.15u mult=1
+ sa=0.265 sb=0.265 sd=0.28 area=0.063 perim=1.14
MI662 net156 M1 net59 VNB sky130_fd_pr__pfet_01v8_hvt m=1 w=0.42u l=0.15u mult=1
+ sa=0.265 sb=0.265 sd=0.28 area=0.063 perim=1.14
MI664 M0 clkneg net156 VNB sky130_fd_pr__pfet_01v8_hvt m=1 w=0.42u l=0.15u mult=1
+ sa=0.265 sb=0.265 sd=0.28 area=0.063 perim=1.14
MI6 net143 S1 net59 VNB sky130_fd_pr__pfet_01v8_hvt m=1 w=0.42u l=0.15u mult=1 sa=0.265
+ sb=0.265 sd=0.28 area=0.063 perim=1.14
MI5 S0 clkpos net143 VNB sky130_fd_pr__pfet_01v8_hvt m=1 w=0.42u l=0.15u mult=1
+ sa=0.265 sb=0.265 sd=0.28 area=0.063 perim=1.14
MI24 S0 SET_B net59 VNB sky130_fd_pr__pfet_01v8_hvt m=1 w=0.42u l=0.15u mult=1 sa=0.265
+ sb=0.265 sd=0.28 area=0.063 perim=1.14
MI648 S1 S0 net59 VNB sky130_fd_pr__pfet_01v8_hvt m=1 w=0.84u l=0.15u mult=1 sa=0.265
+ sb=0.265 sd=0.28 area=0.063 perim=1.14
MI658 M1 M0 net59 VNB sky130_fd_pr__pfet_01v8_hvt m=1 w=0.42u l=0.15u mult=1 sa=0.265
+ sb=0.265 sd=0.28 area=0.063 perim=1.14
MI663 net128 S0 net59 VNB sky130_fd_pr__pfet_01v8_hvt m=1 w=0.64u l=0.15u mult=1
+ sa=0.265 sb=0.265 sd=0.28 area=0.063 perim=1.14
MI660 Q net128 net59 VNB sky130_fd_pr__pfet_01v8_hvt m=5 w=1.0u l=0.15u mult=1 sa=0.265
+ sb=0.265 sd=0.28 area=0.063 perim=1.14
.ENDS sky130_fd_sc_hd__dfstp_4
* Copyright 2020 The SkyWater PDK Authors
*
* Licensed under the Apache License, Version 2.0 (the "License");
* you may not use this file except in compliance with the License.
* You may obtain a copy of the License at
*
*     https:  www.apache.org licenses LICENSE-2.0
*
* Unless required by applicable law or agreed to in writing, software
* distributed under the License is distributed on an "AS IS" BASIS,
* WITHOUT WARRANTIES OR CONDITIONS OF ANY KIND, either express or implied.
* See the License for the specific language governing permissions and
* limitations under the License.
*
* SPDX-License-Identifier: Apache-2.0

.SUBCKT sky130_fd_sc_hd__dfxbp_1 CLK D VGND VNB VNB net59 Q Q_N
*.PININFO CLK:I D:I VGND:I VNB:I VNB:I net59:I Q:O Q_N:O
MI657 M0 clkpos net96 VNB sky130_fd_pr__nfet_01v8 m=1 w=0.36u l=0.15u mult=1 sa=0.265
+ sb=0.265 sd=0.28 area=0.063 perim=1.14
MI656 net96 M1 VGND VNB sky130_fd_pr__nfet_01v8 m=1 w=0.42u l=0.15u mult=1 sa=0.265
+ sb=0.265 sd=0.28 area=0.063 perim=1.14
MI646 Q S1 VGND VNB sky130_fd_pr__nfet_01v8 m=1 w=0.65u l=0.15u mult=1 sa=0.265
+ sb=0.265 sd=0.28 area=0.063 perim=1.14
MI669 net88 S1 VGND VNB sky130_fd_pr__nfet_01v8 m=1 w=0.42u l=0.15u mult=1 sa=0.265
+ sb=0.265 sd=0.28 area=0.063 perim=1.14
MI648 db clkneg M0 VNB sky130_fd_pr__nfet_01v8 m=1 w=0.36u l=0.15u mult=1 sa=0.265
+ sb=0.265 sd=0.28 area=0.063 perim=1.14
MI654 db D VGND VNB sky130_fd_pr__nfet_01v8 m=1 w=0.42u l=0.15u mult=1 sa=0.265
+ sb=0.265 sd=0.28 area=0.063 perim=1.14
MI642 S0 clkneg net72 VNB sky130_fd_pr__nfet_01v8 m=1 w=0.36u l=0.15u mult=1 sa=0.265
+ sb=0.265 sd=0.28 area=0.063 perim=1.14
MI641 net72 S1 VGND VNB sky130_fd_pr__nfet_01v8 m=1 w=0.42u l=0.15u mult=1 sa=0.265
+ sb=0.265 sd=0.28 area=0.063 perim=1.14
MI652 M1 clkpos S0 VNB sky130_fd_pr__nfet_01v8 m=1 w=0.36u l=0.15u mult=1 sa=0.265
+ sb=0.265 sd=0.28 area=0.063 perim=1.14
MI649 S1 S0 VGND VNB sky130_fd_pr__nfet_01v8 m=1 w=0.65u l=0.15u mult=1 sa=0.265
+ sb=0.265 sd=0.28 area=0.063 perim=1.14
MI635 clkneg CLK VGND VNB sky130_fd_pr__nfet_01v8 m=1 w=0.42u l=0.15u mult=1 sa=0.265
+ sb=0.265 sd=0.28 area=0.063 perim=1.14
MI636 clkpos clkneg VGND VNB sky130_fd_pr__nfet_01v8 m=1 w=0.42u l=0.15u mult=1
+ sa=0.265 sb=0.265 sd=0.28 area=0.063 perim=1.14
MI634 M1 M0 VGND VNB sky130_fd_pr__nfet_01v8 m=1 w=0.64u l=0.15u mult=1 sa=0.265
+ sb=0.265 sd=0.28 area=0.063 perim=1.14
MI665 Q_N net88 VGND VNB sky130_fd_pr__nfet_01v8 m=1 w=0.65u l=0.15u mult=1 sa=0.265
+ sb=0.265 sd=0.28 area=0.063 perim=1.14
MI659 M0 clkneg net128 VNB sky130_fd_pr__pfet_01v8_hvt m=1 w=0.42u l=0.15u mult=1
+ sa=0.265 sb=0.265 sd=0.28 area=0.063 perim=1.14
MI650 S1 S0 net59 VNB sky130_fd_pr__pfet_01v8_hvt m=1 w=1.0u l=0.15u mult=1 sa=0.265
+ sb=0.265 sd=0.28 area=0.063 perim=1.14
MI644 S0 clkpos net147 VNB sky130_fd_pr__pfet_01v8_hvt m=1 w=0.42u l=0.15u mult=1
+ sa=0.265 sb=0.265 sd=0.28 area=0.063 perim=1.14
MI639 M1 M0 net59 VNB sky130_fd_pr__pfet_01v8_hvt m=1 w=0.75u l=0.15u mult=1 sa=0.265
+ sb=0.265 sd=0.28 area=0.063 perim=1.14
MI670 net88 S1 net59 VNB sky130_fd_pr__pfet_01v8_hvt m=1 w=0.64u l=0.15u mult=1
+ sa=0.265 sb=0.265 sd=0.28 area=0.063 perim=1.14
MI643 net147 S1 net59 VNB sky130_fd_pr__pfet_01v8_hvt m=1 w=0.42u l=0.15u mult=1
+ sa=0.265 sb=0.265 sd=0.28 area=0.063 perim=1.14
MI638 clkneg CLK net59 VNB sky130_fd_pr__pfet_01v8_hvt m=1 w=0.64u l=0.15u mult=1
+ sa=0.265 sb=0.265 sd=0.28 area=0.063 perim=1.14
MI658 net128 M1 net59 VNB sky130_fd_pr__pfet_01v8_hvt m=1 w=0.42u l=0.15u mult=1
+ sa=0.265 sb=0.265 sd=0.28 area=0.063 perim=1.14
MI645 Q S1 net59 VNB sky130_fd_pr__pfet_01v8_hvt m=1 w=1.0u l=0.15u mult=1 sa=0.265
+ sb=0.265 sd=0.28 area=0.063 perim=1.14
MI651 db clkpos M0 VNB sky130_fd_pr__pfet_01v8_hvt m=1 w=0.42u l=0.15u mult=1 sa=0.265
+ sb=0.265 sd=0.28 area=0.063 perim=1.14
MI655 db D net59 VNB sky130_fd_pr__pfet_01v8_hvt m=1 w=0.42u l=0.15u mult=1 sa=0.265
+ sb=0.265 sd=0.28 area=0.063 perim=1.14
MI653 M1 clkneg S0 VNB sky130_fd_pr__pfet_01v8_hvt m=1 w=0.42u l=0.15u mult=1 sa=0.265
+ sb=0.265 sd=0.28 area=0.063 perim=1.14
MI637 clkpos clkneg net59 VNB sky130_fd_pr__pfet_01v8_hvt m=1 w=0.64u l=0.15u mult=1
+ sa=0.265 sb=0.265 sd=0.28 area=0.063 perim=1.14
MI666 Q_N net88 net59 VNB sky130_fd_pr__pfet_01v8_hvt m=1 w=1.0u l=0.15u mult=1
+ sa=0.265 sb=0.265 sd=0.28 area=0.063 perim=1.14
.ENDS sky130_fd_sc_hd__dfxbp_1
* Copyright 2020 The SkyWater PDK Authors
*
* Licensed under the Apache License, Version 2.0 (the "License");
* you may not use this file except in compliance with the License.
* You may obtain a copy of the License at
*
*     https:  www.apache.org licenses LICENSE-2.0
*
* Unless required by applicable law or agreed to in writing, software
* distributed under the License is distributed on an "AS IS" BASIS,
* WITHOUT WARRANTIES OR CONDITIONS OF ANY KIND, either express or implied.
* See the License for the specific language governing permissions and
* limitations under the License.
*
* SPDX-License-Identifier: Apache-2.0

.SUBCKT sky130_fd_sc_hd__dfxbp_2 CLK D VGND VNB VNB net59 Q Q_N
*.PININFO CLK:I D:I VGND:I VNB:I VNB:I net59:I Q:O Q_N:O
MI657 M0 clkpos net96 VNB sky130_fd_pr__nfet_01v8 m=1 w=0.36u l=0.15u mult=1 sa=0.265
+ sb=0.265 sd=0.28 area=0.063 perim=1.14
MI656 net96 M1 VGND VNB sky130_fd_pr__nfet_01v8 m=1 w=0.42u l=0.15u mult=1 sa=0.265
+ sb=0.265 sd=0.28 area=0.063 perim=1.14
MI646 Q S1 VGND VNB sky130_fd_pr__nfet_01v8 m=2 w=0.65u l=0.15u mult=1 sa=0.265
+ sb=0.265 sd=0.28 area=0.063 perim=1.14
MI669 net88 S1 VGND VNB sky130_fd_pr__nfet_01v8 m=1 w=0.42u l=0.15u mult=1 sa=0.265
+ sb=0.265 sd=0.28 area=0.063 perim=1.14
MI648 db clkneg M0 VNB sky130_fd_pr__nfet_01v8 m=1 w=0.36u l=0.15u mult=1 sa=0.265
+ sb=0.265 sd=0.28 area=0.063 perim=1.14
MI654 db D VGND VNB sky130_fd_pr__nfet_01v8 m=1 w=0.42u l=0.15u mult=1 sa=0.265
+ sb=0.265 sd=0.28 area=0.063 perim=1.14
MI642 S0 clkneg net72 VNB sky130_fd_pr__nfet_01v8 m=1 w=0.36u l=0.15u mult=1 sa=0.265
+ sb=0.265 sd=0.28 area=0.063 perim=1.14
MI641 net72 S1 VGND VNB sky130_fd_pr__nfet_01v8 m=1 w=0.42u l=0.15u mult=1 sa=0.265
+ sb=0.265 sd=0.28 area=0.063 perim=1.14
MI652 M1 clkpos S0 VNB sky130_fd_pr__nfet_01v8 m=1 w=0.36u l=0.15u mult=1 sa=0.265
+ sb=0.265 sd=0.28 area=0.063 perim=1.14
MI649 S1 S0 VGND VNB sky130_fd_pr__nfet_01v8 m=1 w=0.65u l=0.15u mult=1 sa=0.265
+ sb=0.265 sd=0.28 area=0.063 perim=1.14
MI635 clkneg CLK VGND VNB sky130_fd_pr__nfet_01v8 m=1 w=0.42u l=0.15u mult=1 sa=0.265
+ sb=0.265 sd=0.28 area=0.063 perim=1.14
MI636 clkpos clkneg VGND VNB sky130_fd_pr__nfet_01v8 m=1 w=0.42u l=0.15u mult=1
+ sa=0.265 sb=0.265 sd=0.28 area=0.063 perim=1.14
MI634 M1 M0 VGND VNB sky130_fd_pr__nfet_01v8 m=1 w=0.64u l=0.15u mult=1 sa=0.265
+ sb=0.265 sd=0.28 area=0.063 perim=1.14
MI665 Q_N net88 VGND VNB sky130_fd_pr__nfet_01v8 m=2 w=0.65u l=0.15u mult=1 sa=0.265
+ sb=0.265 sd=0.28 area=0.063 perim=1.14
MI659 M0 clkneg net128 VNB sky130_fd_pr__pfet_01v8_hvt m=1 w=0.42u l=0.15u mult=1
+ sa=0.265 sb=0.265 sd=0.28 area=0.063 perim=1.14
MI650 S1 S0 net59 VNB sky130_fd_pr__pfet_01v8_hvt m=1 w=1.0u l=0.15u mult=1 sa=0.265
+ sb=0.265 sd=0.28 area=0.063 perim=1.14
MI644 S0 clkpos net147 VNB sky130_fd_pr__pfet_01v8_hvt m=1 w=0.42u l=0.15u mult=1
+ sa=0.265 sb=0.265 sd=0.28 area=0.063 perim=1.14
MI639 M1 M0 net59 VNB sky130_fd_pr__pfet_01v8_hvt m=1 w=0.75u l=0.15u mult=1 sa=0.265
+ sb=0.265 sd=0.28 area=0.063 perim=1.14
MI670 net88 S1 net59 VNB sky130_fd_pr__pfet_01v8_hvt m=1 w=0.64u l=0.15u mult=1
+ sa=0.265 sb=0.265 sd=0.28 area=0.063 perim=1.14
MI643 net147 S1 net59 VNB sky130_fd_pr__pfet_01v8_hvt m=1 w=0.42u l=0.15u mult=1
+ sa=0.265 sb=0.265 sd=0.28 area=0.063 perim=1.14
MI638 clkneg CLK net59 VNB sky130_fd_pr__pfet_01v8_hvt m=1 w=0.64u l=0.15u mult=1
+ sa=0.265 sb=0.265 sd=0.28 area=0.063 perim=1.14
MI658 net128 M1 net59 VNB sky130_fd_pr__pfet_01v8_hvt m=1 w=0.42u l=0.15u mult=1
+ sa=0.265 sb=0.265 sd=0.28 area=0.063 perim=1.14
MI645 Q S1 net59 VNB sky130_fd_pr__pfet_01v8_hvt m=2 w=1.0u l=0.15u mult=1 sa=0.265
+ sb=0.265 sd=0.28 area=0.063 perim=1.14
MI651 db clkpos M0 VNB sky130_fd_pr__pfet_01v8_hvt m=1 w=0.42u l=0.15u mult=1 sa=0.265
+ sb=0.265 sd=0.28 area=0.063 perim=1.14
MI655 db D net59 VNB sky130_fd_pr__pfet_01v8_hvt m=1 w=0.42u l=0.15u mult=1 sa=0.265
+ sb=0.265 sd=0.28 area=0.063 perim=1.14
MI653 M1 clkneg S0 VNB sky130_fd_pr__pfet_01v8_hvt m=1 w=0.42u l=0.15u mult=1 sa=0.265
+ sb=0.265 sd=0.28 area=0.063 perim=1.14
MI637 clkpos clkneg net59 VNB sky130_fd_pr__pfet_01v8_hvt m=1 w=0.64u l=0.15u mult=1
+ sa=0.265 sb=0.265 sd=0.28 area=0.063 perim=1.14
MI666 Q_N net88 net59 VNB sky130_fd_pr__pfet_01v8_hvt m=2 w=1.0u l=0.15u mult=1
+ sa=0.265 sb=0.265 sd=0.28 area=0.063 perim=1.14
.ENDS sky130_fd_sc_hd__dfxbp_2
* Copyright 2020 The SkyWater PDK Authors
*
* Licensed under the Apache License, Version 2.0 (the "License");
* you may not use this file except in compliance with the License.
* You may obtain a copy of the License at
*
*     https:  www.apache.org licenses LICENSE-2.0
*
* Unless required by applicable law or agreed to in writing, software
* distributed under the License is distributed on an "AS IS" BASIS,
* WITHOUT WARRANTIES OR CONDITIONS OF ANY KIND, either express or implied.
* See the License for the specific language governing permissions and
* limitations under the License.
*
* SPDX-License-Identifier: Apache-2.0

.SUBCKT sky130_fd_sc_hd__dfxtp_1 CLK D VGND VNB VNB net59 Q
*.PININFO CLK:I D:I VGND:I VNB:I VNB:I net59:I Q:O
MI657 M0 clkpos net79 VNB sky130_fd_pr__nfet_01v8 m=1 w=0.36u l=0.15u mult=1 sa=0.265
+ sb=0.265 sd=0.28 area=0.063 perim=1.14
MI656 net79 M1 VGND VNB sky130_fd_pr__nfet_01v8 m=1 w=0.42u l=0.15u mult=1 sa=0.265
+ sb=0.265 sd=0.28 area=0.063 perim=1.14
MI646 Q S1 VGND VNB sky130_fd_pr__nfet_01v8 m=1 w=0.65u l=0.15u mult=1 sa=0.265
+ sb=0.265 sd=0.28 area=0.063 perim=1.14
MI648 db clkneg M0 VNB sky130_fd_pr__nfet_01v8 m=1 w=0.36u l=0.15u mult=1 sa=0.265
+ sb=0.265 sd=0.28 area=0.063 perim=1.14
MI654 db D VGND VNB sky130_fd_pr__nfet_01v8 m=1 w=0.42u l=0.15u mult=1 sa=0.265
+ sb=0.265 sd=0.28 area=0.063 perim=1.14
MI642 S0 clkneg net59 VNB sky130_fd_pr__nfet_01v8 m=1 w=0.36u l=0.15u mult=1 sa=0.265
+ sb=0.265 sd=0.28 area=0.063 perim=1.14
MI641 net59 S1 VGND VNB sky130_fd_pr__nfet_01v8 m=1 w=0.42u l=0.15u mult=1 sa=0.265
+ sb=0.265 sd=0.28 area=0.063 perim=1.14
MI652 M1 clkpos S0 VNB sky130_fd_pr__nfet_01v8 m=1 w=0.36u l=0.15u mult=1 sa=0.265
+ sb=0.265 sd=0.28 area=0.063 perim=1.14
MI649 S1 S0 VGND VNB sky130_fd_pr__nfet_01v8 m=1 w=0.65u l=0.15u mult=1 sa=0.265
+ sb=0.265 sd=0.28 area=0.063 perim=1.14
MI635 clkneg CLK VGND VNB sky130_fd_pr__nfet_01v8 m=1 w=0.42u l=0.15u mult=1 sa=0.265
+ sb=0.265 sd=0.28 area=0.063 perim=1.14
MI636 clkpos clkneg VGND VNB sky130_fd_pr__nfet_01v8 m=1 w=0.42u l=0.15u mult=1
+ sa=0.265 sb=0.265 sd=0.28 area=0.063 perim=1.14
MI634 M1 M0 VGND VNB sky130_fd_pr__nfet_01v8 m=1 w=0.64u l=0.15u mult=1 sa=0.265
+ sb=0.265 sd=0.28 area=0.063 perim=1.14
MI659 M0 clkneg net107 VNB sky130_fd_pr__pfet_01v8_hvt m=1 w=0.42u l=0.15u mult=1
+ sa=0.265 sb=0.265 sd=0.28 area=0.063 perim=1.14
MI650 S1 S0 net59 VNB sky130_fd_pr__pfet_01v8_hvt m=1 w=1.0u l=0.15u mult=1 sa=0.265
+ sb=0.265 sd=0.28 area=0.063 perim=1.14
MI644 S0 clkpos net122 VNB sky130_fd_pr__pfet_01v8_hvt m=1 w=0.42u l=0.15u mult=1
+ sa=0.265 sb=0.265 sd=0.28 area=0.063 perim=1.14
MI639 M1 M0 net59 VNB sky130_fd_pr__pfet_01v8_hvt m=1 w=0.75u l=0.15u mult=1 sa=0.265
+ sb=0.265 sd=0.28 area=0.063 perim=1.14
MI643 net122 S1 net59 VNB sky130_fd_pr__pfet_01v8_hvt m=1 w=0.42u l=0.15u mult=1
+ sa=0.265 sb=0.265 sd=0.28 area=0.063 perim=1.14
MI638 clkneg CLK net59 VNB sky130_fd_pr__pfet_01v8_hvt m=1 w=0.64u l=0.15u mult=1
+ sa=0.265 sb=0.265 sd=0.28 area=0.063 perim=1.14
MI658 net107 M1 net59 VNB sky130_fd_pr__pfet_01v8_hvt m=1 w=0.42u l=0.15u mult=1
+ sa=0.265 sb=0.265 sd=0.28 area=0.063 perim=1.14
MI645 Q S1 net59 VNB sky130_fd_pr__pfet_01v8_hvt m=1 w=1.0u l=0.15u mult=1 sa=0.265
+ sb=0.265 sd=0.28 area=0.063 perim=1.14
MI651 db clkpos M0 VNB sky130_fd_pr__pfet_01v8_hvt m=1 w=0.42u l=0.15u mult=1 sa=0.265
+ sb=0.265 sd=0.28 area=0.063 perim=1.14
MI655 db D net59 VNB sky130_fd_pr__pfet_01v8_hvt m=1 w=0.42u l=0.15u mult=1 sa=0.265
+ sb=0.265 sd=0.28 area=0.063 perim=1.14
MI653 M1 clkneg S0 VNB sky130_fd_pr__pfet_01v8_hvt m=1 w=0.42u l=0.15u mult=1 sa=0.265
+ sb=0.265 sd=0.28 area=0.063 perim=1.14
MI637 clkpos clkneg net59 VNB sky130_fd_pr__pfet_01v8_hvt m=1 w=0.64u l=0.15u mult=1
+ sa=0.265 sb=0.265 sd=0.28 area=0.063 perim=1.14
.ENDS sky130_fd_sc_hd__dfxtp_1
* Copyright 2020 The SkyWater PDK Authors
*
* Licensed under the Apache License, Version 2.0 (the "License");
* you may not use this file except in compliance with the License.
* You may obtain a copy of the License at
*
*     https:  www.apache.org licenses LICENSE-2.0
*
* Unless required by applicable law or agreed to in writing, software
* distributed under the License is distributed on an "AS IS" BASIS,
* WITHOUT WARRANTIES OR CONDITIONS OF ANY KIND, either express or implied.
* See the License for the specific language governing permissions and
* limitations under the License.
*
* SPDX-License-Identifier: Apache-2.0

.SUBCKT sky130_fd_sc_hd__dfxtp_2 CLK D VGND VNB VNB net59 Q
*.PININFO CLK:I D:I VGND:I VNB:I VNB:I net59:I Q:O
MI657 M0 clkpos net79 VNB sky130_fd_pr__nfet_01v8 m=1 w=0.36u l=0.15u mult=1 sa=0.265
+ sb=0.265 sd=0.28 area=0.063 perim=1.14
MI656 net79 M1 VGND VNB sky130_fd_pr__nfet_01v8 m=1 w=0.42u l=0.15u mult=1 sa=0.265
+ sb=0.265 sd=0.28 area=0.063 perim=1.14
MI646 Q S1 VGND VNB sky130_fd_pr__nfet_01v8 m=2 w=0.65u l=0.15u mult=1 sa=0.265
+ sb=0.265 sd=0.28 area=0.063 perim=1.14
MI648 db clkneg M0 VNB sky130_fd_pr__nfet_01v8 m=1 w=0.36u l=0.15u mult=1 sa=0.265
+ sb=0.265 sd=0.28 area=0.063 perim=1.14
MI654 db D VGND VNB sky130_fd_pr__nfet_01v8 m=1 w=0.42u l=0.15u mult=1 sa=0.265
+ sb=0.265 sd=0.28 area=0.063 perim=1.14
MI642 S0 clkneg net59 VNB sky130_fd_pr__nfet_01v8 m=1 w=0.36u l=0.15u mult=1 sa=0.265
+ sb=0.265 sd=0.28 area=0.063 perim=1.14
MI641 net59 S1 VGND VNB sky130_fd_pr__nfet_01v8 m=1 w=0.42u l=0.15u mult=1 sa=0.265
+ sb=0.265 sd=0.28 area=0.063 perim=1.14
MI652 M1 clkpos S0 VNB sky130_fd_pr__nfet_01v8 m=1 w=0.36u l=0.15u mult=1 sa=0.265
+ sb=0.265 sd=0.28 area=0.063 perim=1.14
MI649 S1 S0 VGND VNB sky130_fd_pr__nfet_01v8 m=1 w=0.65u l=0.15u mult=1 sa=0.265
+ sb=0.265 sd=0.28 area=0.063 perim=1.14
MI635 clkneg CLK VGND VNB sky130_fd_pr__nfet_01v8 m=1 w=0.42u l=0.15u mult=1 sa=0.265
+ sb=0.265 sd=0.28 area=0.063 perim=1.14
MI636 clkpos clkneg VGND VNB sky130_fd_pr__nfet_01v8 m=1 w=0.42u l=0.15u mult=1
+ sa=0.265 sb=0.265 sd=0.28 area=0.063 perim=1.14
MI634 M1 M0 VGND VNB sky130_fd_pr__nfet_01v8 m=1 w=0.64u l=0.15u mult=1 sa=0.265
+ sb=0.265 sd=0.28 area=0.063 perim=1.14
MI659 M0 clkneg net107 VNB sky130_fd_pr__pfet_01v8_hvt m=1 w=0.42u l=0.15u mult=1
+ sa=0.265 sb=0.265 sd=0.28 area=0.063 perim=1.14
MI650 S1 S0 net59 VNB sky130_fd_pr__pfet_01v8_hvt m=1 w=1.0u l=0.15u mult=1 sa=0.265
+ sb=0.265 sd=0.28 area=0.063 perim=1.14
MI644 S0 clkpos net122 VNB sky130_fd_pr__pfet_01v8_hvt m=1 w=0.42u l=0.15u mult=1
+ sa=0.265 sb=0.265 sd=0.28 area=0.063 perim=1.14
MI639 M1 M0 net59 VNB sky130_fd_pr__pfet_01v8_hvt m=1 w=0.75u l=0.15u mult=1 sa=0.265
+ sb=0.265 sd=0.28 area=0.063 perim=1.14
MI643 net122 S1 net59 VNB sky130_fd_pr__pfet_01v8_hvt m=1 w=0.42u l=0.15u mult=1
+ sa=0.265 sb=0.265 sd=0.28 area=0.063 perim=1.14
MI638 clkneg CLK net59 VNB sky130_fd_pr__pfet_01v8_hvt m=1 w=0.64u l=0.15u mult=1
+ sa=0.265 sb=0.265 sd=0.28 area=0.063 perim=1.14
MI658 net107 M1 net59 VNB sky130_fd_pr__pfet_01v8_hvt m=1 w=0.42u l=0.15u mult=1
+ sa=0.265 sb=0.265 sd=0.28 area=0.063 perim=1.14
MI645 Q S1 net59 VNB sky130_fd_pr__pfet_01v8_hvt m=2 w=1.0u l=0.15u mult=1 sa=0.265
+ sb=0.265 sd=0.28 area=0.063 perim=1.14
MI651 db clkpos M0 VNB sky130_fd_pr__pfet_01v8_hvt m=1 w=0.42u l=0.15u mult=1 sa=0.265
+ sb=0.265 sd=0.28 area=0.063 perim=1.14
MI655 db D net59 VNB sky130_fd_pr__pfet_01v8_hvt m=1 w=0.42u l=0.15u mult=1 sa=0.265
+ sb=0.265 sd=0.28 area=0.063 perim=1.14
MI653 M1 clkneg S0 VNB sky130_fd_pr__pfet_01v8_hvt m=1 w=0.42u l=0.15u mult=1 sa=0.265
+ sb=0.265 sd=0.28 area=0.063 perim=1.14
MI637 clkpos clkneg net59 VNB sky130_fd_pr__pfet_01v8_hvt m=1 w=0.64u l=0.15u mult=1
+ sa=0.265 sb=0.265 sd=0.28 area=0.063 perim=1.14
.ENDS sky130_fd_sc_hd__dfxtp_2
* Copyright 2020 The SkyWater PDK Authors
*
* Licensed under the Apache License, Version 2.0 (the "License");
* you may not use this file except in compliance with the License.
* You may obtain a copy of the License at
*
*     https:  www.apache.org licenses LICENSE-2.0
*
* Unless required by applicable law or agreed to in writing, software
* distributed under the License is distributed on an "AS IS" BASIS,
* WITHOUT WARRANTIES OR CONDITIONS OF ANY KIND, either express or implied.
* See the License for the specific language governing permissions and
* limitations under the License.
*
* SPDX-License-Identifier: Apache-2.0

.SUBCKT sky130_fd_sc_hd__dfxtp_4 CLK D VGND VNB VNB net59 Q
*.PININFO CLK:I D:I VGND:I VNB:I VNB:I net59:I Q:O
MI657 M0 clkpos net79 VNB sky130_fd_pr__nfet_01v8 m=1 w=0.36u l=0.15u mult=1 sa=0.265
+ sb=0.265 sd=0.28 area=0.063 perim=1.14
MI656 net79 M1 VGND VNB sky130_fd_pr__nfet_01v8 m=1 w=0.42u l=0.15u mult=1 sa=0.265
+ sb=0.265 sd=0.28 area=0.063 perim=1.14
MI646 Q S1 VGND VNB sky130_fd_pr__nfet_01v8 m=4 w=0.65u l=0.15u mult=1 sa=0.265
+ sb=0.265 sd=0.28 area=0.063 perim=1.14
MI648 db clkneg M0 VNB sky130_fd_pr__nfet_01v8 m=1 w=0.36u l=0.15u mult=1 sa=0.265
+ sb=0.265 sd=0.28 area=0.063 perim=1.14
MI654 db D VGND VNB sky130_fd_pr__nfet_01v8 m=1 w=0.42u l=0.15u mult=1 sa=0.265
+ sb=0.265 sd=0.28 area=0.063 perim=1.14
MI642 S0 clkneg net59 VNB sky130_fd_pr__nfet_01v8 m=1 w=0.36u l=0.15u mult=1 sa=0.265
+ sb=0.265 sd=0.28 area=0.063 perim=1.14
MI641 net59 S1 VGND VNB sky130_fd_pr__nfet_01v8 m=1 w=0.42u l=0.15u mult=1 sa=0.265
+ sb=0.265 sd=0.28 area=0.063 perim=1.14
MI652 M1 clkpos S0 VNB sky130_fd_pr__nfet_01v8 m=1 w=0.36u l=0.15u mult=1 sa=0.265
+ sb=0.265 sd=0.28 area=0.063 perim=1.14
MI649 S1 S0 VGND VNB sky130_fd_pr__nfet_01v8 m=1 w=0.65u l=0.15u mult=1 sa=0.265
+ sb=0.265 sd=0.28 area=0.063 perim=1.14
MI635 clkneg CLK VGND VNB sky130_fd_pr__nfet_01v8 m=1 w=0.42u l=0.15u mult=1 sa=0.265
+ sb=0.265 sd=0.28 area=0.063 perim=1.14
MI636 clkpos clkneg VGND VNB sky130_fd_pr__nfet_01v8 m=1 w=0.42u l=0.15u mult=1
+ sa=0.265 sb=0.265 sd=0.28 area=0.063 perim=1.14
MI634 M1 M0 VGND VNB sky130_fd_pr__nfet_01v8 m=1 w=0.64u l=0.15u mult=1 sa=0.265
+ sb=0.265 sd=0.28 area=0.063 perim=1.14
MI659 M0 clkneg net107 VNB sky130_fd_pr__pfet_01v8_hvt m=1 w=0.42u l=0.15u mult=1
+ sa=0.265 sb=0.265 sd=0.28 area=0.063 perim=1.14
MI650 S1 S0 net59 VNB sky130_fd_pr__pfet_01v8_hvt m=1 w=1.0u l=0.15u mult=1 sa=0.265
+ sb=0.265 sd=0.28 area=0.063 perim=1.14
MI644 S0 clkpos net122 VNB sky130_fd_pr__pfet_01v8_hvt m=1 w=0.42u l=0.15u mult=1
+ sa=0.265 sb=0.265 sd=0.28 area=0.063 perim=1.14
MI639 M1 M0 net59 VNB sky130_fd_pr__pfet_01v8_hvt m=1 w=0.75u l=0.15u mult=1 sa=0.265
+ sb=0.265 sd=0.28 area=0.063 perim=1.14
MI643 net122 S1 net59 VNB sky130_fd_pr__pfet_01v8_hvt m=1 w=0.42u l=0.15u mult=1
+ sa=0.265 sb=0.265 sd=0.28 area=0.063 perim=1.14
MI638 clkneg CLK net59 VNB sky130_fd_pr__pfet_01v8_hvt m=1 w=0.64u l=0.15u mult=1
+ sa=0.265 sb=0.265 sd=0.28 area=0.063 perim=1.14
MI658 net107 M1 net59 VNB sky130_fd_pr__pfet_01v8_hvt m=1 w=0.42u l=0.15u mult=1
+ sa=0.265 sb=0.265 sd=0.28 area=0.063 perim=1.14
MI645 Q S1 net59 VNB sky130_fd_pr__pfet_01v8_hvt m=4 w=1.0u l=0.15u mult=1 sa=0.265
+ sb=0.265 sd=0.28 area=0.063 perim=1.14
MI651 db clkpos M0 VNB sky130_fd_pr__pfet_01v8_hvt m=1 w=0.42u l=0.15u mult=1 sa=0.265
+ sb=0.265 sd=0.28 area=0.063 perim=1.14
MI655 db D net59 VNB sky130_fd_pr__pfet_01v8_hvt m=1 w=0.42u l=0.15u mult=1 sa=0.265
+ sb=0.265 sd=0.28 area=0.063 perim=1.14
MI653 M1 clkneg S0 VNB sky130_fd_pr__pfet_01v8_hvt m=1 w=0.42u l=0.15u mult=1 sa=0.265
+ sb=0.265 sd=0.28 area=0.063 perim=1.14
MI637 clkpos clkneg net59 VNB sky130_fd_pr__pfet_01v8_hvt m=1 w=0.64u l=0.15u mult=1
+ sa=0.265 sb=0.265 sd=0.28 area=0.063 perim=1.14
.ENDS sky130_fd_sc_hd__dfxtp_4
* Copyright 2020 The SkyWater PDK Authors
*
* Licensed under the Apache License, Version 2.0 (the "License");
* you may not use this file except in compliance with the License.
* You may obtain a copy of the License at
*
*     https:  www.apache.org licenses LICENSE-2.0
*
* Unless required by applicable law or agreed to in writing, software
* distributed under the License is distributed on an "AS IS" BASIS,
* WITHOUT WARRANTIES OR CONDITIONS OF ANY KIND, either express or implied.
* See the License for the specific language governing permissions and
* limitations under the License.
*
* SPDX-License-Identifier: Apache-2.0

.SUBCKT sky130_fd_sc_hd__diode_2 DIODE VGND VNB VNB net59
*.PININFO DIODE:I VGND:I VNB:I VNB:I net59:I
* Notes: Tap diode is not represented here.
.ENDS sky130_fd_sc_hd__diode_2
* Copyright 2020 The SkyWater PDK Authors
*
* Licensed under the Apache License, Version 2.0 (the "License");
* you may not use this file except in compliance with the License.
* You may obtain a copy of the License at
*
*     https:  www.apache.org licenses LICENSE-2.0
*
* Unless required by applicable law or agreed to in writing, software
* distributed under the License is distributed on an "AS IS" BASIS,
* WITHOUT WARRANTIES OR CONDITIONS OF ANY KIND, either express or implied.
* See the License for the specific language governing permissions and
* limitations under the License.
*
* SPDX-License-Identifier: Apache-2.0

.SUBCKT sky130_fd_sc_hd__dlclkp_1 CLK GATE VGND VNB VNB net59 GCLK
*.PININFO CLK:I GATE:I VGND:I VNB:I VNB:I net59:I GCLK:O
MI662 net75 m1 net59 VNB sky130_fd_pr__pfet_01v8_hvt m=1 w=0.42u l=0.15u mult=1
+ sa=0.265 sb=0.265 sd=0.28 area=0.063 perim=1.14
MI664 M0 clkpos net75 VNB sky130_fd_pr__pfet_01v8_hvt m=1 w=0.42u l=0.15u mult=1
+ sa=0.265 sb=0.265 sd=0.28 area=0.063 perim=1.14
MI659 net63 CLK net59 VNB sky130_fd_pr__pfet_01v8_hvt m=1 w=0.64u l=0.15u mult=1
+ sa=0.265 sb=0.265 sd=0.28 area=0.063 perim=1.14
MI658 net63 m1 net59 VNB sky130_fd_pr__pfet_01v8_hvt m=1 w=0.64u l=0.15u mult=1
+ sa=0.265 sb=0.265 sd=0.28 area=0.063 perim=1.14
MI19 m1 M0 net59 VNB sky130_fd_pr__pfet_01v8_hvt m=1 w=1.0u l=0.15u mult=1 sa=0.265
+ sb=0.265 sd=0.28 area=0.063 perim=1.14
MI38 M0 clkneg net54 VNB sky130_fd_pr__pfet_01v8_hvt m=1 w=0.42u l=0.15u mult=1
+ sa=0.265 sb=0.265 sd=0.28 area=0.063 perim=1.14
MI37 net54 GATE net59 VNB sky130_fd_pr__pfet_01v8_hvt m=1 w=0.64u l=0.15u mult=1
+ sa=0.265 sb=0.265 sd=0.28 area=0.063 perim=1.14
MI47 clkneg clkpos net59 VNB sky130_fd_pr__pfet_01v8_hvt m=1 w=0.64u l=0.15u mult=1
+ sa=0.265 sb=0.265 sd=0.28 area=0.063 perim=1.14
MI45 clkpos CLK net59 VNB sky130_fd_pr__pfet_01v8_hvt m=1 w=0.64u l=0.15u mult=1
+ sa=0.265 sb=0.265 sd=0.28 area=0.063 perim=1.14
MI660 GCLK net63 net59 VNB sky130_fd_pr__pfet_01v8_hvt m=1 w=1.0u l=0.15u mult=1
+ sa=0.265 sb=0.265 sd=0.28 area=0.063 perim=1.14
MI20 m1 M0 VGND VNB sky130_fd_pr__nfet_01v8 m=1 w=0.65u l=0.15u mult=1 sa=0.265
+ sb=0.265 sd=0.28 area=0.063 perim=1.14
MI655 M0 clkneg net110 VNB sky130_fd_pr__nfet_01v8 m=1 w=0.39u l=0.15u mult=1 sa=0.265
+ sb=0.265 sd=0.28 area=0.063 perim=1.14
MI654 net110 m1 VGND VNB sky130_fd_pr__nfet_01v8 m=1 w=0.42u l=0.15u mult=1 sa=0.265
+ sb=0.265 sd=0.28 area=0.063 perim=1.14
MI34 M0 clkpos net91 VNB sky130_fd_pr__nfet_01v8 m=1 w=0.42u l=0.15u mult=1 sa=0.265
+ sb=0.265 sd=0.28 area=0.063 perim=1.14
MI657 net99 CLK VGND VNB sky130_fd_pr__nfet_01v8 m=1 w=0.42u l=0.15u mult=1 sa=0.265
+ sb=0.265 sd=0.28 area=0.063 perim=1.14
MI656 net63 m1 net99 VNB sky130_fd_pr__nfet_01v8 m=1 w=0.42u l=0.15u mult=1 sa=0.265
+ sb=0.265 sd=0.28 area=0.063 perim=1.14
MI36 net91 GATE VGND VNB sky130_fd_pr__nfet_01v8 m=1 w=0.42u l=0.15u mult=1 sa=0.265
+ sb=0.265 sd=0.28 area=0.063 perim=1.14
MI46 clkneg clkpos VGND VNB sky130_fd_pr__nfet_01v8 m=1 w=0.42u l=0.15u mult=1
+ sa=0.265 sb=0.265 sd=0.28 area=0.063 perim=1.14
MI44 clkpos CLK VGND VNB sky130_fd_pr__nfet_01v8 m=1 w=0.42u l=0.15u mult=1 sa=0.265
+ sb=0.265 sd=0.28 area=0.063 perim=1.14
MI653 GCLK net63 VGND VNB sky130_fd_pr__nfet_01v8 m=1 w=0.65u l=0.15u mult=1 sa=0.265
+ sb=0.265 sd=0.28 area=0.063 perim=1.14
.ENDS sky130_fd_sc_hd__dlclkp_1
* Copyright 2020 The SkyWater PDK Authors
*
* Licensed under the Apache License, Version 2.0 (the "License");
* you may not use this file except in compliance with the License.
* You may obtain a copy of the License at
*
*     https:  www.apache.org licenses LICENSE-2.0
*
* Unless required by applicable law or agreed to in writing, software
* distributed under the License is distributed on an "AS IS" BASIS,
* WITHOUT WARRANTIES OR CONDITIONS OF ANY KIND, either express or implied.
* See the License for the specific language governing permissions and
* limitations under the License.
*
* SPDX-License-Identifier: Apache-2.0

.SUBCKT sky130_fd_sc_hd__dlclkp_2 CLK GATE VGND VNB VNB net59 GCLK
*.PININFO CLK:I GATE:I VGND:I VNB:I VNB:I net59:I GCLK:O
MI662 net75 m1 net59 VNB sky130_fd_pr__pfet_01v8_hvt m=1 w=0.42u l=0.15u mult=1
+ sa=0.265 sb=0.265 sd=0.28 area=0.063 perim=1.14
MI664 M0 clkpos net75 VNB sky130_fd_pr__pfet_01v8_hvt m=1 w=0.42u l=0.15u mult=1
+ sa=0.265 sb=0.265 sd=0.28 area=0.063 perim=1.14
MI659 net63 CLK net59 VNB sky130_fd_pr__pfet_01v8_hvt m=1 w=0.64u l=0.15u mult=1
+ sa=0.265 sb=0.265 sd=0.28 area=0.063 perim=1.14
MI658 net63 m1 net59 VNB sky130_fd_pr__pfet_01v8_hvt m=1 w=0.64u l=0.15u mult=1
+ sa=0.265 sb=0.265 sd=0.28 area=0.063 perim=1.14
MI19 m1 M0 net59 VNB sky130_fd_pr__pfet_01v8_hvt m=1 w=1.0u l=0.15u mult=1 sa=0.265
+ sb=0.265 sd=0.28 area=0.063 perim=1.14
MI38 M0 clkneg net54 VNB sky130_fd_pr__pfet_01v8_hvt m=1 w=0.42u l=0.15u mult=1
+ sa=0.265 sb=0.265 sd=0.28 area=0.063 perim=1.14
MI37 net54 GATE net59 VNB sky130_fd_pr__pfet_01v8_hvt m=1 w=0.64u l=0.15u mult=1
+ sa=0.265 sb=0.265 sd=0.28 area=0.063 perim=1.14
MI47 clkneg clkpos net59 VNB sky130_fd_pr__pfet_01v8_hvt m=1 w=0.64u l=0.15u mult=1
+ sa=0.265 sb=0.265 sd=0.28 area=0.063 perim=1.14
MI45 clkpos CLK net59 VNB sky130_fd_pr__pfet_01v8_hvt m=1 w=0.64u l=0.15u mult=1
+ sa=0.265 sb=0.265 sd=0.28 area=0.063 perim=1.14
MI660 GCLK net63 net59 VNB sky130_fd_pr__pfet_01v8_hvt m=2 w=1.0u l=0.15u mult=1
+ sa=0.265 sb=0.265 sd=0.28 area=0.063 perim=1.14
MI20 m1 M0 VGND VNB sky130_fd_pr__nfet_01v8 m=1 w=0.65u l=0.15u mult=1 sa=0.265
+ sb=0.265 sd=0.28 area=0.063 perim=1.14
MI655 M0 clkneg net110 VNB sky130_fd_pr__nfet_01v8 m=1 w=0.39u l=0.15u mult=1 sa=0.265
+ sb=0.265 sd=0.28 area=0.063 perim=1.14
MI654 net110 m1 VGND VNB sky130_fd_pr__nfet_01v8 m=1 w=0.42u l=0.15u mult=1 sa=0.265
+ sb=0.265 sd=0.28 area=0.063 perim=1.14
MI34 M0 clkpos net91 VNB sky130_fd_pr__nfet_01v8 m=1 w=0.42u l=0.15u mult=1 sa=0.265
+ sb=0.265 sd=0.28 area=0.063 perim=1.14
MI657 net99 CLK VGND VNB sky130_fd_pr__nfet_01v8 m=1 w=0.42u l=0.15u mult=1 sa=0.265
+ sb=0.265 sd=0.28 area=0.063 perim=1.14
MI656 net63 m1 net99 VNB sky130_fd_pr__nfet_01v8 m=1 w=0.42u l=0.15u mult=1 sa=0.265
+ sb=0.265 sd=0.28 area=0.063 perim=1.14
MI36 net91 GATE VGND VNB sky130_fd_pr__nfet_01v8 m=1 w=0.42u l=0.15u mult=1 sa=0.265
+ sb=0.265 sd=0.28 area=0.063 perim=1.14
MI46 clkneg clkpos VGND VNB sky130_fd_pr__nfet_01v8 m=1 w=0.42u l=0.15u mult=1
+ sa=0.265 sb=0.265 sd=0.28 area=0.063 perim=1.14
MI44 clkpos CLK VGND VNB sky130_fd_pr__nfet_01v8 m=1 w=0.42u l=0.15u mult=1 sa=0.265
+ sb=0.265 sd=0.28 area=0.063 perim=1.14
MI653 GCLK net63 VGND VNB sky130_fd_pr__nfet_01v8 m=2 w=0.65u l=0.15u mult=1 sa=0.265
+ sb=0.265 sd=0.28 area=0.063 perim=1.14
.ENDS sky130_fd_sc_hd__dlclkp_2
* Copyright 2020 The SkyWater PDK Authors
*
* Licensed under the Apache License, Version 2.0 (the "License");
* you may not use this file except in compliance with the License.
* You may obtain a copy of the License at
*
*     https:  www.apache.org licenses LICENSE-2.0
*
* Unless required by applicable law or agreed to in writing, software
* distributed under the License is distributed on an "AS IS" BASIS,
* WITHOUT WARRANTIES OR CONDITIONS OF ANY KIND, either express or implied.
* See the License for the specific language governing permissions and
* limitations under the License.
*
* SPDX-License-Identifier: Apache-2.0

.SUBCKT sky130_fd_sc_hd__dlclkp_4 CLK GATE VGND VNB VNB net59 GCLK
*.PININFO CLK:I GATE:I VGND:I VNB:I VNB:I net59:I GCLK:O
MI662 net75 m1 net59 VNB sky130_fd_pr__pfet_01v8_hvt m=1 w=0.42u l=0.15u mult=1
+ sa=0.265 sb=0.265 sd=0.28 area=0.063 perim=1.14
MI664 M0 clkpos net75 VNB sky130_fd_pr__pfet_01v8_hvt m=1 w=0.42u l=0.15u mult=1
+ sa=0.265 sb=0.265 sd=0.28 area=0.063 perim=1.14
MI659 net63 CLK net59 VNB sky130_fd_pr__pfet_01v8_hvt m=1 w=1.0u l=0.15u mult=1
+ sa=0.265 sb=0.265 sd=0.28 area=0.063 perim=1.14
MI658 net63 m1 net59 VNB sky130_fd_pr__pfet_01v8_hvt m=1 w=1.0u l=0.15u mult=1 sa=0.265
+ sb=0.265 sd=0.28 area=0.063 perim=1.14
MI19 m1 M0 net59 VNB sky130_fd_pr__pfet_01v8_hvt m=1 w=1.0u l=0.15u mult=1 sa=0.265
+ sb=0.265 sd=0.28 area=0.063 perim=1.14
MI38 M0 clkneg net54 VNB sky130_fd_pr__pfet_01v8_hvt m=1 w=0.42u l=0.15u mult=1
+ sa=0.265 sb=0.265 sd=0.28 area=0.063 perim=1.14
MI37 net54 GATE net59 VNB sky130_fd_pr__pfet_01v8_hvt m=1 w=0.64u l=0.15u mult=1
+ sa=0.265 sb=0.265 sd=0.28 area=0.063 perim=1.14
MI47 clkneg clkpos net59 VNB sky130_fd_pr__pfet_01v8_hvt m=1 w=0.64u l=0.15u mult=1
+ sa=0.265 sb=0.265 sd=0.28 area=0.063 perim=1.14
MI45 clkpos CLK net59 VNB sky130_fd_pr__pfet_01v8_hvt m=1 w=0.64u l=0.15u mult=1
+ sa=0.265 sb=0.265 sd=0.28 area=0.063 perim=1.14
MI660 GCLK net63 net59 VNB sky130_fd_pr__pfet_01v8_hvt m=4 w=1.0u l=0.15u mult=1
+ sa=0.265 sb=0.265 sd=0.28 area=0.063 perim=1.14
MI20 m1 M0 VGND VNB sky130_fd_pr__nfet_01v8 m=1 w=0.65u l=0.15u mult=1 sa=0.265
+ sb=0.265 sd=0.28 area=0.063 perim=1.14
MI655 M0 clkneg net110 VNB sky130_fd_pr__nfet_01v8 m=1 w=0.36u l=0.15u mult=1 sa=0.265
+ sb=0.265 sd=0.28 area=0.063 perim=1.14
MI654 net110 m1 VGND VNB sky130_fd_pr__nfet_01v8 m=1 w=0.42u l=0.15u mult=1 sa=0.265
+ sb=0.265 sd=0.28 area=0.063 perim=1.14
MI34 M0 clkpos net91 VNB sky130_fd_pr__nfet_01v8 m=1 w=0.36u l=0.15u mult=1 sa=0.265
+ sb=0.265 sd=0.28 area=0.063 perim=1.14
MI657 net99 CLK VGND VNB sky130_fd_pr__nfet_01v8 m=1 w=0.65u l=0.15u mult=1 sa=0.265
+ sb=0.265 sd=0.28 area=0.063 perim=1.14
MI656 net63 m1 net99 VNB sky130_fd_pr__nfet_01v8 m=1 w=0.65u l=0.15u mult=1 sa=0.265
+ sb=0.265 sd=0.28 area=0.063 perim=1.14
MI36 net91 GATE VGND VNB sky130_fd_pr__nfet_01v8 m=1 w=0.42u l=0.15u mult=1 sa=0.265
+ sb=0.265 sd=0.28 area=0.063 perim=1.14
MI46 clkneg clkpos VGND VNB sky130_fd_pr__nfet_01v8 m=1 w=0.42u l=0.15u mult=1
+ sa=0.265 sb=0.265 sd=0.28 area=0.063 perim=1.14
MI44 clkpos CLK VGND VNB sky130_fd_pr__nfet_01v8 m=1 w=0.42u l=0.15u mult=1 sa=0.265
+ sb=0.265 sd=0.28 area=0.063 perim=1.14
MI653 GCLK net63 VGND VNB sky130_fd_pr__nfet_01v8 m=4 w=0.65u l=0.15u mult=1 sa=0.265
+ sb=0.265 sd=0.28 area=0.063 perim=1.14
.ENDS sky130_fd_sc_hd__dlclkp_4
* Copyright 2020 The SkyWater PDK Authors
*
* Licensed under the Apache License, Version 2.0 (the "License");
* you may not use this file except in compliance with the License.
* You may obtain a copy of the License at
*
*     https:  www.apache.org licenses LICENSE-2.0
*
* Unless required by applicable law or agreed to in writing, software
* distributed under the License is distributed on an "AS IS" BASIS,
* WITHOUT WARRANTIES OR CONDITIONS OF ANY KIND, either express or implied.
* See the License for the specific language governing permissions and
* limitations under the License.
*
* SPDX-License-Identifier: Apache-2.0

.SUBCKT sky130_fd_sc_hd__dlrbn_1 D GATE_N RESET_B VGND VNB VNB net59 Q Q_N
*.PININFO D:I GATE_N:I RESET_B:I VGND:I VNB:I VNB:I net59:I Q:O Q_N:O
MI635 clkneg clkpos net59 VNB sky130_fd_pr__pfet_01v8_hvt m=1 w=0.64u l=0.15u mult=1
+ sa=0.265 sb=0.265 sd=0.28 area=0.063 perim=1.14
MI648 Q_N net125 net59 VNB sky130_fd_pr__pfet_01v8_hvt m=1 w=1.0u l=0.15u mult=1
+ sa=0.265 sb=0.265 sd=0.28 area=0.063 perim=1.14
MI17 M0 clkneg net61 VNB sky130_fd_pr__pfet_01v8_hvt m=1 w=0.42u l=0.15u mult=1
+ sa=0.265 sb=0.265 sd=0.28 area=0.063 perim=1.14
MI646 net125 m1 net59 VNB sky130_fd_pr__pfet_01v8_hvt m=1 w=0.64u l=0.15u mult=1
+ sa=0.265 sb=0.265 sd=0.28 area=0.063 perim=1.14
MI650 Q m1 net59 VNB sky130_fd_pr__pfet_01v8_hvt m=1 w=1.0u l=0.15u mult=1 sa=0.265
+ sb=0.265 sd=0.28 area=0.063 perim=1.14
MI633 clkpos GATE_N net59 VNB sky130_fd_pr__pfet_01v8_hvt m=1 w=0.64u l=0.15u mult=1
+ sa=0.265 sb=0.265 sd=0.28 area=0.063 perim=1.14
MI658 m1 RESET_B net59 VNB sky130_fd_pr__pfet_01v8_hvt m=1 w=1.0u l=0.15u mult=1
+ sa=0.265 sb=0.265 sd=0.28 area=0.063 perim=1.14
MI18 net61 db net59 VNB sky130_fd_pr__pfet_01v8_hvt m=1 w=0.64u l=0.15u mult=1 sa=0.265
+ sb=0.265 sd=0.28 area=0.063 perim=1.14
MI653 net57 m1 net59 VNB sky130_fd_pr__pfet_01v8_hvt m=1 w=0.42u l=0.15u mult=1
+ sa=0.265 sb=0.265 sd=0.28 area=0.063 perim=1.14
MI651 M0 clkpos net57 VNB sky130_fd_pr__pfet_01v8_hvt m=1 w=0.42u l=0.15u mult=1
+ sa=0.265 sb=0.265 sd=0.28 area=0.063 perim=1.14
MI655 m1 M0 net59 VNB sky130_fd_pr__pfet_01v8_hvt m=1 w=1.0u l=0.15u mult=1 sa=0.265
+ sb=0.265 sd=0.28 area=0.063 perim=1.14
MI638 db D net59 VNB sky130_fd_pr__pfet_01v8_hvt m=1 w=0.64u l=0.15u mult=1 sa=0.265
+ sb=0.265 sd=0.28 area=0.063 perim=1.14
MI634 clkpos GATE_N VGND VNB sky130_fd_pr__nfet_01v8 m=1 w=0.42u l=0.15u mult=1
+ sa=0.265 sb=0.265 sd=0.28 area=0.063 perim=1.14
MI647 Q_N net125 VGND VNB sky130_fd_pr__nfet_01v8 m=1 w=0.65u l=0.15u mult=1 sa=0.265
+ sb=0.265 sd=0.28 area=0.063 perim=1.14
MI649 Q m1 VGND VNB sky130_fd_pr__nfet_01v8 m=1 w=0.65u l=0.15u mult=1 sa=0.265
+ sb=0.265 sd=0.28 area=0.063 perim=1.14
MI645 net125 m1 VGND VNB sky130_fd_pr__nfet_01v8 m=1 w=0.42u l=0.15u mult=1 sa=0.265
+ sb=0.265 sd=0.28 area=0.063 perim=1.14
MI657 net108 RESET_B VGND VNB sky130_fd_pr__nfet_01v8 m=1 w=0.65u l=0.15u mult=1
+ sa=0.265 sb=0.265 sd=0.28 area=0.063 perim=1.14
MI652 M0 clkneg net116 VNB sky130_fd_pr__nfet_01v8 m=1 w=0.36u l=0.15u mult=1 sa=0.265
+ sb=0.265 sd=0.28 area=0.063 perim=1.14
MI654 net116 m1 VGND VNB sky130_fd_pr__nfet_01v8 m=1 w=0.42u l=0.15u mult=1 sa=0.265
+ sb=0.265 sd=0.28 area=0.063 perim=1.14
MI656 m1 M0 net108 VNB sky130_fd_pr__nfet_01v8 m=1 w=0.65u l=0.15u mult=1 sa=0.265
+ sb=0.265 sd=0.28 area=0.063 perim=1.14
MI636 clkneg clkpos VGND VNB sky130_fd_pr__nfet_01v8 m=1 w=0.42u l=0.15u mult=1
+ sa=0.265 sb=0.265 sd=0.28 area=0.063 perim=1.14
MI637 db D VGND VNB sky130_fd_pr__nfet_01v8 m=1 w=0.42u l=0.15u mult=1 sa=0.265
+ sb=0.265 sd=0.28 area=0.063 perim=1.14
MI19 M0 clkpos net96 VNB sky130_fd_pr__nfet_01v8 m=1 w=0.36u l=0.15u mult=1 sa=0.265
+ sb=0.265 sd=0.28 area=0.063 perim=1.14
MI20 net96 db VGND VNB sky130_fd_pr__nfet_01v8 m=1 w=0.42u l=0.15u mult=1 sa=0.265
+ sb=0.265 sd=0.28 area=0.063 perim=1.14
.ENDS sky130_fd_sc_hd__dlrbn_1
* Copyright 2020 The SkyWater PDK Authors
*
* Licensed under the Apache License, Version 2.0 (the "License");
* you may not use this file except in compliance with the License.
* You may obtain a copy of the License at
*
*     https:  www.apache.org licenses LICENSE-2.0
*
* Unless required by applicable law or agreed to in writing, software
* distributed under the License is distributed on an "AS IS" BASIS,
* WITHOUT WARRANTIES OR CONDITIONS OF ANY KIND, either express or implied.
* See the License for the specific language governing permissions and
* limitations under the License.
*
* SPDX-License-Identifier: Apache-2.0

.SUBCKT sky130_fd_sc_hd__dlrbn_2 D GATE_N RESET_B VGND VNB VNB net59 Q Q_N
*.PININFO D:I GATE_N:I RESET_B:I VGND:I VNB:I VNB:I net59:I Q:O Q_N:O
MI635 clkneg clkpos net59 VNB sky130_fd_pr__pfet_01v8_hvt m=1 w=0.64u l=0.15u mult=1
+ sa=0.265 sb=0.265 sd=0.28 area=0.063 perim=1.14
MI648 Q_N net125 net59 VNB sky130_fd_pr__pfet_01v8_hvt m=2 w=1.0u l=0.15u mult=1
+ sa=0.265 sb=0.265 sd=0.28 area=0.063 perim=1.14
MI17 M0 clkneg net61 VNB sky130_fd_pr__pfet_01v8_hvt m=1 w=0.42u l=0.15u mult=1
+ sa=0.265 sb=0.265 sd=0.28 area=0.063 perim=1.14
MI646 net125 m1 net59 VNB sky130_fd_pr__pfet_01v8_hvt m=1 w=0.64u l=0.15u mult=1
+ sa=0.265 sb=0.265 sd=0.28 area=0.063 perim=1.14
MI650 Q m1 net59 VNB sky130_fd_pr__pfet_01v8_hvt m=2 w=1.0u l=0.15u mult=1 sa=0.265
+ sb=0.265 sd=0.28 area=0.063 perim=1.14
MI633 clkpos GATE_N net59 VNB sky130_fd_pr__pfet_01v8_hvt m=1 w=0.64u l=0.15u mult=1
+ sa=0.265 sb=0.265 sd=0.28 area=0.063 perim=1.14
MI658 m1 RESET_B net59 VNB sky130_fd_pr__pfet_01v8_hvt m=1 w=1.0u l=0.15u mult=1
+ sa=0.265 sb=0.265 sd=0.28 area=0.063 perim=1.14
MI18 net61 db net59 VNB sky130_fd_pr__pfet_01v8_hvt m=1 w=0.64u l=0.15u mult=1 sa=0.265
+ sb=0.265 sd=0.28 area=0.063 perim=1.14
MI653 net57 m1 net59 VNB sky130_fd_pr__pfet_01v8_hvt m=1 w=0.42u l=0.15u mult=1
+ sa=0.265 sb=0.265 sd=0.28 area=0.063 perim=1.14
MI651 M0 clkpos net57 VNB sky130_fd_pr__pfet_01v8_hvt m=1 w=0.42u l=0.15u mult=1
+ sa=0.265 sb=0.265 sd=0.28 area=0.063 perim=1.14
MI655 m1 M0 net59 VNB sky130_fd_pr__pfet_01v8_hvt m=1 w=1.0u l=0.15u mult=1 sa=0.265
+ sb=0.265 sd=0.28 area=0.063 perim=1.14
MI638 db D net59 VNB sky130_fd_pr__pfet_01v8_hvt m=1 w=0.64u l=0.15u mult=1 sa=0.265
+ sb=0.265 sd=0.28 area=0.063 perim=1.14
MI634 clkpos GATE_N VGND VNB sky130_fd_pr__nfet_01v8 m=1 w=0.42u l=0.15u mult=1
+ sa=0.265 sb=0.265 sd=0.28 area=0.063 perim=1.14
MI647 Q_N net125 VGND VNB sky130_fd_pr__nfet_01v8 m=2 w=0.65u l=0.15u mult=1 sa=0.265
+ sb=0.265 sd=0.28 area=0.063 perim=1.14
MI649 Q m1 VGND VNB sky130_fd_pr__nfet_01v8 m=2 w=0.65u l=0.15u mult=1 sa=0.265
+ sb=0.265 sd=0.28 area=0.063 perim=1.14
MI645 net125 m1 VGND VNB sky130_fd_pr__nfet_01v8 m=1 w=0.42u l=0.15u mult=1 sa=0.265
+ sb=0.265 sd=0.28 area=0.063 perim=1.14
MI657 net108 RESET_B VGND VNB sky130_fd_pr__nfet_01v8 m=1 w=0.65u l=0.15u mult=1
+ sa=0.265 sb=0.265 sd=0.28 area=0.063 perim=1.14
MI652 M0 clkneg net116 VNB sky130_fd_pr__nfet_01v8 m=1 w=0.36u l=0.15u mult=1 sa=0.265
+ sb=0.265 sd=0.28 area=0.063 perim=1.14
MI654 net116 m1 VGND VNB sky130_fd_pr__nfet_01v8 m=1 w=0.42u l=0.15u mult=1 sa=0.265
+ sb=0.265 sd=0.28 area=0.063 perim=1.14
MI656 m1 M0 net108 VNB sky130_fd_pr__nfet_01v8 m=1 w=0.65u l=0.15u mult=1 sa=0.265
+ sb=0.265 sd=0.28 area=0.063 perim=1.14
MI636 clkneg clkpos VGND VNB sky130_fd_pr__nfet_01v8 m=1 w=0.42u l=0.15u mult=1
+ sa=0.265 sb=0.265 sd=0.28 area=0.063 perim=1.14
MI637 db D VGND VNB sky130_fd_pr__nfet_01v8 m=1 w=0.42u l=0.15u mult=1 sa=0.265
+ sb=0.265 sd=0.28 area=0.063 perim=1.14
MI19 M0 clkpos net96 VNB sky130_fd_pr__nfet_01v8 m=1 w=0.36u l=0.15u mult=1 sa=0.265
+ sb=0.265 sd=0.28 area=0.063 perim=1.14
MI20 net96 db VGND VNB sky130_fd_pr__nfet_01v8 m=1 w=0.42u l=0.15u mult=1 sa=0.265
+ sb=0.265 sd=0.28 area=0.063 perim=1.14
.ENDS sky130_fd_sc_hd__dlrbn_2
* Copyright 2020 The SkyWater PDK Authors
*
* Licensed under the Apache License, Version 2.0 (the "License");
* you may not use this file except in compliance with the License.
* You may obtain a copy of the License at
*
*     https:  www.apache.org licenses LICENSE-2.0
*
* Unless required by applicable law or agreed to in writing, software
* distributed under the License is distributed on an "AS IS" BASIS,
* WITHOUT WARRANTIES OR CONDITIONS OF ANY KIND, either express or implied.
* See the License for the specific language governing permissions and
* limitations under the License.
*
* SPDX-License-Identifier: Apache-2.0

.SUBCKT sky130_fd_sc_hd__dlrbp_1 D GATE RESET_B VGND VNB VNB net59 Q Q_N
*.PININFO D:I GATE:I RESET_B:I VGND:I VNB:I VNB:I net59:I Q:O Q_N:O
MI635 clkpos clkneg net59 VNB sky130_fd_pr__pfet_01v8_hvt m=1 w=0.64u l=0.15u mult=1
+ sa=0.265 sb=0.265 sd=0.28 area=0.063 perim=1.14
MI648 Q_N net125 net59 VNB sky130_fd_pr__pfet_01v8_hvt m=1 w=1.0u l=0.15u mult=1
+ sa=0.265 sb=0.265 sd=0.28 area=0.063 perim=1.14
MI17 M0 clkneg net61 VNB sky130_fd_pr__pfet_01v8_hvt m=1 w=0.42u l=0.15u mult=1
+ sa=0.265 sb=0.265 sd=0.28 area=0.063 perim=1.14
MI646 net125 m1 net59 VNB sky130_fd_pr__pfet_01v8_hvt m=1 w=0.64u l=0.15u mult=1
+ sa=0.265 sb=0.265 sd=0.28 area=0.063 perim=1.14
MI650 Q m1 net59 VNB sky130_fd_pr__pfet_01v8_hvt m=1 w=1.0u l=0.15u mult=1 sa=0.265
+ sb=0.265 sd=0.28 area=0.063 perim=1.14
MI633 clkneg GATE net59 VNB sky130_fd_pr__pfet_01v8_hvt m=1 w=0.64u l=0.15u mult=1
+ sa=0.265 sb=0.265 sd=0.28 area=0.063 perim=1.14
MI658 m1 RESET_B net59 VNB sky130_fd_pr__pfet_01v8_hvt m=1 w=1.0u l=0.15u mult=1
+ sa=0.265 sb=0.265 sd=0.28 area=0.063 perim=1.14
MI18 net61 db net59 VNB sky130_fd_pr__pfet_01v8_hvt m=1 w=0.64u l=0.15u mult=1 sa=0.265
+ sb=0.265 sd=0.28 area=0.063 perim=1.14
MI653 net57 m1 net59 VNB sky130_fd_pr__pfet_01v8_hvt m=1 w=0.42u l=0.15u mult=1
+ sa=0.265 sb=0.265 sd=0.28 area=0.063 perim=1.14
MI651 M0 clkpos net57 VNB sky130_fd_pr__pfet_01v8_hvt m=1 w=0.42u l=0.15u mult=1
+ sa=0.265 sb=0.265 sd=0.28 area=0.063 perim=1.14
MI655 m1 M0 net59 VNB sky130_fd_pr__pfet_01v8_hvt m=1 w=1.0u l=0.15u mult=1 sa=0.265
+ sb=0.265 sd=0.28 area=0.063 perim=1.14
MI638 db D net59 VNB sky130_fd_pr__pfet_01v8_hvt m=1 w=0.64u l=0.15u mult=1 sa=0.265
+ sb=0.265 sd=0.28 area=0.063 perim=1.14
MI634 clkneg GATE VGND VNB sky130_fd_pr__nfet_01v8 m=1 w=0.42u l=0.15u mult=1 sa=0.265
+ sb=0.265 sd=0.28 area=0.063 perim=1.14
MI647 Q_N net125 VGND VNB sky130_fd_pr__nfet_01v8 m=1 w=0.65u l=0.15u mult=1 sa=0.265
+ sb=0.265 sd=0.28 area=0.063 perim=1.14
MI649 Q m1 VGND VNB sky130_fd_pr__nfet_01v8 m=1 w=0.65u l=0.15u mult=1 sa=0.265
+ sb=0.265 sd=0.28 area=0.063 perim=1.14
MI645 net125 m1 VGND VNB sky130_fd_pr__nfet_01v8 m=1 w=0.42u l=0.15u mult=1 sa=0.265
+ sb=0.265 sd=0.28 area=0.063 perim=1.14
MI657 net121 RESET_B VGND VNB sky130_fd_pr__nfet_01v8 m=1 w=0.65u l=0.15u mult=1
+ sa=0.265 sb=0.265 sd=0.28 area=0.063 perim=1.14
MI652 M0 clkneg net116 VNB sky130_fd_pr__nfet_01v8 m=1 w=0.36u l=0.15u mult=1 sa=0.265
+ sb=0.265 sd=0.28 area=0.063 perim=1.14
MI654 net116 m1 VGND VNB sky130_fd_pr__nfet_01v8 m=1 w=0.42u l=0.15u mult=1 sa=0.265
+ sb=0.265 sd=0.28 area=0.063 perim=1.14
MI656 m1 M0 net121 VNB sky130_fd_pr__nfet_01v8 m=1 w=0.65u l=0.15u mult=1 sa=0.265
+ sb=0.265 sd=0.28 area=0.063 perim=1.14
MI636 clkpos clkneg VGND VNB sky130_fd_pr__nfet_01v8 m=1 w=0.42u l=0.15u mult=1
+ sa=0.265 sb=0.265 sd=0.28 area=0.063 perim=1.14
MI637 db D VGND VNB sky130_fd_pr__nfet_01v8 m=1 w=0.42u l=0.15u mult=1 sa=0.265
+ sb=0.265 sd=0.28 area=0.063 perim=1.14
MI19 M0 clkpos net96 VNB sky130_fd_pr__nfet_01v8 m=1 w=0.36u l=0.15u mult=1 sa=0.265
+ sb=0.265 sd=0.28 area=0.063 perim=1.14
MI20 net96 db VGND VNB sky130_fd_pr__nfet_01v8 m=1 w=0.42u l=0.15u mult=1 sa=0.265
+ sb=0.265 sd=0.28 area=0.063 perim=1.14
.ENDS sky130_fd_sc_hd__dlrbp_1
* Copyright 2020 The SkyWater PDK Authors
*
* Licensed under the Apache License, Version 2.0 (the "License");
* you may not use this file except in compliance with the License.
* You may obtain a copy of the License at
*
*     https:  www.apache.org licenses LICENSE-2.0
*
* Unless required by applicable law or agreed to in writing, software
* distributed under the License is distributed on an "AS IS" BASIS,
* WITHOUT WARRANTIES OR CONDITIONS OF ANY KIND, either express or implied.
* See the License for the specific language governing permissions and
* limitations under the License.
*
* SPDX-License-Identifier: Apache-2.0

.SUBCKT sky130_fd_sc_hd__dlrbp_2 D GATE RESET_B VGND VNB VNB net59 Q Q_N
*.PININFO D:I GATE:I RESET_B:I VGND:I VNB:I VNB:I net59:I Q:O Q_N:O
MI635 clkpos clkneg net59 VNB sky130_fd_pr__pfet_01v8_hvt m=1 w=0.64u l=0.15u mult=1
+ sa=0.265 sb=0.265 sd=0.28 area=0.063 perim=1.14
MI648 Q_N net125 net59 VNB sky130_fd_pr__pfet_01v8_hvt m=2 w=1.0u l=0.15u mult=1
+ sa=0.265 sb=0.265 sd=0.28 area=0.063 perim=1.14
MI17 M0 clkneg net61 VNB sky130_fd_pr__pfet_01v8_hvt m=1 w=0.42u l=0.15u mult=1
+ sa=0.265 sb=0.265 sd=0.28 area=0.063 perim=1.14
MI646 net125 m1 net59 VNB sky130_fd_pr__pfet_01v8_hvt m=1 w=0.64u l=0.15u mult=1
+ sa=0.265 sb=0.265 sd=0.28 area=0.063 perim=1.14
MI650 Q m1 net59 VNB sky130_fd_pr__pfet_01v8_hvt m=2 w=1.0u l=0.15u mult=1 sa=0.265
+ sb=0.265 sd=0.28 area=0.063 perim=1.14
MI633 clkneg GATE net59 VNB sky130_fd_pr__pfet_01v8_hvt m=1 w=0.64u l=0.15u mult=1
+ sa=0.265 sb=0.265 sd=0.28 area=0.063 perim=1.14
MI658 m1 RESET_B net59 VNB sky130_fd_pr__pfet_01v8_hvt m=1 w=1.0u l=0.15u mult=1
+ sa=0.265 sb=0.265 sd=0.28 area=0.063 perim=1.14
MI18 net61 db net59 VNB sky130_fd_pr__pfet_01v8_hvt m=1 w=0.64u l=0.15u mult=1 sa=0.265
+ sb=0.265 sd=0.28 area=0.063 perim=1.14
MI653 net57 m1 net59 VNB sky130_fd_pr__pfet_01v8_hvt m=1 w=0.42u l=0.15u mult=1
+ sa=0.265 sb=0.265 sd=0.28 area=0.063 perim=1.14
MI651 M0 clkpos net57 VNB sky130_fd_pr__pfet_01v8_hvt m=1 w=0.42u l=0.15u mult=1
+ sa=0.265 sb=0.265 sd=0.28 area=0.063 perim=1.14
MI655 m1 M0 net59 VNB sky130_fd_pr__pfet_01v8_hvt m=1 w=1.0u l=0.15u mult=1 sa=0.265
+ sb=0.265 sd=0.28 area=0.063 perim=1.14
MI638 db D net59 VNB sky130_fd_pr__pfet_01v8_hvt m=1 w=0.64u l=0.15u mult=1 sa=0.265
+ sb=0.265 sd=0.28 area=0.063 perim=1.14
MI634 clkneg GATE VGND VNB sky130_fd_pr__nfet_01v8 m=1 w=0.42u l=0.15u mult=1 sa=0.265
+ sb=0.265 sd=0.28 area=0.063 perim=1.14
MI647 Q_N net125 VGND VNB sky130_fd_pr__nfet_01v8 m=2 w=0.65u l=0.15u mult=1 sa=0.265
+ sb=0.265 sd=0.28 area=0.063 perim=1.14
MI649 Q m1 VGND VNB sky130_fd_pr__nfet_01v8 m=2 w=0.65u l=0.15u mult=1 sa=0.265
+ sb=0.265 sd=0.28 area=0.063 perim=1.14
MI645 net125 m1 VGND VNB sky130_fd_pr__nfet_01v8 m=1 w=0.42u l=0.15u mult=1 sa=0.265
+ sb=0.265 sd=0.28 area=0.063 perim=1.14
MI657 net108 RESET_B VGND VNB sky130_fd_pr__nfet_01v8 m=1 w=0.65u l=0.15u mult=1
+ sa=0.265 sb=0.265 sd=0.28 area=0.063 perim=1.14
MI652 M0 clkneg net116 VNB sky130_fd_pr__nfet_01v8 m=1 w=0.36u l=0.15u mult=1 sa=0.265
+ sb=0.265 sd=0.28 area=0.063 perim=1.14
MI654 net116 m1 VGND VNB sky130_fd_pr__nfet_01v8 m=1 w=0.42u l=0.15u mult=1 sa=0.265
+ sb=0.265 sd=0.28 area=0.063 perim=1.14
MI656 m1 M0 net108 VNB sky130_fd_pr__nfet_01v8 m=1 w=0.65u l=0.15u mult=1 sa=0.265
+ sb=0.265 sd=0.28 area=0.063 perim=1.14
MI636 clkpos clkneg VGND VNB sky130_fd_pr__nfet_01v8 m=1 w=0.42u l=0.15u mult=1
+ sa=0.265 sb=0.265 sd=0.28 area=0.063 perim=1.14
MI637 db D VGND VNB sky130_fd_pr__nfet_01v8 m=1 w=0.42u l=0.15u mult=1 sa=0.265
+ sb=0.265 sd=0.28 area=0.063 perim=1.14
MI19 M0 clkpos net96 VNB sky130_fd_pr__nfet_01v8 m=1 w=0.36u l=0.15u mult=1 sa=0.265
+ sb=0.265 sd=0.28 area=0.063 perim=1.14
MI20 net96 db VGND VNB sky130_fd_pr__nfet_01v8 m=1 w=0.42u l=0.15u mult=1 sa=0.265
+ sb=0.265 sd=0.28 area=0.063 perim=1.14
.ENDS sky130_fd_sc_hd__dlrbp_2
* Copyright 2020 The SkyWater PDK Authors
*
* Licensed under the Apache License, Version 2.0 (the "License");
* you may not use this file except in compliance with the License.
* You may obtain a copy of the License at
*
*     https:  www.apache.org licenses LICENSE-2.0
*
* Unless required by applicable law or agreed to in writing, software
* distributed under the License is distributed on an "AS IS" BASIS,
* WITHOUT WARRANTIES OR CONDITIONS OF ANY KIND, either express or implied.
* See the License for the specific language governing permissions and
* limitations under the License.
*
* SPDX-License-Identifier: Apache-2.0

.SUBCKT sky130_fd_sc_hd__dlrtn_1 D GATE_N RESET_B VGND VNB VNB net59 Q
*.PININFO D:I GATE_N:I RESET_B:I VGND:I VNB:I VNB:I net59:I Q:O
MI635 clkneg clkpos net59 VNB sky130_fd_pr__pfet_01v8_hvt m=1 w=0.64u l=0.15u mult=1
+ sa=0.265 sb=0.265 sd=0.28 area=0.063 perim=1.14
MI17 M0 clkneg net54 VNB sky130_fd_pr__pfet_01v8_hvt m=1 w=0.42u l=0.15u mult=1
+ sa=0.265 sb=0.265 sd=0.28 area=0.063 perim=1.14
MI650 Q m1 net59 VNB sky130_fd_pr__pfet_01v8_hvt m=1 w=1.0u l=0.15u mult=1 sa=0.265
+ sb=0.265 sd=0.28 area=0.063 perim=1.14
MI633 clkpos GATE_N net59 VNB sky130_fd_pr__pfet_01v8_hvt m=1 w=0.64u l=0.15u mult=1
+ sa=0.265 sb=0.265 sd=0.28 area=0.063 perim=1.14
MI658 m1 RESET_B net59 VNB sky130_fd_pr__pfet_01v8_hvt m=1 w=1.0u l=0.15u mult=1
+ sa=0.265 sb=0.265 sd=0.28 area=0.063 perim=1.14
MI18 net54 db net59 VNB sky130_fd_pr__pfet_01v8_hvt m=1 w=0.64u l=0.15u mult=1 sa=0.265
+ sb=0.265 sd=0.28 area=0.063 perim=1.14
MI653 net50 m1 net59 VNB sky130_fd_pr__pfet_01v8_hvt m=1 w=0.42u l=0.15u mult=1
+ sa=0.265 sb=0.265 sd=0.28 area=0.063 perim=1.14
MI651 M0 clkpos net50 VNB sky130_fd_pr__pfet_01v8_hvt m=1 w=0.42u l=0.15u mult=1
+ sa=0.265 sb=0.265 sd=0.28 area=0.063 perim=1.14
MI655 m1 M0 net59 VNB sky130_fd_pr__pfet_01v8_hvt m=1 w=1.0u l=0.15u mult=1 sa=0.265
+ sb=0.265 sd=0.28 area=0.063 perim=1.14
MI638 db D net59 VNB sky130_fd_pr__pfet_01v8_hvt m=1 w=0.64u l=0.15u mult=1 sa=0.265
+ sb=0.265 sd=0.28 area=0.063 perim=1.14
MI634 clkpos GATE_N VGND VNB sky130_fd_pr__nfet_01v8 m=1 w=0.42u l=0.15u mult=1
+ sa=0.265 sb=0.265 sd=0.28 area=0.063 perim=1.14
MI649 Q m1 VGND VNB sky130_fd_pr__nfet_01v8 m=1 w=0.65u l=0.15u mult=1 sa=0.265
+ sb=0.265 sd=0.28 area=0.063 perim=1.14
MI657 net93 RESET_B VGND VNB sky130_fd_pr__nfet_01v8 m=1 w=0.65u l=0.15u mult=1
+ sa=0.265 sb=0.265 sd=0.28 area=0.063 perim=1.14
MI652 M0 clkneg net101 VNB sky130_fd_pr__nfet_01v8 m=1 w=0.36u l=0.15u mult=1 sa=0.265
+ sb=0.265 sd=0.28 area=0.063 perim=1.14
MI654 net101 m1 VGND VNB sky130_fd_pr__nfet_01v8 m=1 w=0.42u l=0.15u mult=1 sa=0.265
+ sb=0.265 sd=0.28 area=0.063 perim=1.14
MI656 m1 M0 net93 VNB sky130_fd_pr__nfet_01v8 m=1 w=0.65u l=0.15u mult=1 sa=0.265
+ sb=0.265 sd=0.28 area=0.063 perim=1.14
MI636 clkneg clkpos VGND VNB sky130_fd_pr__nfet_01v8 m=1 w=0.42u l=0.15u mult=1
+ sa=0.265 sb=0.265 sd=0.28 area=0.063 perim=1.14
MI637 db D VGND VNB sky130_fd_pr__nfet_01v8 m=1 w=0.42u l=0.15u mult=1 sa=0.265
+ sb=0.265 sd=0.28 area=0.063 perim=1.14
MI19 M0 clkpos net81 VNB sky130_fd_pr__nfet_01v8 m=1 w=0.36u l=0.15u mult=1 sa=0.265
+ sb=0.265 sd=0.28 area=0.063 perim=1.14
MI20 net81 db VGND VNB sky130_fd_pr__nfet_01v8 m=1 w=0.42u l=0.15u mult=1 sa=0.265
+ sb=0.265 sd=0.28 area=0.063 perim=1.14
.ENDS sky130_fd_sc_hd__dlrtn_1
* Copyright 2020 The SkyWater PDK Authors
*
* Licensed under the Apache License, Version 2.0 (the "License");
* you may not use this file except in compliance with the License.
* You may obtain a copy of the License at
*
*     https:  www.apache.org licenses LICENSE-2.0
*
* Unless required by applicable law or agreed to in writing, software
* distributed under the License is distributed on an "AS IS" BASIS,
* WITHOUT WARRANTIES OR CONDITIONS OF ANY KIND, either express or implied.
* See the License for the specific language governing permissions and
* limitations under the License.
*
* SPDX-License-Identifier: Apache-2.0

.SUBCKT sky130_fd_sc_hd__dlrtn_2 D GATE_N RESET_B VGND VNB VNB net59 Q
*.PININFO D:I GATE_N:I RESET_B:I VGND:I VNB:I VNB:I net59:I Q:O
MI635 clkneg clkpos net59 VNB sky130_fd_pr__pfet_01v8_hvt m=1 w=0.64u l=0.15u mult=1
+ sa=0.265 sb=0.265 sd=0.28 area=0.063 perim=1.14
MI17 M0 clkneg net54 VNB sky130_fd_pr__pfet_01v8_hvt m=1 w=0.42u l=0.15u mult=1
+ sa=0.265 sb=0.265 sd=0.28 area=0.063 perim=1.14
MI650 Q m1 net59 VNB sky130_fd_pr__pfet_01v8_hvt m=2 w=1.0u l=0.15u mult=1 sa=0.265
+ sb=0.265 sd=0.28 area=0.063 perim=1.14
MI633 clkpos GATE_N net59 VNB sky130_fd_pr__pfet_01v8_hvt m=1 w=0.64u l=0.15u mult=1
+ sa=0.265 sb=0.265 sd=0.28 area=0.063 perim=1.14
MI658 m1 RESET_B net59 VNB sky130_fd_pr__pfet_01v8_hvt m=1 w=1.0u l=0.15u mult=1
+ sa=0.265 sb=0.265 sd=0.28 area=0.063 perim=1.14
MI18 net54 db net59 VNB sky130_fd_pr__pfet_01v8_hvt m=1 w=0.64u l=0.15u mult=1 sa=0.265
+ sb=0.265 sd=0.28 area=0.063 perim=1.14
MI653 net50 m1 net59 VNB sky130_fd_pr__pfet_01v8_hvt m=1 w=0.42u l=0.15u mult=1
+ sa=0.265 sb=0.265 sd=0.28 area=0.063 perim=1.14
MI651 M0 clkpos net50 VNB sky130_fd_pr__pfet_01v8_hvt m=1 w=0.42u l=0.15u mult=1
+ sa=0.265 sb=0.265 sd=0.28 area=0.063 perim=1.14
MI655 m1 M0 net59 VNB sky130_fd_pr__pfet_01v8_hvt m=1 w=1.0u l=0.15u mult=1 sa=0.265
+ sb=0.265 sd=0.28 area=0.063 perim=1.14
MI638 db D net59 VNB sky130_fd_pr__pfet_01v8_hvt m=1 w=0.64u l=0.15u mult=1 sa=0.265
+ sb=0.265 sd=0.28 area=0.063 perim=1.14
MI634 clkpos GATE_N VGND VNB sky130_fd_pr__nfet_01v8 m=1 w=0.42u l=0.15u mult=1
+ sa=0.265 sb=0.265 sd=0.28 area=0.063 perim=1.14
MI649 Q m1 VGND VNB sky130_fd_pr__nfet_01v8 m=2 w=0.65u l=0.15u mult=1 sa=0.265
+ sb=0.265 sd=0.28 area=0.063 perim=1.14
MI657 net93 RESET_B VGND VNB sky130_fd_pr__nfet_01v8 m=1 w=0.65u l=0.15u mult=1
+ sa=0.265 sb=0.265 sd=0.28 area=0.063 perim=1.14
MI652 M0 clkneg net101 VNB sky130_fd_pr__nfet_01v8 m=1 w=0.36u l=0.15u mult=1 sa=0.265
+ sb=0.265 sd=0.28 area=0.063 perim=1.14
MI654 net101 m1 VGND VNB sky130_fd_pr__nfet_01v8 m=1 w=0.42u l=0.15u mult=1 sa=0.265
+ sb=0.265 sd=0.28 area=0.063 perim=1.14
MI656 m1 M0 net93 VNB sky130_fd_pr__nfet_01v8 m=1 w=0.65u l=0.15u mult=1 sa=0.265
+ sb=0.265 sd=0.28 area=0.063 perim=1.14
MI636 clkneg clkpos VGND VNB sky130_fd_pr__nfet_01v8 m=1 w=0.42u l=0.15u mult=1
+ sa=0.265 sb=0.265 sd=0.28 area=0.063 perim=1.14
MI637 db D VGND VNB sky130_fd_pr__nfet_01v8 m=1 w=0.42u l=0.15u mult=1 sa=0.265
+ sb=0.265 sd=0.28 area=0.063 perim=1.14
MI19 M0 clkpos net81 VNB sky130_fd_pr__nfet_01v8 m=1 w=0.36u l=0.15u mult=1 sa=0.265
+ sb=0.265 sd=0.28 area=0.063 perim=1.14
MI20 net81 db VGND VNB sky130_fd_pr__nfet_01v8 m=1 w=0.42u l=0.15u mult=1 sa=0.265
+ sb=0.265 sd=0.28 area=0.063 perim=1.14
.ENDS sky130_fd_sc_hd__dlrtn_2
* Copyright 2020 The SkyWater PDK Authors
*
* Licensed under the Apache License, Version 2.0 (the "License");
* you may not use this file except in compliance with the License.
* You may obtain a copy of the License at
*
*     https:  www.apache.org licenses LICENSE-2.0
*
* Unless required by applicable law or agreed to in writing, software
* distributed under the License is distributed on an "AS IS" BASIS,
* WITHOUT WARRANTIES OR CONDITIONS OF ANY KIND, either express or implied.
* See the License for the specific language governing permissions and
* limitations under the License.
*
* SPDX-License-Identifier: Apache-2.0

.SUBCKT sky130_fd_sc_hd__dlrtn_4 D GATE_N RESET_B VGND VNB VNB net59 Q
*.PININFO D:I GATE_N:I RESET_B:I VGND:I VNB:I VNB:I net59:I Q:O
MI635 clkneg clkpos net59 VNB sky130_fd_pr__pfet_01v8_hvt m=1 w=0.64u l=0.15u mult=1
+ sa=0.265 sb=0.265 sd=0.28 area=0.063 perim=1.14
MI17 M0 clkneg net55 VNB sky130_fd_pr__pfet_01v8_hvt m=1 w=0.42u l=0.15u mult=1
+ sa=0.265 sb=0.265 sd=0.28 area=0.063 perim=1.14
MI650 Q m1 net59 VNB sky130_fd_pr__pfet_01v8_hvt m=4 w=1.0u l=0.15u mult=1 sa=0.265
+ sb=0.265 sd=0.28 area=0.063 perim=1.14
MI633 clkpos GATE_N net59 VNB sky130_fd_pr__pfet_01v8_hvt m=1 w=0.64u l=0.15u mult=1
+ sa=0.265 sb=0.265 sd=0.28 area=0.063 perim=1.14
MI658 m1 RESET_B net59 VNB sky130_fd_pr__pfet_01v8_hvt m=1 w=1.0u l=0.15u mult=1
+ sa=0.265 sb=0.265 sd=0.28 area=0.063 perim=1.14
MI18 net55 db net59 VNB sky130_fd_pr__pfet_01v8_hvt m=1 w=0.64u l=0.15u mult=1 sa=0.265
+ sb=0.265 sd=0.28 area=0.063 perim=1.14
MI653 net51 m1 net59 VNB sky130_fd_pr__pfet_01v8_hvt m=1 w=0.42u l=0.15u mult=1
+ sa=0.265 sb=0.265 sd=0.28 area=0.063 perim=1.14
MI651 M0 clkpos net51 VNB sky130_fd_pr__pfet_01v8_hvt m=1 w=0.42u l=0.15u mult=1
+ sa=0.265 sb=0.265 sd=0.28 area=0.063 perim=1.14
MI655 m1 M0 net59 VNB sky130_fd_pr__pfet_01v8_hvt m=1 w=1.0u l=0.15u mult=1 sa=0.265
+ sb=0.265 sd=0.28 area=0.063 perim=1.14
MI638 db D net59 VNB sky130_fd_pr__pfet_01v8_hvt m=1 w=0.64u l=0.15u mult=1 sa=0.265
+ sb=0.265 sd=0.28 area=0.063 perim=1.14
MI634 clkpos GATE_N VGND VNB sky130_fd_pr__nfet_01v8 m=1 w=0.42u l=0.15u mult=1
+ sa=0.265 sb=0.265 sd=0.28 area=0.063 perim=1.14
MI649 Q m1 VGND VNB sky130_fd_pr__nfet_01v8 m=4 w=0.65u l=0.15u mult=1 sa=0.265
+ sb=0.265 sd=0.28 area=0.063 perim=1.14
MI657 net94 RESET_B VGND VNB sky130_fd_pr__nfet_01v8 m=1 w=0.65u l=0.15u mult=1
+ sa=0.265 sb=0.265 sd=0.28 area=0.063 perim=1.14
MI652 M0 clkneg net102 VNB sky130_fd_pr__nfet_01v8 m=1 w=0.36u l=0.15u mult=1 sa=0.265
+ sb=0.265 sd=0.28 area=0.063 perim=1.14
MI654 net102 m1 VGND VNB sky130_fd_pr__nfet_01v8 m=1 w=0.42u l=0.15u mult=1 sa=0.265
+ sb=0.265 sd=0.28 area=0.063 perim=1.14
MI656 m1 M0 net94 VNB sky130_fd_pr__nfet_01v8 m=1 w=0.65u l=0.15u mult=1 sa=0.265
+ sb=0.265 sd=0.28 area=0.063 perim=1.14
MI636 clkneg clkpos VGND VNB sky130_fd_pr__nfet_01v8 m=1 w=0.42u l=0.15u mult=1
+ sa=0.265 sb=0.265 sd=0.28 area=0.063 perim=1.14
MI637 db D VGND VNB sky130_fd_pr__nfet_01v8 m=1 w=0.42u l=0.15u mult=1 sa=0.265
+ sb=0.265 sd=0.28 area=0.063 perim=1.14
MI19 M0 clkpos net82 VNB sky130_fd_pr__nfet_01v8 m=1 w=0.36u l=0.15u mult=1 sa=0.265
+ sb=0.265 sd=0.28 area=0.063 perim=1.14
MI20 net82 db VGND VNB sky130_fd_pr__nfet_01v8 m=1 w=0.42u l=0.15u mult=1 sa=0.265
+ sb=0.265 sd=0.28 area=0.063 perim=1.14
.ENDS sky130_fd_sc_hd__dlrtn_4
* Copyright 2020 The SkyWater PDK Authors
*
* Licensed under the Apache License, Version 2.0 (the "License");
* you may not use this file except in compliance with the License.
* You may obtain a copy of the License at
*
*     https:  www.apache.org licenses LICENSE-2.0
*
* Unless required by applicable law or agreed to in writing, software
* distributed under the License is distributed on an "AS IS" BASIS,
* WITHOUT WARRANTIES OR CONDITIONS OF ANY KIND, either express or implied.
* See the License for the specific language governing permissions and
* limitations under the License.
*
* SPDX-License-Identifier: Apache-2.0

.SUBCKT sky130_fd_sc_hd__dlrtp_1 D GATE RESET_B VGND VNB VNB net59 Q
*.PININFO D:I GATE:I RESET_B:I VGND:I VNB:I VNB:I net59:I Q:O
MI635 clkpos clkneg net59 VNB sky130_fd_pr__pfet_01v8_hvt m=1 w=0.64u l=0.15u mult=1
+ sa=0.265 sb=0.265 sd=0.28 area=0.063 perim=1.14
MI17 M0 clkneg net54 VNB sky130_fd_pr__pfet_01v8_hvt m=1 w=0.36u l=0.15u mult=1
+ sa=0.265 sb=0.265 sd=0.28 area=0.063 perim=1.14
MI650 Q m1 net59 VNB sky130_fd_pr__pfet_01v8_hvt m=1 w=1.0u l=0.15u mult=1 sa=0.265
+ sb=0.265 sd=0.28 area=0.063 perim=1.14
MI633 clkneg GATE net59 VNB sky130_fd_pr__pfet_01v8_hvt m=1 w=0.64u l=0.15u mult=1
+ sa=0.265 sb=0.265 sd=0.28 area=0.063 perim=1.14
MI658 m1 RESET_B net59 VNB sky130_fd_pr__pfet_01v8_hvt m=1 w=1.0u l=0.15u mult=1
+ sa=0.265 sb=0.265 sd=0.28 area=0.063 perim=1.14
MI18 net54 db net59 VNB sky130_fd_pr__pfet_01v8_hvt m=1 w=0.64u l=0.15u mult=1 sa=0.265
+ sb=0.265 sd=0.28 area=0.063 perim=1.14
MI653 net50 m1 net59 VNB sky130_fd_pr__pfet_01v8_hvt m=1 w=0.42u l=0.15u mult=1
+ sa=0.265 sb=0.265 sd=0.28 area=0.063 perim=1.14
MI651 M0 clkpos net50 VNB sky130_fd_pr__pfet_01v8_hvt m=1 w=0.36u l=0.15u mult=1
+ sa=0.265 sb=0.265 sd=0.28 area=0.063 perim=1.14
MI655 m1 M0 net59 VNB sky130_fd_pr__pfet_01v8_hvt m=1 w=1.0u l=0.15u mult=1 sa=0.265
+ sb=0.265 sd=0.28 area=0.063 perim=1.14
MI638 db D net59 VNB sky130_fd_pr__pfet_01v8_hvt m=1 w=0.64u l=0.15u mult=1 sa=0.265
+ sb=0.265 sd=0.28 area=0.063 perim=1.14
MI634 clkneg GATE VGND VNB sky130_fd_pr__nfet_01v8 m=1 w=0.42u l=0.15u mult=1 sa=0.265
+ sb=0.265 sd=0.28 area=0.063 perim=1.14
MI649 Q m1 VGND VNB sky130_fd_pr__nfet_01v8 m=1 w=0.65u l=0.15u mult=1 sa=0.265
+ sb=0.265 sd=0.28 area=0.063 perim=1.14
MI657 net93 RESET_B VGND VNB sky130_fd_pr__nfet_01v8 m=1 w=0.65u l=0.15u mult=1
+ sa=0.265 sb=0.265 sd=0.28 area=0.063 perim=1.14
MI652 M0 clkneg net101 VNB sky130_fd_pr__nfet_01v8 m=1 w=0.42u l=0.15u mult=1 sa=0.265
+ sb=0.265 sd=0.28 area=0.063 perim=1.14
MI654 net101 m1 VGND VNB sky130_fd_pr__nfet_01v8 m=1 w=0.42u l=0.15u mult=1 sa=0.265
+ sb=0.265 sd=0.28 area=0.063 perim=1.14
MI656 m1 M0 net93 VNB sky130_fd_pr__nfet_01v8 m=1 w=0.65u l=0.15u mult=1 sa=0.265
+ sb=0.265 sd=0.28 area=0.063 perim=1.14
MI636 clkpos clkneg VGND VNB sky130_fd_pr__nfet_01v8 m=1 w=0.42u l=0.15u mult=1
+ sa=0.265 sb=0.265 sd=0.28 area=0.063 perim=1.14
MI637 db D VGND VNB sky130_fd_pr__nfet_01v8 m=1 w=0.42u l=0.15u mult=1 sa=0.265
+ sb=0.265 sd=0.28 area=0.063 perim=1.14
MI19 M0 clkpos net81 VNB sky130_fd_pr__nfet_01v8 m=1 w=0.42u l=0.15u mult=1 sa=0.265
+ sb=0.265 sd=0.28 area=0.063 perim=1.14
MI20 net81 db VGND VNB sky130_fd_pr__nfet_01v8 m=1 w=0.42u l=0.15u mult=1 sa=0.265
+ sb=0.265 sd=0.28 area=0.063 perim=1.14
.ENDS sky130_fd_sc_hd__dlrtp_1
* Copyright 2020 The SkyWater PDK Authors
*
* Licensed under the Apache License, Version 2.0 (the "License");
* you may not use this file except in compliance with the License.
* You may obtain a copy of the License at
*
*     https:  www.apache.org licenses LICENSE-2.0
*
* Unless required by applicable law or agreed to in writing, software
* distributed under the License is distributed on an "AS IS" BASIS,
* WITHOUT WARRANTIES OR CONDITIONS OF ANY KIND, either express or implied.
* See the License for the specific language governing permissions and
* limitations under the License.
*
* SPDX-License-Identifier: Apache-2.0

.SUBCKT sky130_fd_sc_hd__dlrtp_2 D GATE RESET_B VGND VNB VNB net59 Q
*.PININFO D:I GATE:I RESET_B:I VGND:I VNB:I VNB:I net59:I Q:O
MI635 clkpos clkneg net59 VNB sky130_fd_pr__pfet_01v8_hvt m=1 w=0.64u l=0.15u mult=1
+ sa=0.265 sb=0.265 sd=0.28 area=0.063 perim=1.14
MI17 M0 clkneg net54 VNB sky130_fd_pr__pfet_01v8_hvt m=1 w=0.42u l=0.15u mult=1
+ sa=0.265 sb=0.265 sd=0.28 area=0.063 perim=1.14
MI650 Q m1 net59 VNB sky130_fd_pr__pfet_01v8_hvt m=2 w=1.0u l=0.15u mult=1 sa=0.265
+ sb=0.265 sd=0.28 area=0.063 perim=1.14
MI633 clkneg GATE net59 VNB sky130_fd_pr__pfet_01v8_hvt m=1 w=0.64u l=0.15u mult=1
+ sa=0.265 sb=0.265 sd=0.28 area=0.063 perim=1.14
MI658 m1 RESET_B net59 VNB sky130_fd_pr__pfet_01v8_hvt m=1 w=1.0u l=0.15u mult=1
+ sa=0.265 sb=0.265 sd=0.28 area=0.063 perim=1.14
MI18 net54 db net59 VNB sky130_fd_pr__pfet_01v8_hvt m=1 w=0.64u l=0.15u mult=1 sa=0.265
+ sb=0.265 sd=0.28 area=0.063 perim=1.14
MI653 net50 m1 net59 VNB sky130_fd_pr__pfet_01v8_hvt m=1 w=0.42u l=0.15u mult=1
+ sa=0.265 sb=0.265 sd=0.28 area=0.063 perim=1.14
MI651 M0 clkpos net50 VNB sky130_fd_pr__pfet_01v8_hvt m=1 w=0.42u l=0.15u mult=1
+ sa=0.265 sb=0.265 sd=0.28 area=0.063 perim=1.14
MI655 m1 M0 net59 VNB sky130_fd_pr__pfet_01v8_hvt m=1 w=1.0u l=0.15u mult=1 sa=0.265
+ sb=0.265 sd=0.28 area=0.063 perim=1.14
MI638 db D net59 VNB sky130_fd_pr__pfet_01v8_hvt m=1 w=0.64u l=0.15u mult=1 sa=0.265
+ sb=0.265 sd=0.28 area=0.063 perim=1.14
MI634 clkneg GATE VGND VNB sky130_fd_pr__nfet_01v8 m=1 w=0.42u l=0.15u mult=1 sa=0.265
+ sb=0.265 sd=0.28 area=0.063 perim=1.14
MI649 Q m1 VGND VNB sky130_fd_pr__nfet_01v8 m=2 w=0.65u l=0.15u mult=1 sa=0.265
+ sb=0.265 sd=0.28 area=0.063 perim=1.14
MI657 net93 RESET_B VGND VNB sky130_fd_pr__nfet_01v8 m=1 w=0.65u l=0.15u mult=1
+ sa=0.265 sb=0.265 sd=0.28 area=0.063 perim=1.14
MI652 M0 clkneg net101 VNB sky130_fd_pr__nfet_01v8 m=1 w=0.36u l=0.15u mult=1 sa=0.265
+ sb=0.265 sd=0.28 area=0.063 perim=1.14
MI654 net101 m1 VGND VNB sky130_fd_pr__nfet_01v8 m=1 w=0.42u l=0.15u mult=1 sa=0.265
+ sb=0.265 sd=0.28 area=0.063 perim=1.14
MI656 m1 M0 net93 VNB sky130_fd_pr__nfet_01v8 m=1 w=0.65u l=0.15u mult=1 sa=0.265
+ sb=0.265 sd=0.28 area=0.063 perim=1.14
MI636 clkpos clkneg VGND VNB sky130_fd_pr__nfet_01v8 m=1 w=0.42u l=0.15u mult=1
+ sa=0.265 sb=0.265 sd=0.28 area=0.063 perim=1.14
MI637 db D VGND VNB sky130_fd_pr__nfet_01v8 m=1 w=0.42u l=0.15u mult=1 sa=0.265
+ sb=0.265 sd=0.28 area=0.063 perim=1.14
MI19 M0 clkpos net81 VNB sky130_fd_pr__nfet_01v8 m=1 w=0.36u l=0.15u mult=1 sa=0.265
+ sb=0.265 sd=0.28 area=0.063 perim=1.14
MI20 net81 db VGND VNB sky130_fd_pr__nfet_01v8 m=1 w=0.42u l=0.15u mult=1 sa=0.265
+ sb=0.265 sd=0.28 area=0.063 perim=1.14
.ENDS sky130_fd_sc_hd__dlrtp_2
* Copyright 2020 The SkyWater PDK Authors
*
* Licensed under the Apache License, Version 2.0 (the "License");
* you may not use this file except in compliance with the License.
* You may obtain a copy of the License at
*
*     https:  www.apache.org licenses LICENSE-2.0
*
* Unless required by applicable law or agreed to in writing, software
* distributed under the License is distributed on an "AS IS" BASIS,
* WITHOUT WARRANTIES OR CONDITIONS OF ANY KIND, either express or implied.
* See the License for the specific language governing permissions and
* limitations under the License.
*
* SPDX-License-Identifier: Apache-2.0

.SUBCKT sky130_fd_sc_hd__dlrtp_4 D GATE RESET_B VGND VNB VNB net59 Q
*.PININFO D:I GATE:I RESET_B:I VGND:I VNB:I VNB:I net59:I Q:O
MI635 clkpos clkneg net59 VNB sky130_fd_pr__pfet_01v8_hvt m=1 w=0.64u l=0.15u mult=1
+ sa=0.265 sb=0.265 sd=0.28 area=0.063 perim=1.14
MI17 M0 clkneg net55 VNB sky130_fd_pr__pfet_01v8_hvt m=1 w=0.42u l=0.15u mult=1
+ sa=0.265 sb=0.265 sd=0.28 area=0.063 perim=1.14
MI650 Q m1 net59 VNB sky130_fd_pr__pfet_01v8_hvt m=4 w=1.0u l=0.15u mult=1 sa=0.265
+ sb=0.265 sd=0.28 area=0.063 perim=1.14
MI633 clkneg GATE net59 VNB sky130_fd_pr__pfet_01v8_hvt m=1 w=0.64u l=0.15u mult=1
+ sa=0.265 sb=0.265 sd=0.28 area=0.063 perim=1.14
MI658 m1 RESET_B net59 VNB sky130_fd_pr__pfet_01v8_hvt m=1 w=1.0u l=0.15u mult=1
+ sa=0.265 sb=0.265 sd=0.28 area=0.063 perim=1.14
MI18 net55 db net59 VNB sky130_fd_pr__pfet_01v8_hvt m=1 w=0.64u l=0.15u mult=1 sa=0.265
+ sb=0.265 sd=0.28 area=0.063 perim=1.14
MI653 net51 m1 net59 VNB sky130_fd_pr__pfet_01v8_hvt m=1 w=0.42u l=0.15u mult=1
+ sa=0.265 sb=0.265 sd=0.28 area=0.063 perim=1.14
MI651 M0 clkpos net51 VNB sky130_fd_pr__pfet_01v8_hvt m=1 w=0.42u l=0.15u mult=1
+ sa=0.265 sb=0.265 sd=0.28 area=0.063 perim=1.14
MI655 m1 M0 net59 VNB sky130_fd_pr__pfet_01v8_hvt m=1 w=1.0u l=0.15u mult=1 sa=0.265
+ sb=0.265 sd=0.28 area=0.063 perim=1.14
MI638 db D net59 VNB sky130_fd_pr__pfet_01v8_hvt m=1 w=0.64u l=0.15u mult=1 sa=0.265
+ sb=0.265 sd=0.28 area=0.063 perim=1.14
MI634 clkneg GATE VGND VNB sky130_fd_pr__nfet_01v8 m=1 w=0.42u l=0.15u mult=1 sa=0.265
+ sb=0.265 sd=0.28 area=0.063 perim=1.14
MI649 Q m1 VGND VNB sky130_fd_pr__nfet_01v8 m=4 w=0.65u l=0.15u mult=1 sa=0.265
+ sb=0.265 sd=0.28 area=0.063 perim=1.14
MI657 net94 RESET_B VGND VNB sky130_fd_pr__nfet_01v8 m=1 w=0.65u l=0.15u mult=1
+ sa=0.265 sb=0.265 sd=0.28 area=0.063 perim=1.14
MI652 M0 clkneg net102 VNB sky130_fd_pr__nfet_01v8 m=1 w=0.36u l=0.15u mult=1 sa=0.265
+ sb=0.265 sd=0.28 area=0.063 perim=1.14
MI654 net102 m1 VGND VNB sky130_fd_pr__nfet_01v8 m=1 w=0.42u l=0.15u mult=1 sa=0.265
+ sb=0.265 sd=0.28 area=0.063 perim=1.14
MI656 m1 M0 net94 VNB sky130_fd_pr__nfet_01v8 m=1 w=0.65u l=0.15u mult=1 sa=0.265
+ sb=0.265 sd=0.28 area=0.063 perim=1.14
MI636 clkpos clkneg VGND VNB sky130_fd_pr__nfet_01v8 m=1 w=0.42u l=0.15u mult=1
+ sa=0.265 sb=0.265 sd=0.28 area=0.063 perim=1.14
MI637 db D VGND VNB sky130_fd_pr__nfet_01v8 m=1 w=0.42u l=0.15u mult=1 sa=0.265
+ sb=0.265 sd=0.28 area=0.063 perim=1.14
MI19 M0 clkpos net82 VNB sky130_fd_pr__nfet_01v8 m=1 w=0.36u l=0.15u mult=1 sa=0.265
+ sb=0.265 sd=0.28 area=0.063 perim=1.14
MI20 net82 db VGND VNB sky130_fd_pr__nfet_01v8 m=1 w=0.42u l=0.15u mult=1 sa=0.265
+ sb=0.265 sd=0.28 area=0.063 perim=1.14
.ENDS sky130_fd_sc_hd__dlrtp_4
* Copyright 2020 The SkyWater PDK Authors
*
* Licensed under the Apache License, Version 2.0 (the "License");
* you may not use this file except in compliance with the License.
* You may obtain a copy of the License at
*
*     https:  www.apache.org licenses LICENSE-2.0
*
* Unless required by applicable law or agreed to in writing, software
* distributed under the License is distributed on an "AS IS" BASIS,
* WITHOUT WARRANTIES OR CONDITIONS OF ANY KIND, either express or implied.
* See the License for the specific language governing permissions and
* limitations under the License.
*
* SPDX-License-Identifier: Apache-2.0

.SUBCKT sky130_fd_sc_hd__dlxbn_1 D GATE_N VGND VNB VNB net59 Q Q_N
*.PININFO D:I GATE_N:I VGND:I VNB:I VNB:I net59:I Q:O Q_N:O
MI635 clkneg clkpos net59 VNB sky130_fd_pr__pfet_01v8_hvt m=1 w=0.64u l=0.15u mult=1
+ sa=0.265 sb=0.265 sd=0.28 area=0.063 perim=1.14
MI648 Q_N net112 net59 VNB sky130_fd_pr__pfet_01v8_hvt m=1 w=1.0u l=0.15u mult=1
+ sa=0.265 sb=0.265 sd=0.28 area=0.063 perim=1.14
MI17 M0 clkneg net56 VNB sky130_fd_pr__pfet_01v8_hvt m=1 w=0.42u l=0.15u mult=1
+ sa=0.265 sb=0.265 sd=0.28 area=0.063 perim=1.14
MI646 net112 m1 net59 VNB sky130_fd_pr__pfet_01v8_hvt m=1 w=0.64u l=0.15u mult=1
+ sa=0.265 sb=0.265 sd=0.28 area=0.063 perim=1.14
MI650 Q m1 net59 VNB sky130_fd_pr__pfet_01v8_hvt m=1 w=1.0u l=0.15u mult=1 sa=0.265
+ sb=0.265 sd=0.28 area=0.063 perim=1.14
MI633 clkpos GATE_N net59 VNB sky130_fd_pr__pfet_01v8_hvt m=1 w=0.64u l=0.15u mult=1
+ sa=0.265 sb=0.265 sd=0.28 area=0.063 perim=1.14
MI18 net56 db net59 VNB sky130_fd_pr__pfet_01v8_hvt m=1 w=0.64u l=0.15u mult=1 sa=0.265
+ sb=0.265 sd=0.28 area=0.063 perim=1.14
MI653 net52 m1 net59 VNB sky130_fd_pr__pfet_01v8_hvt m=1 w=0.42u l=0.15u mult=1
+ sa=0.265 sb=0.265 sd=0.28 area=0.063 perim=1.14
MI651 M0 clkpos net52 VNB sky130_fd_pr__pfet_01v8_hvt m=1 w=0.42u l=0.15u mult=1
+ sa=0.265 sb=0.265 sd=0.28 area=0.063 perim=1.14
MI655 m1 M0 net59 VNB sky130_fd_pr__pfet_01v8_hvt m=1 w=1.0u l=0.15u mult=1 sa=0.265
+ sb=0.265 sd=0.28 area=0.063 perim=1.14
MI638 db D net59 VNB sky130_fd_pr__pfet_01v8_hvt m=1 w=0.64u l=0.15u mult=1 sa=0.265
+ sb=0.265 sd=0.28 area=0.063 perim=1.14
MI634 clkpos GATE_N VGND VNB sky130_fd_pr__nfet_01v8 m=1 w=0.42u l=0.15u mult=1
+ sa=0.265 sb=0.265 sd=0.28 area=0.063 perim=1.14
MI647 Q_N net112 VGND VNB sky130_fd_pr__nfet_01v8 m=1 w=0.65u l=0.15u mult=1 sa=0.265
+ sb=0.265 sd=0.28 area=0.063 perim=1.14
MI649 Q m1 VGND VNB sky130_fd_pr__nfet_01v8 m=1 w=0.65u l=0.15u mult=1 sa=0.265
+ sb=0.265 sd=0.28 area=0.063 perim=1.14
MI645 net112 m1 VGND VNB sky130_fd_pr__nfet_01v8 m=1 w=0.42u l=0.15u mult=1 sa=0.265
+ sb=0.265 sd=0.28 area=0.063 perim=1.14
MI652 M0 clkneg net107 VNB sky130_fd_pr__nfet_01v8 m=1 w=0.36u l=0.15u mult=1 sa=0.265
+ sb=0.265 sd=0.28 area=0.063 perim=1.14
MI654 net107 m1 VGND VNB sky130_fd_pr__nfet_01v8 m=1 w=0.42u l=0.15u mult=1 sa=0.265
+ sb=0.265 sd=0.28 area=0.063 perim=1.14
MI656 m1 M0 VGND VNB sky130_fd_pr__nfet_01v8 m=1 w=0.65u l=0.15u mult=1 sa=0.265
+ sb=0.265 sd=0.28 area=0.063 perim=1.14
MI636 clkneg clkpos VGND VNB sky130_fd_pr__nfet_01v8 m=1 w=0.42u l=0.15u mult=1
+ sa=0.265 sb=0.265 sd=0.28 area=0.063 perim=1.14
MI637 db D VGND VNB sky130_fd_pr__nfet_01v8 m=1 w=0.42u l=0.15u mult=1 sa=0.265
+ sb=0.265 sd=0.28 area=0.063 perim=1.14
MI19 M0 clkpos net87 VNB sky130_fd_pr__nfet_01v8 m=1 w=0.36u l=0.15u mult=1 sa=0.265
+ sb=0.265 sd=0.28 area=0.063 perim=1.14
MI20 net87 db VGND VNB sky130_fd_pr__nfet_01v8 m=1 w=0.42u l=0.15u mult=1 sa=0.265
+ sb=0.265 sd=0.28 area=0.063 perim=1.14
.ENDS sky130_fd_sc_hd__dlxbn_1
* Copyright 2020 The SkyWater PDK Authors
*
* Licensed under the Apache License, Version 2.0 (the "License");
* you may not use this file except in compliance with the License.
* You may obtain a copy of the License at
*
*     https:  www.apache.org licenses LICENSE-2.0
*
* Unless required by applicable law or agreed to in writing, software
* distributed under the License is distributed on an "AS IS" BASIS,
* WITHOUT WARRANTIES OR CONDITIONS OF ANY KIND, either express or implied.
* See the License for the specific language governing permissions and
* limitations under the License.
*
* SPDX-License-Identifier: Apache-2.0

.SUBCKT sky130_fd_sc_hd__dlxbn_2 D GATE_N VGND VNB VNB net59 Q Q_N
*.PININFO D:I GATE_N:I VGND:I VNB:I VNB:I net59:I Q:O Q_N:O
MI635 clkneg clkpos net59 VNB sky130_fd_pr__pfet_01v8_hvt m=1 w=0.64u l=0.15u mult=1
+ sa=0.265 sb=0.265 sd=0.28 area=0.063 perim=1.14
MI648 Q_N net114 net59 VNB sky130_fd_pr__pfet_01v8_hvt m=2 w=1.0u l=0.15u mult=1
+ sa=0.265 sb=0.265 sd=0.28 area=0.063 perim=1.14
MI17 M0 clkneg net58 VNB sky130_fd_pr__pfet_01v8_hvt m=1 w=0.42u l=0.15u mult=1
+ sa=0.265 sb=0.265 sd=0.28 area=0.063 perim=1.14
MI646 net114 m1 net59 VNB sky130_fd_pr__pfet_01v8_hvt m=1 w=0.64u l=0.15u mult=1
+ sa=0.265 sb=0.265 sd=0.28 area=0.063 perim=1.14
MI650 Q m1 net59 VNB sky130_fd_pr__pfet_01v8_hvt m=2 w=1.0u l=0.15u mult=1 sa=0.265
+ sb=0.265 sd=0.28 area=0.063 perim=1.14
MI633 clkpos GATE_N net59 VNB sky130_fd_pr__pfet_01v8_hvt m=1 w=0.64u l=0.15u mult=1
+ sa=0.265 sb=0.265 sd=0.28 area=0.063 perim=1.14
MI18 net58 db net59 VNB sky130_fd_pr__pfet_01v8_hvt m=1 w=0.64u l=0.15u mult=1 sa=0.265
+ sb=0.265 sd=0.28 area=0.063 perim=1.14
MI653 net54 m1 net59 VNB sky130_fd_pr__pfet_01v8_hvt m=1 w=0.42u l=0.15u mult=1
+ sa=0.265 sb=0.265 sd=0.28 area=0.063 perim=1.14
MI651 M0 clkpos net54 VNB sky130_fd_pr__pfet_01v8_hvt m=1 w=0.42u l=0.15u mult=1
+ sa=0.265 sb=0.265 sd=0.28 area=0.063 perim=1.14
MI655 m1 M0 net59 VNB sky130_fd_pr__pfet_01v8_hvt m=1 w=1.0u l=0.15u mult=1 sa=0.265
+ sb=0.265 sd=0.28 area=0.063 perim=1.14
MI638 db D net59 VNB sky130_fd_pr__pfet_01v8_hvt m=1 w=0.64u l=0.15u mult=1 sa=0.265
+ sb=0.265 sd=0.28 area=0.063 perim=1.14
MI634 clkpos GATE_N VGND VNB sky130_fd_pr__nfet_01v8 m=1 w=0.42u l=0.15u mult=1
+ sa=0.265 sb=0.265 sd=0.28 area=0.063 perim=1.14
MI647 Q_N net114 VGND VNB sky130_fd_pr__nfet_01v8 m=2 w=0.65u l=0.15u mult=1 sa=0.265
+ sb=0.265 sd=0.28 area=0.063 perim=1.14
MI649 Q m1 VGND VNB sky130_fd_pr__nfet_01v8 m=2 w=0.65u l=0.15u mult=1 sa=0.265
+ sb=0.265 sd=0.28 area=0.063 perim=1.14
MI645 net114 m1 VGND VNB sky130_fd_pr__nfet_01v8 m=1 w=0.42u l=0.15u mult=1 sa=0.265
+ sb=0.265 sd=0.28 area=0.063 perim=1.14
MI652 M0 clkneg net109 VNB sky130_fd_pr__nfet_01v8 m=1 w=0.36u l=0.15u mult=1 sa=0.265
+ sb=0.265 sd=0.28 area=0.063 perim=1.14
MI654 net109 m1 VGND VNB sky130_fd_pr__nfet_01v8 m=1 w=0.42u l=0.15u mult=1 sa=0.265
+ sb=0.265 sd=0.28 area=0.063 perim=1.14
MI656 m1 M0 VGND VNB sky130_fd_pr__nfet_01v8 m=1 w=0.65u l=0.15u mult=1 sa=0.265
+ sb=0.265 sd=0.28 area=0.063 perim=1.14
MI636 clkneg clkpos VGND VNB sky130_fd_pr__nfet_01v8 m=1 w=0.42u l=0.15u mult=1
+ sa=0.265 sb=0.265 sd=0.28 area=0.063 perim=1.14
MI637 db D VGND VNB sky130_fd_pr__nfet_01v8 m=1 w=0.42u l=0.15u mult=1 sa=0.265
+ sb=0.265 sd=0.28 area=0.063 perim=1.14
MI19 M0 clkpos net89 VNB sky130_fd_pr__nfet_01v8 m=1 w=0.36u l=0.15u mult=1 sa=0.265
+ sb=0.265 sd=0.28 area=0.063 perim=1.14
MI20 net89 db VGND VNB sky130_fd_pr__nfet_01v8 m=1 w=0.42u l=0.15u mult=1 sa=0.265
+ sb=0.265 sd=0.28 area=0.063 perim=1.14
.ENDS sky130_fd_sc_hd__dlxbn_2
* Copyright 2020 The SkyWater PDK Authors
*
* Licensed under the Apache License, Version 2.0 (the "License");
* you may not use this file except in compliance with the License.
* You may obtain a copy of the License at
*
*     https:  www.apache.org licenses LICENSE-2.0
*
* Unless required by applicable law or agreed to in writing, software
* distributed under the License is distributed on an "AS IS" BASIS,
* WITHOUT WARRANTIES OR CONDITIONS OF ANY KIND, either express or implied.
* See the License for the specific language governing permissions and
* limitations under the License.
*
* SPDX-License-Identifier: Apache-2.0

.SUBCKT sky130_fd_sc_hd__dlxbp_1 D GATE VGND VNB VNB net59 Q Q_N
*.PININFO D:I GATE:I VGND:I VNB:I VNB:I net59:I Q:O Q_N:O
MI635 clkpos clkneg net59 VNB sky130_fd_pr__pfet_01v8_hvt m=1 w=0.64u l=0.15u mult=1
+ sa=0.265 sb=0.265 sd=0.28 area=0.063 perim=1.14
MI648 Q_N net114 net59 VNB sky130_fd_pr__pfet_01v8_hvt m=1 w=1.0u l=0.15u mult=1
+ sa=0.265 sb=0.265 sd=0.28 area=0.063 perim=1.14
MI17 M0 clkneg net58 VNB sky130_fd_pr__pfet_01v8_hvt m=1 w=0.42u l=0.15u mult=1
+ sa=0.265 sb=0.265 sd=0.28 area=0.063 perim=1.14
MI646 net114 m1 net59 VNB sky130_fd_pr__pfet_01v8_hvt m=1 w=0.64u l=0.15u mult=1
+ sa=0.265 sb=0.265 sd=0.28 area=0.063 perim=1.14
MI650 Q m1 net59 VNB sky130_fd_pr__pfet_01v8_hvt m=1 w=1.0u l=0.15u mult=1 sa=0.265
+ sb=0.265 sd=0.28 area=0.063 perim=1.14
MI633 clkneg GATE net59 VNB sky130_fd_pr__pfet_01v8_hvt m=1 w=0.64u l=0.15u mult=1
+ sa=0.265 sb=0.265 sd=0.28 area=0.063 perim=1.14
MI18 net58 db net59 VNB sky130_fd_pr__pfet_01v8_hvt m=1 w=0.64u l=0.15u mult=1 sa=0.265
+ sb=0.265 sd=0.28 area=0.063 perim=1.14
MI653 net54 m1 net59 VNB sky130_fd_pr__pfet_01v8_hvt m=1 w=0.42u l=0.15u mult=1
+ sa=0.265 sb=0.265 sd=0.28 area=0.063 perim=1.14
MI651 M0 clkpos net54 VNB sky130_fd_pr__pfet_01v8_hvt m=1 w=0.42u l=0.15u mult=1
+ sa=0.265 sb=0.265 sd=0.28 area=0.063 perim=1.14
MI655 m1 M0 net59 VNB sky130_fd_pr__pfet_01v8_hvt m=1 w=1.0u l=0.15u mult=1 sa=0.265
+ sb=0.265 sd=0.28 area=0.063 perim=1.14
MI638 db D net59 VNB sky130_fd_pr__pfet_01v8_hvt m=1 w=0.64u l=0.15u mult=1 sa=0.265
+ sb=0.265 sd=0.28 area=0.063 perim=1.14
MI634 clkneg GATE VGND VNB sky130_fd_pr__nfet_01v8 m=1 w=0.42u l=0.15u mult=1 sa=0.265
+ sb=0.265 sd=0.28 area=0.063 perim=1.14
MI647 Q_N net114 VGND VNB sky130_fd_pr__nfet_01v8 m=1 w=0.65u l=0.15u mult=1 sa=0.265
+ sb=0.265 sd=0.28 area=0.063 perim=1.14
MI649 Q m1 VGND VNB sky130_fd_pr__nfet_01v8 m=1 w=0.65u l=0.15u mult=1 sa=0.265
+ sb=0.265 sd=0.28 area=0.063 perim=1.14
MI645 net114 m1 VGND VNB sky130_fd_pr__nfet_01v8 m=1 w=0.42u l=0.15u mult=1 sa=0.265
+ sb=0.265 sd=0.28 area=0.063 perim=1.14
MI652 M0 clkneg net109 VNB sky130_fd_pr__nfet_01v8 m=1 w=0.36u l=0.15u mult=1 sa=0.265
+ sb=0.265 sd=0.28 area=0.063 perim=1.14
MI654 net109 m1 VGND VNB sky130_fd_pr__nfet_01v8 m=1 w=0.42u l=0.15u mult=1 sa=0.265
+ sb=0.265 sd=0.28 area=0.063 perim=1.14
MI656 m1 M0 VGND VNB sky130_fd_pr__nfet_01v8 m=1 w=0.65u l=0.15u mult=1 sa=0.265
+ sb=0.265 sd=0.28 area=0.063 perim=1.14
MI636 clkpos clkneg VGND VNB sky130_fd_pr__nfet_01v8 m=1 w=0.42u l=0.15u mult=1
+ sa=0.265 sb=0.265 sd=0.28 area=0.063 perim=1.14
MI637 db D VGND VNB sky130_fd_pr__nfet_01v8 m=1 w=0.42u l=0.15u mult=1 sa=0.265
+ sb=0.265 sd=0.28 area=0.063 perim=1.14
MI19 M0 clkpos net89 VNB sky130_fd_pr__nfet_01v8 m=1 w=0.36u l=0.15u mult=1 sa=0.265
+ sb=0.265 sd=0.28 area=0.063 perim=1.14
MI20 net89 db VGND VNB sky130_fd_pr__nfet_01v8 m=1 w=0.42u l=0.15u mult=1 sa=0.265
+ sb=0.265 sd=0.28 area=0.063 perim=1.14
.ENDS sky130_fd_sc_hd__dlxbp_1
* Copyright 2020 The SkyWater PDK Authors
*
* Licensed under the Apache License, Version 2.0 (the "License");
* you may not use this file except in compliance with the License.
* You may obtain a copy of the License at
*
*     https:  www.apache.org licenses LICENSE-2.0
*
* Unless required by applicable law or agreed to in writing, software
* distributed under the License is distributed on an "AS IS" BASIS,
* WITHOUT WARRANTIES OR CONDITIONS OF ANY KIND, either express or implied.
* See the License for the specific language governing permissions and
* limitations under the License.
*
* SPDX-License-Identifier: Apache-2.0

.SUBCKT sky130_fd_sc_hd__dlxtn_1 D GATE_N VGND VNB VNB net59 Q
*.PININFO D:I GATE_N:I VGND:I VNB:I VNB:I net59:I Q:O
MI635 clkneg clkpos net59 VNB sky130_fd_pr__pfet_01v8_hvt m=1 w=0.64u l=0.15u mult=1
+ sa=0.265 sb=0.265 sd=0.28 area=0.063 perim=1.14
MI17 M0 clkneg net53 VNB sky130_fd_pr__pfet_01v8_hvt m=1 w=0.42u l=0.15u mult=1
+ sa=0.265 sb=0.265 sd=0.28 area=0.063 perim=1.14
MI650 Q m1 net59 VNB sky130_fd_pr__pfet_01v8_hvt m=1 w=1.0u l=0.15u mult=1 sa=0.265
+ sb=0.265 sd=0.28 area=0.063 perim=1.14
MI633 clkpos GATE_N net59 VNB sky130_fd_pr__pfet_01v8_hvt m=1 w=0.64u l=0.15u mult=1
+ sa=0.265 sb=0.265 sd=0.28 area=0.063 perim=1.14
MI18 net53 db net59 VNB sky130_fd_pr__pfet_01v8_hvt m=1 w=0.64u l=0.15u mult=1 sa=0.265
+ sb=0.265 sd=0.28 area=0.063 perim=1.14
MI653 net44 m1 net59 VNB sky130_fd_pr__pfet_01v8_hvt m=1 w=0.42u l=0.15u mult=1
+ sa=0.265 sb=0.265 sd=0.28 area=0.063 perim=1.14
MI651 M0 clkpos net44 VNB sky130_fd_pr__pfet_01v8_hvt m=1 w=0.42u l=0.15u mult=1
+ sa=0.265 sb=0.265 sd=0.28 area=0.063 perim=1.14
MI655 m1 M0 net59 VNB sky130_fd_pr__pfet_01v8_hvt m=1 w=1.0u l=0.15u mult=1 sa=0.265
+ sb=0.265 sd=0.28 area=0.063 perim=1.14
MI638 db D net59 VNB sky130_fd_pr__pfet_01v8_hvt m=1 w=0.64u l=0.15u mult=1 sa=0.265
+ sb=0.265 sd=0.28 area=0.063 perim=1.14
MI634 clkpos GATE_N VGND VNB sky130_fd_pr__nfet_01v8 m=1 w=0.42u l=0.15u mult=1
+ sa=0.265 sb=0.265 sd=0.28 area=0.063 perim=1.14
MI649 Q m1 VGND VNB sky130_fd_pr__nfet_01v8 m=1 w=0.65u l=0.15u mult=1 sa=0.265
+ sb=0.265 sd=0.28 area=0.063 perim=1.14
MI652 M0 clkneg net96 VNB sky130_fd_pr__nfet_01v8 m=1 w=0.36u l=0.15u mult=1 sa=0.265
+ sb=0.265 sd=0.28 area=0.063 perim=1.14
MI654 net96 m1 VGND VNB sky130_fd_pr__nfet_01v8 m=1 w=0.42u l=0.15u mult=1 sa=0.265
+ sb=0.265 sd=0.28 area=0.063 perim=1.14
MI656 m1 M0 VGND VNB sky130_fd_pr__nfet_01v8 m=1 w=0.65u l=0.15u mult=1 sa=0.265
+ sb=0.265 sd=0.28 area=0.063 perim=1.14
MI636 clkneg clkpos VGND VNB sky130_fd_pr__nfet_01v8 m=1 w=0.42u l=0.15u mult=1
+ sa=0.265 sb=0.265 sd=0.28 area=0.063 perim=1.14
MI637 db D VGND VNB sky130_fd_pr__nfet_01v8 m=1 w=0.42u l=0.15u mult=1 sa=0.265
+ sb=0.265 sd=0.28 area=0.063 perim=1.14
MI19 M0 clkpos net76 VNB sky130_fd_pr__nfet_01v8 m=1 w=0.36u l=0.15u mult=1 sa=0.265
+ sb=0.265 sd=0.28 area=0.063 perim=1.14
MI20 net76 db VGND VNB sky130_fd_pr__nfet_01v8 m=1 w=0.42u l=0.15u mult=1 sa=0.265
+ sb=0.265 sd=0.28 area=0.063 perim=1.14
.ENDS sky130_fd_sc_hd__dlxtn_1
* Copyright 2020 The SkyWater PDK Authors
*
* Licensed under the Apache License, Version 2.0 (the "License");
* you may not use this file except in compliance with the License.
* You may obtain a copy of the License at
*
*     https:  www.apache.org licenses LICENSE-2.0
*
* Unless required by applicable law or agreed to in writing, software
* distributed under the License is distributed on an "AS IS" BASIS,
* WITHOUT WARRANTIES OR CONDITIONS OF ANY KIND, either express or implied.
* See the License for the specific language governing permissions and
* limitations under the License.
*
* SPDX-License-Identifier: Apache-2.0

.SUBCKT sky130_fd_sc_hd__dlxtn_2 D GATE_N VGND VNB VNB net59 Q
*.PININFO D:I GATE_N:I VGND:I VNB:I VNB:I net59:I Q:O
MI635 clkneg clkpos net59 VNB sky130_fd_pr__pfet_01v8_hvt m=1 w=0.64u l=0.15u mult=1
+ sa=0.265 sb=0.265 sd=0.28 area=0.063 perim=1.14
MI17 M0 clkneg net51 VNB sky130_fd_pr__pfet_01v8_hvt m=1 w=0.42u l=0.15u mult=1
+ sa=0.265 sb=0.265 sd=0.28 area=0.063 perim=1.14
MI650 Q m1 net59 VNB sky130_fd_pr__pfet_01v8_hvt m=2 w=1.0u l=0.15u mult=1 sa=0.265
+ sb=0.265 sd=0.28 area=0.063 perim=1.14
MI633 clkpos GATE_N net59 VNB sky130_fd_pr__pfet_01v8_hvt m=1 w=0.64u l=0.15u mult=1
+ sa=0.265 sb=0.265 sd=0.28 area=0.063 perim=1.14
MI18 net51 db net59 VNB sky130_fd_pr__pfet_01v8_hvt m=1 w=0.64u l=0.15u mult=1 sa=0.265
+ sb=0.265 sd=0.28 area=0.063 perim=1.14
MI653 net47 m1 net59 VNB sky130_fd_pr__pfet_01v8_hvt m=1 w=0.42u l=0.15u mult=1
+ sa=0.265 sb=0.265 sd=0.28 area=0.063 perim=1.14
MI651 M0 clkpos net47 VNB sky130_fd_pr__pfet_01v8_hvt m=1 w=0.42u l=0.15u mult=1
+ sa=0.265 sb=0.265 sd=0.28 area=0.063 perim=1.14
MI655 m1 M0 net59 VNB sky130_fd_pr__pfet_01v8_hvt m=1 w=1.0u l=0.15u mult=1 sa=0.265
+ sb=0.265 sd=0.28 area=0.063 perim=1.14
MI638 db D net59 VNB sky130_fd_pr__pfet_01v8_hvt m=1 w=0.64u l=0.15u mult=1 sa=0.265
+ sb=0.265 sd=0.28 area=0.063 perim=1.14
MI634 clkpos GATE_N VGND VNB sky130_fd_pr__nfet_01v8 m=1 w=0.42u l=0.15u mult=1
+ sa=0.265 sb=0.265 sd=0.28 area=0.063 perim=1.14
MI649 Q m1 VGND VNB sky130_fd_pr__nfet_01v8 m=2 w=0.65u l=0.15u mult=1 sa=0.265
+ sb=0.265 sd=0.28 area=0.063 perim=1.14
MI652 M0 clkneg net94 VNB sky130_fd_pr__nfet_01v8 m=1 w=0.36u l=0.15u mult=1 sa=0.265
+ sb=0.265 sd=0.28 area=0.063 perim=1.14
MI654 net94 m1 VGND VNB sky130_fd_pr__nfet_01v8 m=1 w=0.42u l=0.15u mult=1 sa=0.265
+ sb=0.265 sd=0.28 area=0.063 perim=1.14
MI656 m1 M0 VGND VNB sky130_fd_pr__nfet_01v8 m=1 w=0.65u l=0.15u mult=1 sa=0.265
+ sb=0.265 sd=0.28 area=0.063 perim=1.14
MI636 clkneg clkpos VGND VNB sky130_fd_pr__nfet_01v8 m=1 w=0.42u l=0.15u mult=1
+ sa=0.265 sb=0.265 sd=0.28 area=0.063 perim=1.14
MI637 db D VGND VNB sky130_fd_pr__nfet_01v8 m=1 w=0.42u l=0.15u mult=1 sa=0.265
+ sb=0.265 sd=0.28 area=0.063 perim=1.14
MI19 M0 clkpos net74 VNB sky130_fd_pr__nfet_01v8 m=1 w=0.36u l=0.15u mult=1 sa=0.265
+ sb=0.265 sd=0.28 area=0.063 perim=1.14
MI20 net74 db VGND VNB sky130_fd_pr__nfet_01v8 m=1 w=0.42u l=0.15u mult=1 sa=0.265
+ sb=0.265 sd=0.28 area=0.063 perim=1.14
.ENDS sky130_fd_sc_hd__dlxtn_2
* Copyright 2020 The SkyWater PDK Authors
*
* Licensed under the Apache License, Version 2.0 (the "License");
* you may not use this file except in compliance with the License.
* You may obtain a copy of the License at
*
*     https:  www.apache.org licenses LICENSE-2.0
*
* Unless required by applicable law or agreed to in writing, software
* distributed under the License is distributed on an "AS IS" BASIS,
* WITHOUT WARRANTIES OR CONDITIONS OF ANY KIND, either express or implied.
* See the License for the specific language governing permissions and
* limitations under the License.
*
* SPDX-License-Identifier: Apache-2.0

.SUBCKT sky130_fd_sc_hd__dlxtn_4 D GATE_N VGND VNB VNB net59 Q
*.PININFO D:I GATE_N:I VGND:I VNB:I VNB:I net59:I Q:O
MI635 clkneg clkpos net59 VNB sky130_fd_pr__pfet_01v8_hvt m=1 w=0.64u l=0.15u mult=1
+ sa=0.265 sb=0.265 sd=0.28 area=0.063 perim=1.14
MI17 M0 clkneg net51 VNB sky130_fd_pr__pfet_01v8_hvt m=1 w=0.42u l=0.15u mult=1
+ sa=0.265 sb=0.265 sd=0.28 area=0.063 perim=1.14
MI650 Q m1 net59 VNB sky130_fd_pr__pfet_01v8_hvt m=4 w=1.0u l=0.15u mult=1 sa=0.265
+ sb=0.265 sd=0.28 area=0.063 perim=1.14
MI633 clkpos GATE_N net59 VNB sky130_fd_pr__pfet_01v8_hvt m=1 w=0.64u l=0.15u mult=1
+ sa=0.265 sb=0.265 sd=0.28 area=0.063 perim=1.14
MI18 net51 db net59 VNB sky130_fd_pr__pfet_01v8_hvt m=1 w=0.64u l=0.15u mult=1 sa=0.265
+ sb=0.265 sd=0.28 area=0.063 perim=1.14
MI653 net47 m1 net59 VNB sky130_fd_pr__pfet_01v8_hvt m=1 w=0.42u l=0.15u mult=1
+ sa=0.265 sb=0.265 sd=0.28 area=0.063 perim=1.14
MI651 M0 clkpos net47 VNB sky130_fd_pr__pfet_01v8_hvt m=1 w=0.42u l=0.15u mult=1
+ sa=0.265 sb=0.265 sd=0.28 area=0.063 perim=1.14
MI655 m1 M0 net59 VNB sky130_fd_pr__pfet_01v8_hvt m=1 w=1.0u l=0.15u mult=1 sa=0.265
+ sb=0.265 sd=0.28 area=0.063 perim=1.14
MI638 db D net59 VNB sky130_fd_pr__pfet_01v8_hvt m=1 w=0.64u l=0.15u mult=1 sa=0.265
+ sb=0.265 sd=0.28 area=0.063 perim=1.14
MI634 clkpos GATE_N VGND VNB sky130_fd_pr__nfet_01v8 m=1 w=0.42u l=0.15u mult=1
+ sa=0.265 sb=0.265 sd=0.28 area=0.063 perim=1.14
MI649 Q m1 VGND VNB sky130_fd_pr__nfet_01v8 m=4 w=0.65u l=0.15u mult=1 sa=0.265
+ sb=0.265 sd=0.28 area=0.063 perim=1.14
MI652 M0 clkneg net94 VNB sky130_fd_pr__nfet_01v8 m=1 w=0.36u l=0.15u mult=1 sa=0.265
+ sb=0.265 sd=0.28 area=0.063 perim=1.14
MI654 net94 m1 VGND VNB sky130_fd_pr__nfet_01v8 m=1 w=0.42u l=0.15u mult=1 sa=0.265
+ sb=0.265 sd=0.28 area=0.063 perim=1.14
MI656 m1 M0 VGND VNB sky130_fd_pr__nfet_01v8 m=1 w=0.65u l=0.15u mult=1 sa=0.265
+ sb=0.265 sd=0.28 area=0.063 perim=1.14
MI636 clkneg clkpos VGND VNB sky130_fd_pr__nfet_01v8 m=1 w=0.42u l=0.15u mult=1
+ sa=0.265 sb=0.265 sd=0.28 area=0.063 perim=1.14
MI637 db D VGND VNB sky130_fd_pr__nfet_01v8 m=1 w=0.42u l=0.15u mult=1 sa=0.265
+ sb=0.265 sd=0.28 area=0.063 perim=1.14
MI19 M0 clkpos net74 VNB sky130_fd_pr__nfet_01v8 m=1 w=0.36u l=0.15u mult=1 sa=0.265
+ sb=0.265 sd=0.28 area=0.063 perim=1.14
MI20 net74 db VGND VNB sky130_fd_pr__nfet_01v8 m=1 w=0.42u l=0.15u mult=1 sa=0.265
+ sb=0.265 sd=0.28 area=0.063 perim=1.14
.ENDS sky130_fd_sc_hd__dlxtn_4
* Copyright 2020 The SkyWater PDK Authors
*
* Licensed under the Apache License, Version 2.0 (the "License");
* you may not use this file except in compliance with the License.
* You may obtain a copy of the License at
*
*     https:  www.apache.org licenses LICENSE-2.0
*
* Unless required by applicable law or agreed to in writing, software
* distributed under the License is distributed on an "AS IS" BASIS,
* WITHOUT WARRANTIES OR CONDITIONS OF ANY KIND, either express or implied.
* See the License for the specific language governing permissions and
* limitations under the License.
*
* SPDX-License-Identifier: Apache-2.0

.SUBCKT sky130_fd_sc_hd__dlxtp_1 D GATE VGND VNB VNB net59 Q
*.PININFO D:I GATE:I VGND:I VNB:I VNB:I net59:I Q:O
MI635 clkpos clkneg net59 VNB sky130_fd_pr__pfet_01v8_hvt m=1 w=0.64u l=0.15u mult=1
+ sa=0.265 sb=0.265 sd=0.28 area=0.063 perim=1.14
MI17 M0 clkneg net51 VNB sky130_fd_pr__pfet_01v8_hvt m=1 w=0.42u l=0.15u mult=1
+ sa=0.265 sb=0.265 sd=0.28 area=0.063 perim=1.14
MI650 Q m1 net59 VNB sky130_fd_pr__pfet_01v8_hvt m=1 w=1.0u l=0.15u mult=1 sa=0.265
+ sb=0.265 sd=0.28 area=0.063 perim=1.14
MI633 clkneg GATE net59 VNB sky130_fd_pr__pfet_01v8_hvt m=1 w=0.64u l=0.15u mult=1
+ sa=0.265 sb=0.265 sd=0.28 area=0.063 perim=1.14
MI18 net51 db net59 VNB sky130_fd_pr__pfet_01v8_hvt m=1 w=0.64u l=0.15u mult=1 sa=0.265
+ sb=0.265 sd=0.28 area=0.063 perim=1.14
MI653 net47 m1 net59 VNB sky130_fd_pr__pfet_01v8_hvt m=1 w=0.42u l=0.15u mult=1
+ sa=0.265 sb=0.265 sd=0.28 area=0.063 perim=1.14
MI651 M0 clkpos net47 VNB sky130_fd_pr__pfet_01v8_hvt m=1 w=0.42u l=0.15u mult=1
+ sa=0.265 sb=0.265 sd=0.28 area=0.063 perim=1.14
MI655 m1 M0 net59 VNB sky130_fd_pr__pfet_01v8_hvt m=1 w=1.0u l=0.15u mult=1 sa=0.265
+ sb=0.265 sd=0.28 area=0.063 perim=1.14
MI638 db D net59 VNB sky130_fd_pr__pfet_01v8_hvt m=1 w=0.64u l=0.15u mult=1 sa=0.265
+ sb=0.265 sd=0.28 area=0.063 perim=1.14
MI634 clkneg GATE VGND VNB sky130_fd_pr__nfet_01v8 m=1 w=0.42u l=0.15u mult=1 sa=0.265
+ sb=0.265 sd=0.28 area=0.063 perim=1.14
MI649 Q m1 VGND VNB sky130_fd_pr__nfet_01v8 m=1 w=0.65u l=0.15u mult=1 sa=0.265
+ sb=0.265 sd=0.28 area=0.063 perim=1.14
MI652 M0 clkneg net94 VNB sky130_fd_pr__nfet_01v8 m=1 w=0.36u l=0.15u mult=1 sa=0.265
+ sb=0.265 sd=0.28 area=0.063 perim=1.14
MI654 net94 m1 VGND VNB sky130_fd_pr__nfet_01v8 m=1 w=0.36u l=0.15u mult=1 sa=0.265
+ sb=0.265 sd=0.28 area=0.063 perim=1.14
MI656 m1 M0 VGND VNB sky130_fd_pr__nfet_01v8 m=1 w=0.65u l=0.15u mult=1 sa=0.265
+ sb=0.265 sd=0.28 area=0.063 perim=1.14
MI636 clkpos clkneg VGND VNB sky130_fd_pr__nfet_01v8 m=1 w=0.42u l=0.15u mult=1
+ sa=0.265 sb=0.265 sd=0.28 area=0.063 perim=1.14
MI637 db D VGND VNB sky130_fd_pr__nfet_01v8 m=1 w=0.42u l=0.15u mult=1 sa=0.265
+ sb=0.265 sd=0.28 area=0.063 perim=1.14
MI19 M0 clkpos net74 VNB sky130_fd_pr__nfet_01v8 m=1 w=0.36u l=0.15u mult=1 sa=0.265
+ sb=0.265 sd=0.28 area=0.063 perim=1.14
MI20 net74 db VGND VNB sky130_fd_pr__nfet_01v8 m=1 w=0.42u l=0.15u mult=1 sa=0.265
+ sb=0.265 sd=0.28 area=0.063 perim=1.14
.ENDS sky130_fd_sc_hd__dlxtp_1
* Copyright 2020 The SkyWater PDK Authors
*
* Licensed under the Apache License, Version 2.0 (the "License");
* you may not use this file except in compliance with the License.
* You may obtain a copy of the License at
*
*     https:  www.apache.org licenses LICENSE-2.0
*
* Unless required by applicable law or agreed to in writing, software
* distributed under the License is distributed on an "AS IS" BASIS,
* WITHOUT WARRANTIES OR CONDITIONS OF ANY KIND, either express or implied.
* See the License for the specific language governing permissions and
* limitations under the License.
*
* SPDX-License-Identifier: Apache-2.0

.SUBCKT sky130_fd_sc_hd__dlygate4sd1_1 A VGND VNB VNB net59 X
*.PININFO A:I VGND:I VNB:I VNB:I net59:I X:O
MMIN1 Ab net34 VGND VNB sky130_fd_pr__nfet_01v8 m=1 w=0.42u l=0.15u mult=1 sa=0.265
+ sb=0.265 sd=0.28 area=0.063 perim=1.14
MMIN2 X Ab VGND VNB sky130_fd_pr__nfet_01v8 m=1 w=0.65u l=0.15u mult=1 sa=0.265
+ sb=0.265 sd=0.28 area=0.063 perim=1.14
MI6 net34 net30 VGND VNB sky130_fd_pr__nfet_01v8 m=1 w=0.42u l=0.15u mult=1 sa=0.265
+ sb=0.265 sd=0.28 area=0.063 perim=1.14
MI9 net30 A VGND VNB sky130_fd_pr__nfet_01v8 m=1 w=0.42u l=0.15u mult=1 sa=0.265
+ sb=0.265 sd=0.28 area=0.063 perim=1.14
MMIP1 Ab net34 net59 VNB sky130_fd_pr__pfet_01v8_hvt m=1 w=0.42u l=0.15u mult=1
+ sa=0.265 sb=0.265 sd=0.28 area=0.063 perim=1.14
MMIP2 X Ab net59 VNB sky130_fd_pr__pfet_01v8_hvt m=1 w=1.0u l=0.15u mult=1 sa=0.265
+ sb=0.265 sd=0.28 area=0.063 perim=1.14
MI7 net34 net30 net59 VNB sky130_fd_pr__pfet_01v8_hvt m=1 w=0.42u l=0.15u mult=1
+ sa=0.265 sb=0.265 sd=0.28 area=0.063 perim=1.14
MI8 net30 A net59 VNB sky130_fd_pr__pfet_01v8_hvt m=1 w=0.42u l=0.15u mult=1 sa=0.265
+ sb=0.265 sd=0.28 area=0.063 perim=1.14
.ENDS sky130_fd_sc_hd__dlygate4sd1_1
* Copyright 2020 The SkyWater PDK Authors
*
* Licensed under the Apache License, Version 2.0 (the "License");
* you may not use this file except in compliance with the License.
* You may obtain a copy of the License at
*
*     https:  www.apache.org licenses LICENSE-2.0
*
* Unless required by applicable law or agreed to in writing, software
* distributed under the License is distributed on an "AS IS" BASIS,
* WITHOUT WARRANTIES OR CONDITIONS OF ANY KIND, either express or implied.
* See the License for the specific language governing permissions and
* limitations under the License.
*
* SPDX-License-Identifier: Apache-2.0

.SUBCKT sky130_fd_sc_hd__dlygate4sd2_1 A VGND VNB VNB net59 X
*.PININFO A:I VGND:I VNB:I VNB:I net59:I X:O
MMIN1 Ab net34 VGND VNB sky130_fd_pr__nfet_01v8 m=1 w=0.42u l=0.18u mult=1 sa=0.265
+ sb=0.265 sd=0.28 area=0.063 perim=1.14
MMIN2 X Ab VGND VNB sky130_fd_pr__nfet_01v8 m=1 w=0.65u l=0.15u mult=1 sa=0.265
+ sb=0.265 sd=0.28 area=0.063 perim=1.14
MI6 net34 net30 VGND VNB sky130_fd_pr__nfet_01v8 m=1 w=0.42u l=0.18u mult=1 sa=0.265
+ sb=0.265 sd=0.28 area=0.063 perim=1.14
MI9 net30 A VGND VNB sky130_fd_pr__nfet_01v8 m=1 w=0.42u l=0.15u mult=1 sa=0.265
+ sb=0.265 sd=0.28 area=0.063 perim=1.14
MMIP1 Ab net34 net59 VNB sky130_fd_pr__pfet_01v8_hvt m=1 w=0.42u l=0.18u mult=1
+ sa=0.265 sb=0.265 sd=0.28 area=0.063 perim=1.14
MMIP2 X Ab net59 VNB sky130_fd_pr__pfet_01v8_hvt m=1 w=1.0u l=0.15u mult=1 sa=0.265
+ sb=0.265 sd=0.28 area=0.063 perim=1.14
MI7 net34 net30 net59 VNB sky130_fd_pr__pfet_01v8_hvt m=1 w=0.42u l=0.18u mult=1
+ sa=0.265 sb=0.265 sd=0.28 area=0.063 perim=1.14
MI8 net30 A net59 VNB sky130_fd_pr__pfet_01v8_hvt m=1 w=0.42u l=0.15u mult=1 sa=0.265
+ sb=0.265 sd=0.28 area=0.063 perim=1.14
.ENDS sky130_fd_sc_hd__dlygate4sd2_1
* Copyright 2020 The SkyWater PDK Authors
*
* Licensed under the Apache License, Version 2.0 (the "License");
* you may not use this file except in compliance with the License.
* You may obtain a copy of the License at
*
*     https:  www.apache.org licenses LICENSE-2.0
*
* Unless required by applicable law or agreed to in writing, software
* distributed under the License is distributed on an "AS IS" BASIS,
* WITHOUT WARRANTIES OR CONDITIONS OF ANY KIND, either express or implied.
* See the License for the specific language governing permissions and
* limitations under the License.
*
* SPDX-License-Identifier: Apache-2.0

.SUBCKT sky130_fd_sc_hd__dlygate4sd3_1 A VGND VNB VNB net59 X
*.PININFO A:I VGND:I VNB:I VNB:I net59:I X:O
MMIN1 Ab net34 VGND VNB sky130_fd_pr__nfet_01v8 m=1 w=0.42u l=0.5u mult=1 sa=0.265
+ sb=0.265 sd=0.28 area=0.063 perim=1.14
MMIN2 X Ab VGND VNB sky130_fd_pr__nfet_01v8 m=1 w=0.65u l=0.15u mult=1 sa=0.265
+ sb=0.265 sd=0.28 area=0.063 perim=1.14
MI6 net34 net30 VGND VNB sky130_fd_pr__nfet_01v8 m=1 w=0.42u l=0.5u mult=1 sa=0.265
+ sb=0.265 sd=0.28 area=0.063 perim=1.14
MI9 net30 A VGND VNB sky130_fd_pr__nfet_01v8 m=1 w=0.42u l=0.15u mult=1 sa=0.265
+ sb=0.265 sd=0.28 area=0.063 perim=1.14
MMIP1 Ab net34 net59 VNB sky130_fd_pr__pfet_01v8_hvt m=1 w=0.42u l=0.5u mult=1 sa=0.265
+ sb=0.265 sd=0.28 area=0.063 perim=1.14
MMIP2 X Ab net59 VNB sky130_fd_pr__pfet_01v8_hvt m=1 w=1.0u l=0.15u mult=1 sa=0.265
+ sb=0.265 sd=0.28 area=0.063 perim=1.14
MI7 net34 net30 net59 VNB sky130_fd_pr__pfet_01v8_hvt m=1 w=0.42u l=0.5u mult=1
+ sa=0.265 sb=0.265 sd=0.28 area=0.063 perim=1.14
MI8 net30 A net59 VNB sky130_fd_pr__pfet_01v8_hvt m=1 w=0.42u l=0.15u mult=1 sa=0.265
+ sb=0.265 sd=0.28 area=0.063 perim=1.14
.ENDS sky130_fd_sc_hd__dlygate4sd3_1
* Copyright 2020 The SkyWater PDK Authors
*
* Licensed under the Apache License, Version 2.0 (the "License");
* you may not use this file except in compliance with the License.
* You may obtain a copy of the License at
*
*     https:  www.apache.org licenses LICENSE-2.0
*
* Unless required by applicable law or agreed to in writing, software
* distributed under the License is distributed on an "AS IS" BASIS,
* WITHOUT WARRANTIES OR CONDITIONS OF ANY KIND, either express or implied.
* See the License for the specific language governing permissions and
* limitations under the License.
*
* SPDX-License-Identifier: Apache-2.0

.SUBCKT sky130_fd_sc_hd__dlymetal6s2s_1 A VGND VNB VNB net59 X
*.PININFO A:I VGND:I VNB:I VNB:I net59:I X:O
MMIN1 Ab net55 VGND VNB sky130_fd_pr__nfet_01v8 m=1 w=0.42u l=0.15u mult=1 sa=0.265
+ sb=0.265 sd=0.28 area=0.063 perim=1.14
MMIN2 net59 Ab VGND VNB sky130_fd_pr__nfet_01v8 m=1 w=0.65u l=0.15u mult=1 sa=0.265
+ sb=0.265 sd=0.28 area=0.063 perim=1.14
MI6 net55 net47 VGND VNB sky130_fd_pr__nfet_01v8 m=1 w=0.65u l=0.15u mult=1 sa=0.265
+ sb=0.265 sd=0.28 area=0.063 perim=1.14
MI15 net51 A VGND VNB sky130_fd_pr__nfet_01v8 m=1 w=0.42u l=0.15u mult=1 sa=0.265
+ sb=0.265 sd=0.28 area=0.063 perim=1.14
MI9 net47 X VGND VNB sky130_fd_pr__nfet_01v8 m=1 w=0.42u l=0.15u mult=1 sa=0.265
+ sb=0.265 sd=0.28 area=0.063 perim=1.14
MI16 X net51 VGND VNB sky130_fd_pr__nfet_01v8 m=1 w=0.65u l=0.15u mult=1 sa=0.265
+ sb=0.265 sd=0.28 area=0.063 perim=1.14
MMIP1 Ab net55 net59 VNB sky130_fd_pr__pfet_01v8_hvt m=1 w=0.42u l=0.15u mult=1
+ sa=0.265 sb=0.265 sd=0.28 area=0.063 perim=1.14
MMIP2 net59 Ab net59 VNB sky130_fd_pr__pfet_01v8_hvt m=1 w=1.0u l=0.15u mult=1 sa=0.265
+ sb=0.265 sd=0.28 area=0.063 perim=1.14
MI7 net55 net47 net59 VNB sky130_fd_pr__pfet_01v8_hvt m=1 w=1.0u l=0.15u mult=1
+ sa=0.265 sb=0.265 sd=0.28 area=0.063 perim=1.14
MI8 net47 X net59 VNB sky130_fd_pr__pfet_01v8_hvt m=1 w=0.42u l=0.15u mult=1 sa=0.265
+ sb=0.265 sd=0.28 area=0.063 perim=1.14
MI18 X net51 net59 VNB sky130_fd_pr__pfet_01v8_hvt m=1 w=1.0u l=0.15u mult=1 sa=0.265
+ sb=0.265 sd=0.28 area=0.063 perim=1.14
MI17 net51 A net59 VNB sky130_fd_pr__pfet_01v8_hvt m=1 w=0.42u l=0.15u mult=1 sa=0.265
+ sb=0.265 sd=0.28 area=0.063 perim=1.14
.ENDS sky130_fd_sc_hd__dlymetal6s2s_1
* Copyright 2020 The SkyWater PDK Authors
*
* Licensed under the Apache License, Version 2.0 (the "License");
* you may not use this file except in compliance with the License.
* You may obtain a copy of the License at
*
*     https:  www.apache.org licenses LICENSE-2.0
*
* Unless required by applicable law or agreed to in writing, software
* distributed under the License is distributed on an "AS IS" BASIS,
* WITHOUT WARRANTIES OR CONDITIONS OF ANY KIND, either express or implied.
* See the License for the specific language governing permissions and
* limitations under the License.
*
* SPDX-License-Identifier: Apache-2.0

.SUBCKT sky130_fd_sc_hd__dlymetal6s4s_1 A VGND VNB VNB net59 X
*.PININFO A:I VGND:I VNB:I VNB:I net59:I X:O
MMIN1 Ab X VGND VNB sky130_fd_pr__nfet_01v8 m=1 w=0.42u l=0.15u mult=1 sa=0.265
+ sb=0.265 sd=0.28 area=0.063 perim=1.14
MMIN2 net59 Ab VGND VNB sky130_fd_pr__nfet_01v8 m=1 w=0.65u l=0.15u mult=1 sa=0.265
+ sb=0.265 sd=0.28 area=0.063 perim=1.14
MI6 X net47 VGND VNB sky130_fd_pr__nfet_01v8 m=1 w=0.65u l=0.15u mult=1 sa=0.265
+ sb=0.265 sd=0.28 area=0.063 perim=1.14
MI15 net51 A VGND VNB sky130_fd_pr__nfet_01v8 m=1 w=0.42u l=0.15u mult=1 sa=0.265
+ sb=0.265 sd=0.28 area=0.063 perim=1.14
MI9 net47 net43 VGND VNB sky130_fd_pr__nfet_01v8 m=1 w=0.42u l=0.15u mult=1 sa=0.265
+ sb=0.265 sd=0.28 area=0.063 perim=1.14
MI16 net43 net51 VGND VNB sky130_fd_pr__nfet_01v8 m=1 w=0.65u l=0.15u mult=1 sa=0.265
+ sb=0.265 sd=0.28 area=0.063 perim=1.14
MMIP1 Ab X net59 VNB sky130_fd_pr__pfet_01v8_hvt m=1 w=0.42u l=0.15u mult=1 sa=0.265
+ sb=0.265 sd=0.28 area=0.063 perim=1.14
MMIP2 net59 Ab net59 VNB sky130_fd_pr__pfet_01v8_hvt m=1 w=1.0u l=0.15u mult=1 sa=0.265
+ sb=0.265 sd=0.28 area=0.063 perim=1.14
MI7 X net47 net59 VNB sky130_fd_pr__pfet_01v8_hvt m=1 w=1.0u l=0.15u mult=1 sa=0.265
+ sb=0.265 sd=0.28 area=0.063 perim=1.14
MI8 net47 net43 net59 VNB sky130_fd_pr__pfet_01v8_hvt m=1 w=0.42u l=0.15u mult=1
+ sa=0.265 sb=0.265 sd=0.28 area=0.063 perim=1.14
MI18 net43 net51 net59 VNB sky130_fd_pr__pfet_01v8_hvt m=1 w=1.0u l=0.15u mult=1
+ sa=0.265 sb=0.265 sd=0.28 area=0.063 perim=1.14
MI17 net51 A net59 VNB sky130_fd_pr__pfet_01v8_hvt m=1 w=0.42u l=0.15u mult=1 sa=0.265
+ sb=0.265 sd=0.28 area=0.063 perim=1.14
.ENDS sky130_fd_sc_hd__dlymetal6s4s_1
* Copyright 2020 The SkyWater PDK Authors
*
* Licensed under the Apache License, Version 2.0 (the "License");
* you may not use this file except in compliance with the License.
* You may obtain a copy of the License at
*
*     https:  www.apache.org licenses LICENSE-2.0
*
* Unless required by applicable law or agreed to in writing, software
* distributed under the License is distributed on an "AS IS" BASIS,
* WITHOUT WARRANTIES OR CONDITIONS OF ANY KIND, either express or implied.
* See the License for the specific language governing permissions and
* limitations under the License.
*
* SPDX-License-Identifier: Apache-2.0

.SUBCKT sky130_fd_sc_hd__dlymetal6s6s_1 A VGND VNB VNB net59 X
*.PININFO A:I VGND:I VNB:I VNB:I net59:I X:O
MMIN1 Ab net56 VGND VNB sky130_fd_pr__nfet_01v8 m=1 w=0.42u l=0.15u mult=1 sa=0.265
+ sb=0.265 sd=0.28 area=0.063 perim=1.14
MMIN2 X Ab VGND VNB sky130_fd_pr__nfet_01v8 m=1 w=0.65u l=0.15u mult=1 sa=0.265
+ sb=0.265 sd=0.28 area=0.063 perim=1.14
MI6 net56 net48 VGND VNB sky130_fd_pr__nfet_01v8 m=1 w=0.65u l=0.15u mult=1 sa=0.265
+ sb=0.265 sd=0.28 area=0.063 perim=1.14
MI15 net52 A VGND VNB sky130_fd_pr__nfet_01v8 m=1 w=0.42u l=0.15u mult=1 sa=0.265
+ sb=0.265 sd=0.28 area=0.063 perim=1.14
MI9 net48 net44 VGND VNB sky130_fd_pr__nfet_01v8 m=1 w=0.42u l=0.15u mult=1 sa=0.265
+ sb=0.265 sd=0.28 area=0.063 perim=1.14
MI16 net44 net52 VGND VNB sky130_fd_pr__nfet_01v8 m=1 w=0.65u l=0.15u mult=1 sa=0.265
+ sb=0.265 sd=0.28 area=0.063 perim=1.14
MMIP1 Ab net56 net59 VNB sky130_fd_pr__pfet_01v8_hvt m=1 w=0.42u l=0.15u mult=1
+ sa=0.265 sb=0.265 sd=0.28 area=0.063 perim=1.14
MMIP2 X Ab net59 VNB sky130_fd_pr__pfet_01v8_hvt m=1 w=1.0u l=0.15u mult=1 sa=0.265
+ sb=0.265 sd=0.28 area=0.063 perim=1.14
MI7 net56 net48 net59 VNB sky130_fd_pr__pfet_01v8_hvt m=1 w=1.0u l=0.15u mult=1
+ sa=0.265 sb=0.265 sd=0.28 area=0.063 perim=1.14
MI8 net48 net44 net59 VNB sky130_fd_pr__pfet_01v8_hvt m=1 w=0.42u l=0.15u mult=1
+ sa=0.265 sb=0.265 sd=0.28 area=0.063 perim=1.14
MI18 net44 net52 net59 VNB sky130_fd_pr__pfet_01v8_hvt m=1 w=1.0u l=0.15u mult=1
+ sa=0.265 sb=0.265 sd=0.28 area=0.063 perim=1.14
MI17 net52 A net59 VNB sky130_fd_pr__pfet_01v8_hvt m=1 w=0.42u l=0.15u mult=1 sa=0.265
+ sb=0.265 sd=0.28 area=0.063 perim=1.14
.ENDS sky130_fd_sc_hd__dlymetal6s6s_1
* Copyright 2020 The SkyWater PDK Authors
*
* Licensed under the Apache License, Version 2.0 (the "License");
* you may not use this file except in compliance with the License.
* You may obtain a copy of the License at
*
*     https:  www.apache.org licenses LICENSE-2.0
*
* Unless required by applicable law or agreed to in writing, software
* distributed under the License is distributed on an "AS IS" BASIS,
* WITHOUT WARRANTIES OR CONDITIONS OF ANY KIND, either express or implied.
* See the License for the specific language governing permissions and
* limitations under the License.
*
* SPDX-License-Identifier: Apache-2.0

.SUBCKT sky130_fd_sc_hd__ebufn_1 A TE_B VGND VNB VNB net59 Z
*.PININFO A:I TE_B:I VGND:I VNB:I VNB:I net59:I Z:O
MMN0 Z net35 sndA VNB sky130_fd_pr__nfet_01v8 m=1 w=0.65u l=0.15u mult=1 sa=0.265
+ sb=0.265 sd=0.28 area=0.063 perim=1.14
MMN1 sndA net39 VGND VNB sky130_fd_pr__nfet_01v8 m=1 w=0.65u l=0.15u mult=1 sa=0.265
+ sb=0.265 sd=0.28 area=0.063 perim=1.14
MMIN1 net39 TE_B VGND VNB sky130_fd_pr__nfet_01v8 m=1 w=0.42u l=0.15u mult=1 sa=0.265
+ sb=0.265 sd=0.28 area=0.063 perim=1.14
MI6 net35 A VGND VNB sky130_fd_pr__nfet_01v8 m=1 w=0.42u l=0.15u mult=1 sa=0.265
+ sb=0.265 sd=0.28 area=0.063 perim=1.14
MMP0 net59 TE_B sndTEB VNB sky130_fd_pr__pfet_01v8_hvt m=1 w=1.0u l=0.15u mult=1
+ sa=0.265 sb=0.265 sd=0.28 area=0.063 perim=1.14
MMP1 sndTEB net35 Z VNB sky130_fd_pr__pfet_01v8_hvt m=1 w=1.0u l=0.15u mult=1 sa=0.265
+ sb=0.265 sd=0.28 area=0.063 perim=1.14
MMIP1 net39 TE_B net59 VNB sky130_fd_pr__pfet_01v8_hvt m=1 w=0.64u l=0.15u mult=1
+ sa=0.265 sb=0.265 sd=0.28 area=0.063 perim=1.14
MI5 net35 A net59 VNB sky130_fd_pr__pfet_01v8_hvt m=1 w=0.64u l=0.15u mult=1 sa=0.265
+ sb=0.265 sd=0.28 area=0.063 perim=1.14
.ENDS sky130_fd_sc_hd__ebufn_1
* Copyright 2020 The SkyWater PDK Authors
*
* Licensed under the Apache License, Version 2.0 (the "License");
* you may not use this file except in compliance with the License.
* You may obtain a copy of the License at
*
*     https:  www.apache.org licenses LICENSE-2.0
*
* Unless required by applicable law or agreed to in writing, software
* distributed under the License is distributed on an "AS IS" BASIS,
* WITHOUT WARRANTIES OR CONDITIONS OF ANY KIND, either express or implied.
* See the License for the specific language governing permissions and
* limitations under the License.
*
* SPDX-License-Identifier: Apache-2.0

.SUBCKT sky130_fd_sc_hd__ebufn_2 A TE_B VGND VNB VNB net59 Z
*.PININFO A:I TE_B:I VGND:I VNB:I VNB:I net59:I Z:O
MMN0 Z net35 sndA VNB sky130_fd_pr__nfet_01v8 m=2 w=0.65u l=0.15u mult=1 sa=0.265
+ sb=0.265 sd=0.28 area=0.063 perim=1.14
MMN1 sndA net39 VGND VNB sky130_fd_pr__nfet_01v8 m=2 w=0.65u l=0.15u mult=1 sa=0.265
+ sb=0.265 sd=0.28 area=0.063 perim=1.14
MMIN1 net39 TE_B VGND VNB sky130_fd_pr__nfet_01v8 m=1 w=0.42u l=0.15u mult=1 sa=0.265
+ sb=0.265 sd=0.28 area=0.063 perim=1.14
MI6 net35 A VGND VNB sky130_fd_pr__nfet_01v8 m=1 w=0.42u l=0.15u mult=1 sa=0.265
+ sb=0.265 sd=0.28 area=0.063 perim=1.14
MMP0 net59 TE_B sndTEB VNB sky130_fd_pr__pfet_01v8_hvt m=2 w=0.94u l=0.15u mult=1
+ sa=0.265 sb=0.265 sd=0.28 area=0.063 perim=1.14
MMP1 sndTEB net35 Z VNB sky130_fd_pr__pfet_01v8_hvt m=2 w=1.0u l=0.15u mult=1 sa=0.265
+ sb=0.265 sd=0.28 area=0.063 perim=1.14
MMIP1 net39 TE_B net59 VNB sky130_fd_pr__pfet_01v8_hvt m=1 w=0.64u l=0.15u mult=1
+ sa=0.265 sb=0.265 sd=0.28 area=0.063 perim=1.14
MI5 net35 A net59 VNB sky130_fd_pr__pfet_01v8_hvt m=1 w=0.64u l=0.15u mult=1 sa=0.265
+ sb=0.265 sd=0.28 area=0.063 perim=1.14
.ENDS sky130_fd_sc_hd__ebufn_2
* Copyright 2020 The SkyWater PDK Authors
*
* Licensed under the Apache License, Version 2.0 (the "License");
* you may not use this file except in compliance with the License.
* You may obtain a copy of the License at
*
*     https:  www.apache.org licenses LICENSE-2.0
*
* Unless required by applicable law or agreed to in writing, software
* distributed under the License is distributed on an "AS IS" BASIS,
* WITHOUT WARRANTIES OR CONDITIONS OF ANY KIND, either express or implied.
* See the License for the specific language governing permissions and
* limitations under the License.
*
* SPDX-License-Identifier: Apache-2.0

.SUBCKT sky130_fd_sc_hd__ebufn_4 A TE_B VGND VNB VNB net59 Z
*.PININFO A:I TE_B:I VGND:I VNB:I VNB:I net59:I Z:O
MMN0 Z net35 sndA VNB sky130_fd_pr__nfet_01v8 m=4 w=0.65u l=0.15u mult=1 sa=0.265
+ sb=0.265 sd=0.28 area=0.063 perim=1.14
MMN1 sndA net39 VGND VNB sky130_fd_pr__nfet_01v8 m=4 w=0.65u l=0.15u mult=1 sa=0.265
+ sb=0.265 sd=0.28 area=0.063 perim=1.14
MMIN1 net39 TE_B VGND VNB sky130_fd_pr__nfet_01v8 m=1 w=0.65u l=0.15u mult=1 sa=0.265
+ sb=0.265 sd=0.28 area=0.063 perim=1.14
MI6 net35 A VGND VNB sky130_fd_pr__nfet_01v8 m=1 w=0.65u l=0.15u mult=1 sa=0.265
+ sb=0.265 sd=0.28 area=0.063 perim=1.14
MMP0 net59 TE_B sndTEB VNB sky130_fd_pr__pfet_01v8_hvt m=4 w=0.94u l=0.15u mult=1
+ sa=0.265 sb=0.265 sd=0.28 area=0.063 perim=1.14
MMP1 sndTEB net35 Z VNB sky130_fd_pr__pfet_01v8_hvt m=4 w=1.0u l=0.15u mult=1 sa=0.265
+ sb=0.265 sd=0.28 area=0.063 perim=1.14
MMIP1 net39 TE_B net59 VNB sky130_fd_pr__pfet_01v8_hvt m=1 w=1.0u l=0.15u mult=1
+ sa=0.265 sb=0.265 sd=0.28 area=0.063 perim=1.14
MI5 net35 A net59 VNB sky130_fd_pr__pfet_01v8_hvt m=1 w=1.0u l=0.15u mult=1 sa=0.265
+ sb=0.265 sd=0.28 area=0.063 perim=1.14
.ENDS sky130_fd_sc_hd__ebufn_4
* Copyright 2020 The SkyWater PDK Authors
*
* Licensed under the Apache License, Version 2.0 (the "License");
* you may not use this file except in compliance with the License.
* You may obtain a copy of the License at
*
*     https:  www.apache.org licenses LICENSE-2.0
*
* Unless required by applicable law or agreed to in writing, software
* distributed under the License is distributed on an "AS IS" BASIS,
* WITHOUT WARRANTIES OR CONDITIONS OF ANY KIND, either express or implied.
* See the License for the specific language governing permissions and
* limitations under the License.
*
* SPDX-License-Identifier: Apache-2.0

.SUBCKT sky130_fd_sc_hd__ebufn_8 A TE_B VGND VNB VNB net59 Z
*.PININFO A:I TE_B:I VGND:I VNB:I VNB:I net59:I Z:O
MMN0 Z net35 sndA VNB sky130_fd_pr__nfet_01v8 m=8 w=0.65u l=0.15u mult=1 sa=0.265
+ sb=0.265 sd=0.28 area=0.063 perim=1.14
MMN1 sndA net39 VGND VNB sky130_fd_pr__nfet_01v8 m=8 w=0.65u l=0.15u mult=1 sa=0.265
+ sb=0.265 sd=0.28 area=0.063 perim=1.14
MMIN1 net39 TE_B VGND VNB sky130_fd_pr__nfet_01v8 m=1 w=0.65u l=0.15u mult=1 sa=0.265
+ sb=0.265 sd=0.28 area=0.063 perim=1.14
MI6 net35 A VGND VNB sky130_fd_pr__nfet_01v8 m=2 w=0.65u l=0.15u mult=1 sa=0.265
+ sb=0.265 sd=0.28 area=0.063 perim=1.14
MMP0 net59 TE_B sndTEB VNB sky130_fd_pr__pfet_01v8_hvt m=8 w=0.94u l=0.15u mult=1
+ sa=0.265 sb=0.265 sd=0.28 area=0.063 perim=1.14
MMP1 sndTEB net35 Z VNB sky130_fd_pr__pfet_01v8_hvt m=8 w=1.0u l=0.15u mult=1 sa=0.265
+ sb=0.265 sd=0.28 area=0.063 perim=1.14
MMIP1 net39 TE_B net59 VNB sky130_fd_pr__pfet_01v8_hvt m=1 w=1.0u l=0.15u mult=1
+ sa=0.265 sb=0.265 sd=0.28 area=0.063 perim=1.14
MI5 net35 A net59 VNB sky130_fd_pr__pfet_01v8_hvt m=2 w=1.0u l=0.15u mult=1 sa=0.265
+ sb=0.265 sd=0.28 area=0.063 perim=1.14
.ENDS sky130_fd_sc_hd__ebufn_8
* Copyright 2020 The SkyWater PDK Authors
*
* Licensed under the Apache License, Version 2.0 (the "License");
* you may not use this file except in compliance with the License.
* You may obtain a copy of the License at
*
*     https:  www.apache.org licenses LICENSE-2.0
*
* Unless required by applicable law or agreed to in writing, software
* distributed under the License is distributed on an "AS IS" BASIS,
* WITHOUT WARRANTIES OR CONDITIONS OF ANY KIND, either express or implied.
* See the License for the specific language governing permissions and
* limitations under the License.
*
* SPDX-License-Identifier: Apache-2.0

.SUBCKT sky130_fd_sc_hd__edfxbp_1 CLK D DE VGND VNB VNB net59 Q Q_N
*.PININFO CLK:I D:I DE:I VGND:I VNB:I VNB:I net59:I Q:O Q_N:O
MI14 net124 M1 net59 VNB sky130_fd_pr__pfet_01v8_hvt m=1 w=0.42u l=0.15u mult=1
+ sa=0.265 sb=0.265 sd=0.28 area=0.063 perim=1.14
MI637 clkpos clkneg net59 VNB sky130_fd_pr__pfet_01v8_hvt m=1 w=0.64u l=0.15u mult=1
+ sa=0.265 sb=0.265 sd=0.28 area=0.063 perim=1.14
MI13 S0 clkneg net124 VNB sky130_fd_pr__pfet_01v8_hvt m=1 w=0.42u l=0.15u mult=1
+ sa=0.265 sb=0.265 sd=0.28 area=0.063 perim=1.14
MI655 net68 deneg net59 VNB sky130_fd_pr__pfet_01v8_hvt m=1 w=0.64u l=0.15u mult=1
+ sa=0.265 sb=0.265 sd=0.28 area=0.063 perim=1.14
MI651 db clkpos M0 VNB sky130_fd_pr__pfet_01v8_hvt m=1 w=0.42u l=0.15u mult=1 sa=0.265
+ sb=0.265 sd=0.28 area=0.063 perim=1.14
MI645 Q S0 net59 VNB sky130_fd_pr__pfet_01v8_hvt m=1 w=1.0u l=0.15u mult=1 sa=0.265
+ sb=0.265 sd=0.28 area=0.063 perim=1.14
MI658 net109 M1 net59 VNB sky130_fd_pr__pfet_01v8_hvt m=1 w=0.42u l=0.15u mult=1
+ sa=0.265 sb=0.265 sd=0.28 area=0.063 perim=1.14
MI638 clkneg CLK net59 VNB sky130_fd_pr__pfet_01v8_hvt m=1 w=0.64u l=0.15u mult=1
+ sa=0.265 sb=0.265 sd=0.28 area=0.063 perim=1.14
MI643 net92 S1 net59 VNB sky130_fd_pr__pfet_01v8_hvt m=1 w=0.42u l=0.15u mult=1
+ sa=0.265 sb=0.265 sd=0.28 area=0.063 perim=1.14
MI639 M1 M0 net59 VNB sky130_fd_pr__pfet_01v8_hvt m=1 w=0.75u l=0.15u mult=1 sa=0.265
+ sb=0.265 sd=0.28 area=0.063 perim=1.14
MI644 S0 clkpos net92 VNB sky130_fd_pr__pfet_01v8_hvt m=1 w=0.42u l=0.15u mult=1
+ sa=0.265 sb=0.265 sd=0.28 area=0.063 perim=1.14
MI659 M0 clkneg net109 VNB sky130_fd_pr__pfet_01v8_hvt m=1 w=0.42u l=0.15u mult=1
+ sa=0.265 sb=0.265 sd=0.28 area=0.063 perim=1.14
MI10 net85 DE net59 VNB sky130_fd_pr__pfet_01v8_hvt m=1 w=0.64u l=0.15u mult=1 sa=0.265
+ sb=0.265 sd=0.28 area=0.063 perim=1.14
MI17 S1 S0 net59 VNB sky130_fd_pr__pfet_01v8_hvt m=1 w=0.64u l=0.15u mult=1 sa=0.265
+ sb=0.265 sd=0.28 area=0.063 perim=1.14
MI9 db S1 net85 VNB sky130_fd_pr__pfet_01v8_hvt m=1 w=0.64u l=0.15u mult=1 sa=0.265
+ sb=0.265 sd=0.28 area=0.063 perim=1.14
MI4 deneg DE net59 VNB sky130_fd_pr__pfet_01v8_hvt m=1 w=0.64u l=0.15u mult=1 sa=0.265
+ sb=0.265 sd=0.28 area=0.063 perim=1.14
MI8 db D net68 VNB sky130_fd_pr__pfet_01v8_hvt m=1 w=0.64u l=0.15u mult=1 sa=0.265
+ sb=0.265 sd=0.28 area=0.063 perim=1.14
MI21 Q_N S1 net59 VNB sky130_fd_pr__pfet_01v8_hvt m=1 w=1.0u l=0.15u mult=1 sa=0.265
+ sb=0.265 sd=0.28 area=0.063 perim=1.14
MI634 M1 M0 VGND VNB sky130_fd_pr__nfet_01v8 m=1 w=0.64u l=0.15u mult=1 sa=0.265
+ sb=0.265 sd=0.28 area=0.063 perim=1.14
MI636 clkpos clkneg VGND VNB sky130_fd_pr__nfet_01v8 m=1 w=0.42u l=0.15u mult=1
+ sa=0.265 sb=0.265 sd=0.28 area=0.063 perim=1.14
MI635 clkneg CLK VGND VNB sky130_fd_pr__nfet_01v8 m=1 w=0.42u l=0.15u mult=1 sa=0.265
+ sb=0.265 sd=0.28 area=0.063 perim=1.14
MI641 net193 S1 VGND VNB sky130_fd_pr__nfet_01v8 m=1 w=0.42u l=0.15u mult=1 sa=0.265
+ sb=0.265 sd=0.28 area=0.063 perim=1.14
MI642 S0 clkneg net193 VNB sky130_fd_pr__nfet_01v8 m=1 w=0.36u l=0.15u mult=1 sa=0.265
+ sb=0.265 sd=0.28 area=0.063 perim=1.14
MI654 net148 DE VGND VNB sky130_fd_pr__nfet_01v8 m=1 w=0.42u l=0.15u mult=1 sa=0.265
+ sb=0.265 sd=0.28 area=0.063 perim=1.14
MI648 db clkneg M0 VNB sky130_fd_pr__nfet_01v8 m=1 w=0.36u l=0.15u mult=1 sa=0.265
+ sb=0.265 sd=0.28 area=0.063 perim=1.14
MI646 Q S0 VGND VNB sky130_fd_pr__nfet_01v8 m=1 w=0.65u l=0.15u mult=1 sa=0.265
+ sb=0.265 sd=0.28 area=0.063 perim=1.14
MI656 net168 M1 VGND VNB sky130_fd_pr__nfet_01v8 m=1 w=0.42u l=0.15u mult=1 sa=0.265
+ sb=0.265 sd=0.28 area=0.063 perim=1.14
MI657 M0 clkpos net168 VNB sky130_fd_pr__nfet_01v8 m=1 w=0.36u l=0.15u mult=1 sa=0.265
+ sb=0.265 sd=0.28 area=0.063 perim=1.14
MI18 S1 S0 VGND VNB sky130_fd_pr__nfet_01v8 m=1 w=0.42u l=0.15u mult=1 sa=0.265
+ sb=0.265 sd=0.28 area=0.063 perim=1.14
MI16 net161 M1 VGND VNB sky130_fd_pr__nfet_01v8 m=1 w=0.42u l=0.15u mult=1 sa=0.265
+ sb=0.265 sd=0.28 area=0.063 perim=1.14
MI15 S0 clkpos net161 VNB sky130_fd_pr__nfet_01v8 m=1 w=0.36u l=0.15u mult=1 sa=0.265
+ sb=0.265 sd=0.28 area=0.063 perim=1.14
MI5 deneg DE VGND VNB sky130_fd_pr__nfet_01v8 m=1 w=0.42u l=0.15u mult=1 sa=0.265
+ sb=0.265 sd=0.28 area=0.063 perim=1.14
MI7 db D net148 VNB sky130_fd_pr__nfet_01v8 m=1 w=0.42u l=0.15u mult=1 sa=0.265
+ sb=0.265 sd=0.28 area=0.063 perim=1.14
MI11 db S1 net141 VNB sky130_fd_pr__nfet_01v8 m=1 w=0.42u l=0.15u mult=1 sa=0.265
+ sb=0.265 sd=0.28 area=0.063 perim=1.14
MI12 net141 deneg VGND VNB sky130_fd_pr__nfet_01v8 m=1 w=0.42u l=0.15u mult=1 sa=0.265
+ sb=0.265 sd=0.28 area=0.063 perim=1.14
MI22 Q_N S1 VGND VNB sky130_fd_pr__nfet_01v8 m=1 w=0.65u l=0.15u mult=1 sa=0.265
+ sb=0.265 sd=0.28 area=0.063 perim=1.14
.ENDS sky130_fd_sc_hd__edfxbp_1
* Copyright 2020 The SkyWater PDK Authors
*
* Licensed under the Apache License, Version 2.0 (the "License");
* you may not use this file except in compliance with the License.
* You may obtain a copy of the License at
*
*     https:  www.apache.org licenses LICENSE-2.0
*
* Unless required by applicable law or agreed to in writing, software
* distributed under the License is distributed on an "AS IS" BASIS,
* WITHOUT WARRANTIES OR CONDITIONS OF ANY KIND, either express or implied.
* See the License for the specific language governing permissions and
* limitations under the License.
*
* SPDX-License-Identifier: Apache-2.0

.SUBCKT sky130_fd_sc_hd__edfxtp_1 CLK D DE VGND VNB VNB net59 Q
*.PININFO CLK:I D:I DE:I VGND:I VNB:I VNB:I net59:I Q:O
MI14 net115 M1 net59 VNB sky130_fd_pr__pfet_01v8_hvt m=1 w=0.42u l=0.15u mult=1
+ sa=0.265 sb=0.265 sd=0.28 area=0.063 perim=1.14
MI637 clkpos clkneg net59 VNB sky130_fd_pr__pfet_01v8_hvt m=1 w=0.64u l=0.15u mult=1
+ sa=0.265 sb=0.265 sd=0.28 area=0.063 perim=1.14
MI13 S0 clkneg net115 VNB sky130_fd_pr__pfet_01v8_hvt m=1 w=0.42u l=0.15u mult=1
+ sa=0.265 sb=0.265 sd=0.28 area=0.063 perim=1.14
MI655 net59 deneg net59 VNB sky130_fd_pr__pfet_01v8_hvt m=1 w=0.64u l=0.15u mult=1
+ sa=0.265 sb=0.265 sd=0.28 area=0.063 perim=1.14
MI651 db clkpos M0 VNB sky130_fd_pr__pfet_01v8_hvt m=1 w=0.42u l=0.15u mult=1 sa=0.265
+ sb=0.265 sd=0.28 area=0.063 perim=1.14
MI645 Q S0 net59 VNB sky130_fd_pr__pfet_01v8_hvt m=1 w=1.0u l=0.15u mult=1 sa=0.265
+ sb=0.265 sd=0.28 area=0.063 perim=1.14
MI658 net79 M1 net59 VNB sky130_fd_pr__pfet_01v8_hvt m=1 w=0.42u l=0.15u mult=1
+ sa=0.265 sb=0.265 sd=0.28 area=0.063 perim=1.14
MI638 clkneg CLK net59 VNB sky130_fd_pr__pfet_01v8_hvt m=1 w=0.64u l=0.15u mult=1
+ sa=0.265 sb=0.265 sd=0.28 area=0.063 perim=1.14
MI643 net83 S1 net59 VNB sky130_fd_pr__pfet_01v8_hvt m=1 w=0.42u l=0.15u mult=1
+ sa=0.265 sb=0.265 sd=0.28 area=0.063 perim=1.14
MI639 M1 M0 net59 VNB sky130_fd_pr__pfet_01v8_hvt m=1 w=0.75u l=0.15u mult=1 sa=0.265
+ sb=0.265 sd=0.28 area=0.063 perim=1.14
MI644 S0 clkpos net83 VNB sky130_fd_pr__pfet_01v8_hvt m=1 w=0.42u l=0.15u mult=1
+ sa=0.265 sb=0.265 sd=0.28 area=0.063 perim=1.14
MI659 M0 clkneg net79 VNB sky130_fd_pr__pfet_01v8_hvt m=1 w=0.42u l=0.15u mult=1
+ sa=0.265 sb=0.265 sd=0.28 area=0.063 perim=1.14
MI10 net76 DE net59 VNB sky130_fd_pr__pfet_01v8_hvt m=1 w=0.64u l=0.15u mult=1 sa=0.265
+ sb=0.265 sd=0.28 area=0.063 perim=1.14
MI17 S1 S0 net59 VNB sky130_fd_pr__pfet_01v8_hvt m=1 w=0.64u l=0.15u mult=1 sa=0.265
+ sb=0.265 sd=0.28 area=0.063 perim=1.14
MI9 db S1 net76 VNB sky130_fd_pr__pfet_01v8_hvt m=1 w=0.64u l=0.15u mult=1 sa=0.265
+ sb=0.265 sd=0.28 area=0.063 perim=1.14
MI4 deneg DE net59 VNB sky130_fd_pr__pfet_01v8_hvt m=1 w=0.64u l=0.15u mult=1 sa=0.265
+ sb=0.265 sd=0.28 area=0.063 perim=1.14
MI8 db D net59 VNB sky130_fd_pr__pfet_01v8_hvt m=1 w=0.64u l=0.15u mult=1 sa=0.265
+ sb=0.265 sd=0.28 area=0.063 perim=1.14
MI634 M1 M0 VGND VNB sky130_fd_pr__nfet_01v8 m=1 w=0.64u l=0.15u mult=1 sa=0.265
+ sb=0.265 sd=0.28 area=0.063 perim=1.14
MI636 clkpos clkneg VGND VNB sky130_fd_pr__nfet_01v8 m=1 w=0.42u l=0.15u mult=1
+ sa=0.265 sb=0.265 sd=0.28 area=0.063 perim=1.14
MI635 clkneg CLK VGND VNB sky130_fd_pr__nfet_01v8 m=1 w=0.42u l=0.15u mult=1 sa=0.265
+ sb=0.265 sd=0.28 area=0.063 perim=1.14
MI641 net175 S1 VGND VNB sky130_fd_pr__nfet_01v8 m=1 w=0.42u l=0.15u mult=1 sa=0.265
+ sb=0.265 sd=0.28 area=0.063 perim=1.14
MI642 S0 clkneg net175 VNB sky130_fd_pr__nfet_01v8 m=1 w=0.36u l=0.15u mult=1 sa=0.265
+ sb=0.265 sd=0.28 area=0.063 perim=1.14
MI654 net172 DE VGND VNB sky130_fd_pr__nfet_01v8 m=1 w=0.42u l=0.15u mult=1 sa=0.265
+ sb=0.265 sd=0.28 area=0.063 perim=1.14
MI648 db clkneg M0 VNB sky130_fd_pr__nfet_01v8 m=1 w=0.36u l=0.15u mult=1 sa=0.265
+ sb=0.265 sd=0.28 area=0.063 perim=1.14
MI646 Q S0 VGND VNB sky130_fd_pr__nfet_01v8 m=1 w=0.65u l=0.15u mult=1 sa=0.265
+ sb=0.265 sd=0.28 area=0.063 perim=1.14
MI656 net160 M1 VGND VNB sky130_fd_pr__nfet_01v8 m=1 w=0.42u l=0.15u mult=1 sa=0.265
+ sb=0.265 sd=0.28 area=0.063 perim=1.14
MI657 M0 clkpos net160 VNB sky130_fd_pr__nfet_01v8 m=1 w=0.36u l=0.15u mult=1 sa=0.265
+ sb=0.265 sd=0.28 area=0.063 perim=1.14
MI18 S1 S0 VGND VNB sky130_fd_pr__nfet_01v8 m=1 w=0.42u l=0.15u mult=1 sa=0.265
+ sb=0.265 sd=0.28 area=0.063 perim=1.14
MI16 net148 M1 VGND VNB sky130_fd_pr__nfet_01v8 m=1 w=0.42u l=0.15u mult=1 sa=0.265
+ sb=0.265 sd=0.28 area=0.063 perim=1.14
MI15 S0 clkpos net148 VNB sky130_fd_pr__nfet_01v8 m=1 w=0.36u l=0.15u mult=1 sa=0.265
+ sb=0.265 sd=0.28 area=0.063 perim=1.14
MI5 deneg DE VGND VNB sky130_fd_pr__nfet_01v8 m=1 w=0.42u l=0.15u mult=1 sa=0.265
+ sb=0.265 sd=0.28 area=0.063 perim=1.14
MI7 db D net172 VNB sky130_fd_pr__nfet_01v8 m=1 w=0.42u l=0.15u mult=1 sa=0.265
+ sb=0.265 sd=0.28 area=0.063 perim=1.14
MI11 db S1 net128 VNB sky130_fd_pr__nfet_01v8 m=1 w=0.42u l=0.15u mult=1 sa=0.265
+ sb=0.265 sd=0.28 area=0.063 perim=1.14
MI12 net128 deneg VGND VNB sky130_fd_pr__nfet_01v8 m=1 w=0.42u l=0.15u mult=1 sa=0.265
+ sb=0.265 sd=0.28 area=0.063 perim=1.14
.ENDS sky130_fd_sc_hd__edfxtp_1
* Copyright 2020 The SkyWater PDK Authors
*
* Licensed under the Apache License, Version 2.0 (the "License");
* you may not use this file except in compliance with the License.
* You may obtain a copy of the License at
*
*     https:  www.apache.org licenses LICENSE-2.0
*
* Unless required by applicable law or agreed to in writing, software
* distributed under the License is distributed on an "AS IS" BASIS,
* WITHOUT WARRANTIES OR CONDITIONS OF ANY KIND, either express or implied.
* See the License for the specific language governing permissions and
* limitations under the License.
*
* SPDX-License-Identifier: Apache-2.0

.SUBCKT sky130_fd_sc_hd__einvn_0 A TE_B VGND VNB VNB net59 Z
*.PININFO A:I TE_B:I VGND:I VNB:I VNB:I net59:I Z:O
MMN0 Z A sndA VNB sky130_fd_pr__nfet_01v8 m=1 w=0.42u l=0.15u mult=1 sa=0.265 sb=0.265
+ sd=0.28 area=0.063 perim=1.14
MMN1 sndA net25 VGND VNB sky130_fd_pr__nfet_01v8 m=1 w=0.42u l=0.15u mult=1 sa=0.265
+ sb=0.265 sd=0.28 area=0.063 perim=1.14
MMIN1 net25 TE_B VGND VNB sky130_fd_pr__nfet_01v8 m=1 w=0.42u l=0.15u mult=1 sa=0.265
+ sb=0.265 sd=0.28 area=0.063 perim=1.14
MMP0 net59 TE_B sndTEB VNB sky130_fd_pr__pfet_01v8_hvt m=1 w=0.64u l=0.15u mult=1
+ sa=0.265 sb=0.265 sd=0.28 area=0.063 perim=1.14
MMP1 sndTEB A Z VNB sky130_fd_pr__pfet_01v8_hvt m=1 w=0.64u l=0.15u mult=1 sa=0.265
+ sb=0.265 sd=0.28 area=0.063 perim=1.14
MMIP1 net25 TE_B net59 VNB sky130_fd_pr__pfet_01v8_hvt m=1 w=0.42u l=0.15u mult=1
+ sa=0.265 sb=0.265 sd=0.28 area=0.063 perim=1.14
.ENDS sky130_fd_sc_hd__einvn_0
* Copyright 2020 The SkyWater PDK Authors
*
* Licensed under the Apache License, Version 2.0 (the "License");
* you may not use this file except in compliance with the License.
* You may obtain a copy of the License at
*
*     https:  www.apache.org licenses LICENSE-2.0
*
* Unless required by applicable law or agreed to in writing, software
* distributed under the License is distributed on an "AS IS" BASIS,
* WITHOUT WARRANTIES OR CONDITIONS OF ANY KIND, either express or implied.
* See the License for the specific language governing permissions and
* limitations under the License.
*
* SPDX-License-Identifier: Apache-2.0

.SUBCKT sky130_fd_sc_hd__einvn_1 A TE_B VGND VNB VNB net59 Z
*.PININFO A:I TE_B:I VGND:I VNB:I VNB:I net59:I Z:O
MMN0 Z A sndA VNB sky130_fd_pr__nfet_01v8 m=1 w=0.65u l=0.15u mult=1 sa=0.265 sb=0.265
+ sd=0.28 area=0.063 perim=1.14
MMN1 sndA net25 VGND VNB sky130_fd_pr__nfet_01v8 m=1 w=0.65u l=0.15u mult=1 sa=0.265
+ sb=0.265 sd=0.28 area=0.063 perim=1.14
MMIN1 net25 TE_B VGND VNB sky130_fd_pr__nfet_01v8 m=1 w=0.42u l=0.15u mult=1 sa=0.265
+ sb=0.265 sd=0.28 area=0.063 perim=1.14
MMP0 net59 TE_B sndTEB VNB sky130_fd_pr__pfet_01v8_hvt m=1 w=1.0u l=0.15u mult=1
+ sa=0.265 sb=0.265 sd=0.28 area=0.063 perim=1.14
MMP1 sndTEB A Z VNB sky130_fd_pr__pfet_01v8_hvt m=1 w=1.0u l=0.15u mult=1 sa=0.265
+ sb=0.265 sd=0.28 area=0.063 perim=1.14
MMIP1 net25 TE_B net59 VNB sky130_fd_pr__pfet_01v8_hvt m=1 w=0.64u l=0.15u mult=1
+ sa=0.265 sb=0.265 sd=0.28 area=0.063 perim=1.14
.ENDS sky130_fd_sc_hd__einvn_1
* Copyright 2020 The SkyWater PDK Authors
*
* Licensed under the Apache License, Version 2.0 (the "License");
* you may not use this file except in compliance with the License.
* You may obtain a copy of the License at
*
*     https:  www.apache.org licenses LICENSE-2.0
*
* Unless required by applicable law or agreed to in writing, software
* distributed under the License is distributed on an "AS IS" BASIS,
* WITHOUT WARRANTIES OR CONDITIONS OF ANY KIND, either express or implied.
* See the License for the specific language governing permissions and
* limitations under the License.
*
* SPDX-License-Identifier: Apache-2.0

.SUBCKT sky130_fd_sc_hd__einvn_2 A TE_B VGND VNB VNB net59 Z
*.PININFO A:I TE_B:I VGND:I VNB:I VNB:I net59:I Z:O
MMN0 Z A sndA VNB sky130_fd_pr__nfet_01v8 m=2 w=0.65u l=0.15u mult=1 sa=0.265 sb=0.265
+ sd=0.28 area=0.063 perim=1.14
MMN1 sndA TE VGND VNB sky130_fd_pr__nfet_01v8 m=2 w=0.65u l=0.15u mult=1 sa=0.265
+ sb=0.265 sd=0.28 area=0.063 perim=1.14
MMIN1 TE TE_B VGND VNB sky130_fd_pr__nfet_01v8 m=1 w=0.42u l=0.15u mult=1 sa=0.265
+ sb=0.265 sd=0.28 area=0.063 perim=1.14
MMP0 net59 TE_B sndTEB VNB sky130_fd_pr__pfet_01v8_hvt m=2 w=0.94u l=0.15u mult=1
+ sa=0.265 sb=0.265 sd=0.28 area=0.063 perim=1.14
MMP1 sndTEB A Z VNB sky130_fd_pr__pfet_01v8_hvt m=2 w=1.0u l=0.15u mult=1 sa=0.265
+ sb=0.265 sd=0.28 area=0.063 perim=1.14
MMIP1 TE TE_B net59 VNB sky130_fd_pr__pfet_01v8_hvt m=1 w=0.64u l=0.15u mult=1 sa=0.265
+ sb=0.265 sd=0.28 area=0.063 perim=1.14
.ENDS sky130_fd_sc_hd__einvn_2
* Copyright 2020 The SkyWater PDK Authors
*
* Licensed under the Apache License, Version 2.0 (the "License");
* you may not use this file except in compliance with the License.
* You may obtain a copy of the License at
*
*     https:  www.apache.org licenses LICENSE-2.0
*
* Unless required by applicable law or agreed to in writing, software
* distributed under the License is distributed on an "AS IS" BASIS,
* WITHOUT WARRANTIES OR CONDITIONS OF ANY KIND, either express or implied.
* See the License for the specific language governing permissions and
* limitations under the License.
*
* SPDX-License-Identifier: Apache-2.0

.SUBCKT sky130_fd_sc_hd__einvn_4 A TE_B VGND VNB VNB net59 Z
*.PININFO A:I TE_B:I VGND:I VNB:I VNB:I net59:I Z:O
MMN0 Z A sndA VNB sky130_fd_pr__nfet_01v8 m=4 w=0.65u l=0.15u mult=1 sa=0.265 sb=0.265
+ sd=0.28 area=0.063 perim=1.14
MMN1 sndA TE VGND VNB sky130_fd_pr__nfet_01v8 m=4 w=0.65u l=0.15u mult=1 sa=0.265
+ sb=0.265 sd=0.28 area=0.063 perim=1.14
MMIN1 TE TE_B VGND VNB sky130_fd_pr__nfet_01v8 m=1 w=0.65u l=0.15u mult=1 sa=0.265
+ sb=0.265 sd=0.28 area=0.063 perim=1.14
MMP0 net59 TE_B sndTEB VNB sky130_fd_pr__pfet_01v8_hvt m=4 w=0.94u l=0.15u mult=1
+ sa=0.265 sb=0.265 sd=0.28 area=0.063 perim=1.14
MMP1 sndTEB A Z VNB sky130_fd_pr__pfet_01v8_hvt m=4 w=1.0u l=0.15u mult=1 sa=0.265
+ sb=0.265 sd=0.28 area=0.063 perim=1.14
MMIP1 TE TE_B net59 VNB sky130_fd_pr__pfet_01v8_hvt m=1 w=1.0u l=0.15u mult=1 sa=0.265
+ sb=0.265 sd=0.28 area=0.063 perim=1.14
.ENDS sky130_fd_sc_hd__einvn_4
* Copyright 2020 The SkyWater PDK Authors
*
* Licensed under the Apache License, Version 2.0 (the "License");
* you may not use this file except in compliance with the License.
* You may obtain a copy of the License at
*
*     https:  www.apache.org licenses LICENSE-2.0
*
* Unless required by applicable law or agreed to in writing, software
* distributed under the License is distributed on an "AS IS" BASIS,
* WITHOUT WARRANTIES OR CONDITIONS OF ANY KIND, either express or implied.
* See the License for the specific language governing permissions and
* limitations under the License.
*
* SPDX-License-Identifier: Apache-2.0

.SUBCKT sky130_fd_sc_hd__einvn_8 A TE_B VGND VNB VNB net59 Z
*.PININFO A:I TE_B:I VGND:I VNB:I VNB:I net59:I Z:O
MMN0 Z A sndA VNB sky130_fd_pr__nfet_01v8 m=8 w=0.65u l=0.15u mult=1 sa=0.265 sb=0.265
+ sd=0.28 area=0.063 perim=1.14
MMN1 sndA TE VGND VNB sky130_fd_pr__nfet_01v8 m=8 w=0.65u l=0.15u mult=1 sa=0.265
+ sb=0.265 sd=0.28 area=0.063 perim=1.14
MMIN1 TE TE_B VGND VNB sky130_fd_pr__nfet_01v8 m=1 w=0.65u l=0.15u mult=1 sa=0.265
+ sb=0.265 sd=0.28 area=0.063 perim=1.14
MMP0 net59 TE_B sndTEB VNB sky130_fd_pr__pfet_01v8_hvt m=8 w=0.94u l=0.15u mult=1
+ sa=0.265 sb=0.265 sd=0.28 area=0.063 perim=1.14
MMP1 sndTEB A Z VNB sky130_fd_pr__pfet_01v8_hvt m=8 w=1.0u l=0.15u mult=1 sa=0.265
+ sb=0.265 sd=0.28 area=0.063 perim=1.14
MMIP1 TE TE_B net59 VNB sky130_fd_pr__pfet_01v8_hvt m=1 w=1.0u l=0.15u mult=1 sa=0.265
+ sb=0.265 sd=0.28 area=0.063 perim=1.14
.ENDS sky130_fd_sc_hd__einvn_8
* Copyright 2020 The SkyWater PDK Authors
*
* Licensed under the Apache License, Version 2.0 (the "License");
* you may not use this file except in compliance with the License.
* You may obtain a copy of the License at
*
*     https:  www.apache.org licenses LICENSE-2.0
*
* Unless required by applicable law or agreed to in writing, software
* distributed under the License is distributed on an "AS IS" BASIS,
* WITHOUT WARRANTIES OR CONDITIONS OF ANY KIND, either express or implied.
* See the License for the specific language governing permissions and
* limitations under the License.
*
* SPDX-License-Identifier: Apache-2.0

.SUBCKT sky130_fd_sc_hd__einvp_1 A TE VGND VNB VNB net59 Z
*.PININFO A:I TE:I VGND:I VNB:I VNB:I net59:I Z:O
MMN0 Z A sndA VNB sky130_fd_pr__nfet_01v8 m=1 w=0.65u l=0.15u mult=1 sa=0.265 sb=0.265
+ sd=0.28 area=0.063 perim=1.14
MMN1 sndA TE VGND VNB sky130_fd_pr__nfet_01v8 m=1 w=0.65u l=0.15u mult=1 sa=0.265
+ sb=0.265 sd=0.28 area=0.063 perim=1.14
MMIN1 TEB TE VGND VNB sky130_fd_pr__nfet_01v8 m=1 w=0.42u l=0.15u mult=1 sa=0.265
+ sb=0.265 sd=0.28 area=0.063 perim=1.14
MMP0 net59 TEB sndTEB VNB sky130_fd_pr__pfet_01v8_hvt m=1 w=1.0u l=0.15u mult=1
+ sa=0.265 sb=0.265 sd=0.28 area=0.063 perim=1.14
MMP1 sndTEB A Z VNB sky130_fd_pr__pfet_01v8_hvt m=1 w=1.0u l=0.15u mult=1 sa=0.265
+ sb=0.265 sd=0.28 area=0.063 perim=1.14
MMIP1 TEB TE net59 VNB sky130_fd_pr__pfet_01v8_hvt m=1 w=0.42u l=0.15u mult=1 sa=0.265
+ sb=0.265 sd=0.28 area=0.063 perim=1.14
.ENDS sky130_fd_sc_hd__einvp_1
* Copyright 2020 The SkyWater PDK Authors
*
* Licensed under the Apache License, Version 2.0 (the "License");
* you may not use this file except in compliance with the License.
* You may obtain a copy of the License at
*
*     https:  www.apache.org licenses LICENSE-2.0
*
* Unless required by applicable law or agreed to in writing, software
* distributed under the License is distributed on an "AS IS" BASIS,
* WITHOUT WARRANTIES OR CONDITIONS OF ANY KIND, either express or implied.
* See the License for the specific language governing permissions and
* limitations under the License.
*
* SPDX-License-Identifier: Apache-2.0

.SUBCKT sky130_fd_sc_hd__einvp_2 A TE VGND VNB VNB net59 Z
*.PININFO A:I TE:I VGND:I VNB:I VNB:I net59:I Z:O
MMN0 Z A sndA VNB sky130_fd_pr__nfet_01v8 m=2 w=0.65u l=0.15u mult=1 sa=0.265 sb=0.265
+ sd=0.28 area=0.063 perim=1.14
MMN1 sndA TE VGND VNB sky130_fd_pr__nfet_01v8 m=2 w=0.65u l=0.15u mult=1 sa=0.265
+ sb=0.265 sd=0.28 area=0.063 perim=1.14
MMIN1 TEB TE VGND VNB sky130_fd_pr__nfet_01v8 m=1 w=0.42u l=0.15u mult=1 sa=0.265
+ sb=0.265 sd=0.28 area=0.063 perim=1.14
MMP0 net59 TEB sndTEB VNB sky130_fd_pr__pfet_01v8_hvt m=2 w=0.94u l=0.15u mult=1
+ sa=0.265 sb=0.265 sd=0.28 area=0.063 perim=1.14
MMP1 sndTEB A Z VNB sky130_fd_pr__pfet_01v8_hvt m=2 w=1.0u l=0.15u mult=1 sa=0.265
+ sb=0.265 sd=0.28 area=0.063 perim=1.14
MMIP1 TEB TE net59 VNB sky130_fd_pr__pfet_01v8_hvt m=1 w=0.64u l=0.15u mult=1 sa=0.265
+ sb=0.265 sd=0.28 area=0.063 perim=1.14
.ENDS sky130_fd_sc_hd__einvp_2
* Copyright 2020 The SkyWater PDK Authors
*
* Licensed under the Apache License, Version 2.0 (the "License");
* you may not use this file except in compliance with the License.
* You may obtain a copy of the License at
*
*     https:  www.apache.org licenses LICENSE-2.0
*
* Unless required by applicable law or agreed to in writing, software
* distributed under the License is distributed on an "AS IS" BASIS,
* WITHOUT WARRANTIES OR CONDITIONS OF ANY KIND, either express or implied.
* See the License for the specific language governing permissions and
* limitations under the License.
*
* SPDX-License-Identifier: Apache-2.0

.SUBCKT sky130_fd_sc_hd__einvp_4 A TE VGND VNB VNB net59 Z
*.PININFO A:I TE:I VGND:I VNB:I VNB:I net59:I Z:O
MMN0 Z A sndA VNB sky130_fd_pr__nfet_01v8 m=4 w=0.65u l=0.15u mult=1 sa=0.265 sb=0.265
+ sd=0.28 area=0.063 perim=1.14
MMN1 sndA TE VGND VNB sky130_fd_pr__nfet_01v8 m=4 w=0.65u l=0.15u mult=1 sa=0.265
+ sb=0.265 sd=0.28 area=0.063 perim=1.14
MMIN1 TEB TE VGND VNB sky130_fd_pr__nfet_01v8 m=1 w=0.65u l=0.15u mult=1 sa=0.265
+ sb=0.265 sd=0.28 area=0.063 perim=1.14
MMP0 net59 TEB sndTEB VNB sky130_fd_pr__pfet_01v8_hvt m=4 w=0.94u l=0.15u mult=1
+ sa=0.265 sb=0.265 sd=0.28 area=0.063 perim=1.14
MMP1 sndTEB A Z VNB sky130_fd_pr__pfet_01v8_hvt m=4 w=1.0u l=0.15u mult=1 sa=0.265
+ sb=0.265 sd=0.28 area=0.063 perim=1.14
MMIP1 TEB TE net59 VNB sky130_fd_pr__pfet_01v8_hvt m=1 w=1.0u l=0.15u mult=1 sa=0.265
+ sb=0.265 sd=0.28 area=0.063 perim=1.14
.ENDS sky130_fd_sc_hd__einvp_4
* Copyright 2020 The SkyWater PDK Authors
*
* Licensed under the Apache License, Version 2.0 (the "License");
* you may not use this file except in compliance with the License.
* You may obtain a copy of the License at
*
*     https:  www.apache.org licenses LICENSE-2.0
*
* Unless required by applicable law or agreed to in writing, software
* distributed under the License is distributed on an "AS IS" BASIS,
* WITHOUT WARRANTIES OR CONDITIONS OF ANY KIND, either express or implied.
* See the License for the specific language governing permissions and
* limitations under the License.
*
* SPDX-License-Identifier: Apache-2.0

.SUBCKT sky130_fd_sc_hd__einvp_8 A TE VGND VNB VNB net59 Z
*.PININFO A:I TE:I VGND:I VNB:I VNB:I net59:I Z:O
MMN0 Z A sndA VNB sky130_fd_pr__nfet_01v8 m=8 w=0.65u l=0.15u mult=1 sa=0.265 sb=0.265
+ sd=0.28 area=0.063 perim=1.14
MMN1 sndA TE VGND VNB sky130_fd_pr__nfet_01v8 m=8 w=0.65u l=0.15u mult=1 sa=0.265
+ sb=0.265 sd=0.28 area=0.063 perim=1.14
MMIN1 TEB TE VGND VNB sky130_fd_pr__nfet_01v8 m=1 w=0.65u l=0.15u mult=1 sa=0.265
+ sb=0.265 sd=0.28 area=0.063 perim=1.14
MMP0 net59 TEB sndTEB VNB sky130_fd_pr__pfet_01v8_hvt m=8 w=0.94u l=0.15u mult=1
+ sa=0.265 sb=0.265 sd=0.28 area=0.063 perim=1.14
MMP1 sndTEB A Z VNB sky130_fd_pr__pfet_01v8_hvt m=8 w=1.0u l=0.15u mult=1 sa=0.265
+ sb=0.265 sd=0.28 area=0.063 perim=1.14
MMIP1 TEB TE net59 VNB sky130_fd_pr__pfet_01v8_hvt m=1 w=1.0u l=0.15u mult=1 sa=0.265
+ sb=0.265 sd=0.28 area=0.063 perim=1.14
.ENDS sky130_fd_sc_hd__einvp_8
* Copyright 2020 The SkyWater PDK Authors
*
* Licensed under the Apache License, Version 2.0 (the "License");
* you may not use this file except in compliance with the License.
* You may obtain a copy of the License at
*
*     https:  www.apache.org licenses LICENSE-2.0
*
* Unless required by applicable law or agreed to in writing, software
* distributed under the License is distributed on an "AS IS" BASIS,
* WITHOUT WARRANTIES OR CONDITIONS OF ANY KIND, either express or implied.
* See the License for the specific language governing permissions and
* limitations under the License.
*
* SPDX-License-Identifier: Apache-2.0

.SUBCKT sky130_fd_sc_hd__fa_1 A B CIN VGND VNB VNB net59 COUT SUM
*.PININFO A:I B:I CIN:I VGND:I VNB:I VNB:I net59:I COUT:O SUM:O
MMNs1s nint1 majb sumb VNB sky130_fd_pr__nfet_01v8 m=1 w=0.42u l=0.15u mult=1 sa=0.265
+ sb=0.265 sd=0.28 area=0.063 perim=1.14
MMIN2 COUT majb VGND VNB sky130_fd_pr__nfet_01v8 m=1 w=0.65u l=0.15u mult=1 sa=0.265
+ sb=0.265 sd=0.28 area=0.063 perim=1.14
MMIN3 SUM sumb VGND VNB sky130_fd_pr__nfet_01v8 m=1 w=0.65u l=0.15u mult=1 sa=0.265
+ sb=0.265 sd=0.28 area=0.063 perim=1.14
MMNmaj10 majb B sndNAp1 VNB sky130_fd_pr__nfet_01v8 m=1 w=0.42u l=0.15u mult=1
+ sa=0.265 sb=0.265 sd=0.28 area=0.063 perim=1.14
MMNmaj11 sndNAp1 A VGND VNB sky130_fd_pr__nfet_01v8 m=1 w=0.42u l=0.15u mult=1
+ sa=0.265 sb=0.265 sd=0.28 area=0.063 perim=1.14
MMNmaj30 majb CIN sndNCINn3 VNB sky130_fd_pr__nfet_01v8 m=1 w=0.42u l=0.15u mult=1
+ sa=0.265 sb=0.265 sd=0.28 area=0.063 perim=1.14
MMNmaj31 sndNCINn3 B VGND VNB sky130_fd_pr__nfet_01v8 m=1 w=0.42u l=0.15u mult=1
+ sa=0.265 sb=0.265 sd=0.28 area=0.063 perim=1.14
MMNmaj20 VGND A sndNCINn3 VNB sky130_fd_pr__nfet_01v8 m=1 w=0.42u l=0.15u mult=1
+ sa=0.265 sb=0.265 sd=0.28 area=0.063 perim=1.14
MMNs2s0 VGND A sndNAn4 VNB sky130_fd_pr__nfet_01v8 m=1 w=0.42u l=0.15u mult=1 sa=0.265
+ sb=0.265 sd=0.28 area=0.063 perim=1.14
MMNs2s1 sndNAn4 B sndNBn4 VNB sky130_fd_pr__nfet_01v8 m=1 w=0.42u l=0.15u mult=1
+ sa=0.265 sb=0.265 sd=0.28 area=0.063 perim=1.14
MMNs2s2 sndNBn4 CIN sumb VNB sky130_fd_pr__nfet_01v8 m=1 w=0.42u l=0.15u mult=1
+ sa=0.265 sb=0.265 sd=0.28 area=0.063 perim=1.14
MMNs3s0 nint1 B VGND VNB sky130_fd_pr__nfet_01v8 m=1 w=0.42u l=0.15u mult=1 sa=0.265
+ sb=0.265 sd=0.28 area=0.063 perim=1.14
MMNs3s1 nint1 A VGND VNB sky130_fd_pr__nfet_01v8 m=1 w=0.42u l=0.15u mult=1 sa=0.265
+ sb=0.265 sd=0.28 area=0.063 perim=1.14
MMNs3s2 nint1 CIN VGND VNB sky130_fd_pr__nfet_01v8 m=1 w=0.42u l=0.15u mult=1 sa=0.265
+ sb=0.265 sd=0.28 area=0.063 perim=1.14
MMIP2 COUT majb net59 VNB sky130_fd_pr__pfet_01v8_hvt m=1 w=1.0u l=0.15u mult=1
+ sa=0.265 sb=0.265 sd=0.28 area=0.063 perim=1.14
MMIP3 SUM sumb net59 VNB sky130_fd_pr__pfet_01v8_hvt m=1 w=1.0u l=0.15u mult=1 sa=0.265
+ sb=0.265 sd=0.28 area=0.063 perim=1.14
MMPmaj10 net59 A sndPAp1 VNB sky130_fd_pr__pfet_01v8_hvt m=1 w=0.42u l=0.15u mult=1
+ sa=0.265 sb=0.265 sd=0.28 area=0.063 perim=1.14
MMPmaj11 sndPAp1 B majb VNB sky130_fd_pr__pfet_01v8_hvt m=1 w=0.42u l=0.15u mult=1
+ sa=0.265 sb=0.265 sd=0.28 area=0.063 perim=1.14
MMPmaj20 net59 A sndPCINp3 VNB sky130_fd_pr__pfet_01v8_hvt m=1 w=0.42u l=0.15u mult=1
+ sa=0.265 sb=0.265 sd=0.28 area=0.063 perim=1.14
MMPmaj21 sndPCINp3 CIN majb VNB sky130_fd_pr__pfet_01v8_hvt m=1 w=0.42u l=0.15u mult=1
+ sa=0.265 sb=0.265 sd=0.28 area=0.063 perim=1.14
MMPmaj31 sndPCINp3 B net59 VNB sky130_fd_pr__pfet_01v8_hvt m=1 w=0.42u l=0.15u mult=1
+ sa=0.265 sb=0.265 sd=0.28 area=0.063 perim=1.14
MMPs2s0 net59 A sndPAp4 VNB sky130_fd_pr__pfet_01v8_hvt m=1 w=0.42u l=0.15u mult=1
+ sa=0.265 sb=0.265 sd=0.28 area=0.063 perim=1.14
MMPs2s1 sndPAp4 B sndPBp4 VNB sky130_fd_pr__pfet_01v8_hvt m=1 w=0.42u l=0.15u mult=1
+ sa=0.265 sb=0.265 sd=0.28 area=0.063 perim=1.14
MMPs2s2 sndPBp4 CIN sumb VNB sky130_fd_pr__pfet_01v8_hvt m=1 w=0.42u l=0.15u mult=1
+ sa=0.265 sb=0.265 sd=0.28 area=0.063 perim=1.14
MMPs3s0 pint1 B net59 VNB sky130_fd_pr__pfet_01v8_hvt m=1 w=0.42u l=0.15u mult=1
+ sa=0.265 sb=0.265 sd=0.28 area=0.063 perim=1.14
MMPs3s1 pint1 A net59 VNB sky130_fd_pr__pfet_01v8_hvt m=1 w=0.42u l=0.15u mult=1
+ sa=0.265 sb=0.265 sd=0.28 area=0.063 perim=1.14
MMPs3s2 pint1 CIN net59 VNB sky130_fd_pr__pfet_01v8_hvt m=1 w=0.42u l=0.15u mult=1
+ sa=0.265 sb=0.265 sd=0.28 area=0.063 perim=1.14
MMPs1s pint1 majb sumb VNB sky130_fd_pr__pfet_01v8_hvt m=1 w=0.42u l=0.15u mult=1
+ sa=0.265 sb=0.265 sd=0.28 area=0.063 perim=1.14
.ENDS sky130_fd_sc_hd__fa_1
* Copyright 2020 The SkyWater PDK Authors
*
* Licensed under the Apache License, Version 2.0 (the "License");
* you may not use this file except in compliance with the License.
* You may obtain a copy of the License at
*
*     https:  www.apache.org licenses LICENSE-2.0
*
* Unless required by applicable law or agreed to in writing, software
* distributed under the License is distributed on an "AS IS" BASIS,
* WITHOUT WARRANTIES OR CONDITIONS OF ANY KIND, either express or implied.
* See the License for the specific language governing permissions and
* limitations under the License.
*
* SPDX-License-Identifier: Apache-2.0

.SUBCKT sky130_fd_sc_hd__fa_2 A B CIN VGND VNB VNB net59 COUT SUM
*.PININFO A:I B:I CIN:I VGND:I VNB:I VNB:I net59:I COUT:O SUM:O
MMNs1s nint1 majb sumb VNB sky130_fd_pr__nfet_01v8 m=1 w=0.42u l=0.15u mult=1 sa=0.265
+ sb=0.265 sd=0.28 area=0.063 perim=1.14
MMIN2 COUT majb VGND VNB sky130_fd_pr__nfet_01v8 m=2 w=0.65u l=0.15u mult=1 sa=0.265
+ sb=0.265 sd=0.28 area=0.063 perim=1.14
MMIN3 SUM sumb VGND VNB sky130_fd_pr__nfet_01v8 m=2 w=0.65u l=0.15u mult=1 sa=0.265
+ sb=0.265 sd=0.28 area=0.063 perim=1.14
MMNmaj10 majb B sndNAp1 VNB sky130_fd_pr__nfet_01v8 m=1 w=0.42u l=0.15u mult=1
+ sa=0.265 sb=0.265 sd=0.28 area=0.063 perim=1.14
MMNmaj11 sndNAp1 A VGND VNB sky130_fd_pr__nfet_01v8 m=1 w=0.42u l=0.15u mult=1
+ sa=0.265 sb=0.265 sd=0.28 area=0.063 perim=1.14
MMNmaj30 majb CIN nmajmid VNB sky130_fd_pr__nfet_01v8 m=1 w=0.42u l=0.15u mult=1
+ sa=0.265 sb=0.265 sd=0.28 area=0.063 perim=1.14
MMNmaj21 nmajmid A VGND VNB sky130_fd_pr__nfet_01v8 m=1 w=0.42u l=0.15u mult=1
+ sa=0.265 sb=0.265 sd=0.28 area=0.063 perim=1.14
MMNmaj20 VGND B nmajmid VNB sky130_fd_pr__nfet_01v8 m=1 w=0.42u l=0.15u mult=1
+ sa=0.265 sb=0.265 sd=0.28 area=0.063 perim=1.14
MMNs2s0 VGND A sndNAn4 VNB sky130_fd_pr__nfet_01v8 m=1 w=0.42u l=0.15u mult=1 sa=0.265
+ sb=0.265 sd=0.28 area=0.063 perim=1.14
MMNs2s1 sndNAn4 B sndNBn4 VNB sky130_fd_pr__nfet_01v8 m=1 w=0.42u l=0.15u mult=1
+ sa=0.265 sb=0.265 sd=0.28 area=0.063 perim=1.14
MMNs2s2 sndNBn4 CIN sumb VNB sky130_fd_pr__nfet_01v8 m=1 w=0.42u l=0.15u mult=1
+ sa=0.265 sb=0.265 sd=0.28 area=0.063 perim=1.14
MMNs3s0 nint1 A VGND VNB sky130_fd_pr__nfet_01v8 m=1 w=0.42u l=0.15u mult=1 sa=0.265
+ sb=0.265 sd=0.28 area=0.063 perim=1.14
MMNs3s1 nint1 B VGND VNB sky130_fd_pr__nfet_01v8 m=1 w=0.42u l=0.15u mult=1 sa=0.265
+ sb=0.265 sd=0.28 area=0.063 perim=1.14
MMNs3s2 nint1 CIN VGND VNB sky130_fd_pr__nfet_01v8 m=1 w=0.42u l=0.15u mult=1 sa=0.265
+ sb=0.265 sd=0.28 area=0.063 perim=1.14
MMIP2 COUT majb net59 VNB sky130_fd_pr__pfet_01v8_hvt m=2 w=1.0u l=0.15u mult=1
+ sa=0.265 sb=0.265 sd=0.28 area=0.063 perim=1.14
MMIP3 SUM sumb net59 VNB sky130_fd_pr__pfet_01v8_hvt m=2 w=1.0u l=0.15u mult=1 sa=0.265
+ sb=0.265 sd=0.28 area=0.063 perim=1.14
MMPmaj10 net59 A sndPAp1 VNB sky130_fd_pr__pfet_01v8_hvt m=1 w=0.63u l=0.15u mult=1
+ sa=0.265 sb=0.265 sd=0.28 area=0.063 perim=1.14
MMPmaj11 sndPAp1 B majb VNB sky130_fd_pr__pfet_01v8_hvt m=1 w=0.63u l=0.15u mult=1
+ sa=0.265 sb=0.265 sd=0.28 area=0.063 perim=1.14
MMPmaj20 net59 B pmajmid VNB sky130_fd_pr__pfet_01v8_hvt m=1 w=0.63u l=0.15u mult=1
+ sa=0.265 sb=0.265 sd=0.28 area=0.063 perim=1.14
MMPmaj30 pmajmid CIN majb VNB sky130_fd_pr__pfet_01v8_hvt m=1 w=0.63u l=0.15u mult=1
+ sa=0.265 sb=0.265 sd=0.28 area=0.063 perim=1.14
MMPmaj21 pmajmid A net59 VNB sky130_fd_pr__pfet_01v8_hvt m=1 w=0.63u l=0.15u mult=1
+ sa=0.265 sb=0.265 sd=0.28 area=0.063 perim=1.14
MMPs2s0 net59 A sndPAp4 VNB sky130_fd_pr__pfet_01v8_hvt m=1 w=0.63u l=0.15u mult=1
+ sa=0.265 sb=0.265 sd=0.28 area=0.063 perim=1.14
MMPs2s1 sndPAp4 B sndPBp4 VNB sky130_fd_pr__pfet_01v8_hvt m=1 w=0.63u l=0.15u mult=1
+ sa=0.265 sb=0.265 sd=0.28 area=0.063 perim=1.14
MMPs2s2 sndPBp4 CIN sumb VNB sky130_fd_pr__pfet_01v8_hvt m=1 w=0.64u l=0.15u mult=1
+ sa=0.265 sb=0.265 sd=0.28 area=0.063 perim=1.14
MMPs3s0 pint1 A net59 VNB sky130_fd_pr__pfet_01v8_hvt m=1 w=0.64u l=0.15u mult=1
+ sa=0.265 sb=0.265 sd=0.28 area=0.063 perim=1.14
MMPs3s1 pint1 B net59 VNB sky130_fd_pr__pfet_01v8_hvt m=1 w=0.64u l=0.15u mult=1
+ sa=0.265 sb=0.265 sd=0.28 area=0.063 perim=1.14
MMPs3s2 pint1 CIN net59 VNB sky130_fd_pr__pfet_01v8_hvt m=1 w=0.64u l=0.15u mult=1
+ sa=0.265 sb=0.265 sd=0.28 area=0.063 perim=1.14
MMPs1s pint1 majb sumb VNB sky130_fd_pr__pfet_01v8_hvt m=1 w=0.64u l=0.15u mult=1
+ sa=0.265 sb=0.265 sd=0.28 area=0.063 perim=1.14
.ENDS sky130_fd_sc_hd__fa_2
* Copyright 2020 The SkyWater PDK Authors
*
* Licensed under the Apache License, Version 2.0 (the "License");
* you may not use this file except in compliance with the License.
* You may obtain a copy of the License at
*
*     https:  www.apache.org licenses LICENSE-2.0
*
* Unless required by applicable law or agreed to in writing, software
* distributed under the License is distributed on an "AS IS" BASIS,
* WITHOUT WARRANTIES OR CONDITIONS OF ANY KIND, either express or implied.
* See the License for the specific language governing permissions and
* limitations under the License.
*
* SPDX-License-Identifier: Apache-2.0

.SUBCKT sky130_fd_sc_hd__fa_4 A B CIN VGND VNB VNB net59 COUT SUM
*.PININFO A:I B:I CIN:I VGND:I VNB:I VNB:I net59:I COUT:O SUM:O
MMNs1s nint1 majb sumb VNB sky130_fd_pr__nfet_01v8 m=1 w=0.42u l=0.15u mult=1 sa=0.265
+ sb=0.265 sd=0.28 area=0.063 perim=1.14
MMIN2 COUT majb VGND VNB sky130_fd_pr__nfet_01v8 m=4 w=0.65u l=0.15u mult=1 sa=0.265
+ sb=0.265 sd=0.28 area=0.063 perim=1.14
MMIN3 SUM sumb VGND VNB sky130_fd_pr__nfet_01v8 m=4 w=0.65u l=0.15u mult=1 sa=0.265
+ sb=0.265 sd=0.28 area=0.063 perim=1.14
MMNmaj10 majb B sndNAp1 VNB sky130_fd_pr__nfet_01v8 m=1 w=0.42u l=0.15u mult=1
+ sa=0.265 sb=0.265 sd=0.28 area=0.063 perim=1.14
MMNmaj11 sndNAp1 A VGND VNB sky130_fd_pr__nfet_01v8 m=1 w=0.42u l=0.15u mult=1
+ sa=0.265 sb=0.265 sd=0.28 area=0.063 perim=1.14
MMNmaj30 majb CIN nmajmid VNB sky130_fd_pr__nfet_01v8 m=1 w=0.42u l=0.15u mult=1
+ sa=0.265 sb=0.265 sd=0.28 area=0.063 perim=1.14
MMNmaj21 nmajmid A VGND VNB sky130_fd_pr__nfet_01v8 m=1 w=0.42u l=0.15u mult=1
+ sa=0.265 sb=0.265 sd=0.28 area=0.063 perim=1.14
MMNmaj20 VGND B nmajmid VNB sky130_fd_pr__nfet_01v8 m=1 w=0.42u l=0.15u mult=1
+ sa=0.265 sb=0.265 sd=0.28 area=0.063 perim=1.14
MMNs2s0 VGND A sndNAn4 VNB sky130_fd_pr__nfet_01v8 m=1 w=0.42u l=0.15u mult=1 sa=0.265
+ sb=0.265 sd=0.28 area=0.063 perim=1.14
MMNs2s1 sndNAn4 B sndNBn4 VNB sky130_fd_pr__nfet_01v8 m=1 w=0.42u l=0.15u mult=1
+ sa=0.265 sb=0.265 sd=0.28 area=0.063 perim=1.14
MMNs2s2 sndNBn4 CIN sumb VNB sky130_fd_pr__nfet_01v8 m=1 w=0.42u l=0.15u mult=1
+ sa=0.265 sb=0.265 sd=0.28 area=0.063 perim=1.14
MMNs3s0 nint1 A VGND VNB sky130_fd_pr__nfet_01v8 m=1 w=0.42u l=0.15u mult=1 sa=0.265
+ sb=0.265 sd=0.28 area=0.063 perim=1.14
MMNs3s1 nint1 B VGND VNB sky130_fd_pr__nfet_01v8 m=1 w=0.42u l=0.15u mult=1 sa=0.265
+ sb=0.265 sd=0.28 area=0.063 perim=1.14
MMNs3s2 nint1 CIN VGND VNB sky130_fd_pr__nfet_01v8 m=1 w=0.42u l=0.15u mult=1 sa=0.265
+ sb=0.265 sd=0.28 area=0.063 perim=1.14
MMIP2 COUT majb net59 VNB sky130_fd_pr__pfet_01v8_hvt m=4 w=1.0u l=0.15u mult=1
+ sa=0.265 sb=0.265 sd=0.28 area=0.063 perim=1.14
MMIP3 SUM sumb net59 VNB sky130_fd_pr__pfet_01v8_hvt m=4 w=1.0u l=0.15u mult=1 sa=0.265
+ sb=0.265 sd=0.28 area=0.063 perim=1.14
MMPmaj10 net59 A sndPAp1 VNB sky130_fd_pr__pfet_01v8_hvt m=1 w=0.63u l=0.15u mult=1
+ sa=0.265 sb=0.265 sd=0.28 area=0.063 perim=1.14
MMPmaj11 sndPAp1 B majb VNB sky130_fd_pr__pfet_01v8_hvt m=1 w=0.63u l=0.15u mult=1
+ sa=0.265 sb=0.265 sd=0.28 area=0.063 perim=1.14
MMPmaj20 net59 B pmajmid VNB sky130_fd_pr__pfet_01v8_hvt m=1 w=0.64u l=0.15u mult=1
+ sa=0.265 sb=0.265 sd=0.28 area=0.063 perim=1.14
MMPmaj30 pmajmid CIN majb VNB sky130_fd_pr__pfet_01v8_hvt m=1 w=0.64u l=0.15u mult=1
+ sa=0.265 sb=0.265 sd=0.28 area=0.063 perim=1.14
MMPmaj21 pmajmid A net59 VNB sky130_fd_pr__pfet_01v8_hvt m=1 w=0.64u l=0.15u mult=1
+ sa=0.265 sb=0.265 sd=0.28 area=0.063 perim=1.14
MMPs2s0 net59 A sndPAp4 VNB sky130_fd_pr__pfet_01v8_hvt m=1 w=0.63u l=0.15u mult=1
+ sa=0.265 sb=0.265 sd=0.28 area=0.063 perim=1.14
MMPs2s1 sndPAp4 B sndPBp4 VNB sky130_fd_pr__pfet_01v8_hvt m=1 w=0.63u l=0.15u mult=1
+ sa=0.265 sb=0.265 sd=0.28 area=0.063 perim=1.14
MMPs2s2 sndPBp4 CIN sumb VNB sky130_fd_pr__pfet_01v8_hvt m=1 w=0.64u l=0.15u mult=1
+ sa=0.265 sb=0.265 sd=0.28 area=0.063 perim=1.14
MMPs3s0 pint1 A net59 VNB sky130_fd_pr__pfet_01v8_hvt m=1 w=0.64u l=0.15u mult=1
+ sa=0.265 sb=0.265 sd=0.28 area=0.063 perim=1.14
MMPs3s1 pint1 B net59 VNB sky130_fd_pr__pfet_01v8_hvt m=1 w=0.64u l=0.15u mult=1
+ sa=0.265 sb=0.265 sd=0.28 area=0.063 perim=1.14
MMPs3s2 pint1 CIN net59 VNB sky130_fd_pr__pfet_01v8_hvt m=1 w=0.64u l=0.15u mult=1
+ sa=0.265 sb=0.265 sd=0.28 area=0.063 perim=1.14
MMPs1s pint1 majb sumb VNB sky130_fd_pr__pfet_01v8_hvt m=1 w=0.64u l=0.15u mult=1
+ sa=0.265 sb=0.265 sd=0.28 area=0.063 perim=1.14
.ENDS sky130_fd_sc_hd__fa_4
* Copyright 2020 The SkyWater PDK Authors
*
* Licensed under the Apache License, Version 2.0 (the "License");
* you may not use this file except in compliance with the License.
* You may obtain a copy of the License at
*
*     https:  www.apache.org licenses LICENSE-2.0
*
* Unless required by applicable law or agreed to in writing, software
* distributed under the License is distributed on an "AS IS" BASIS,
* WITHOUT WARRANTIES OR CONDITIONS OF ANY KIND, either express or implied.
* See the License for the specific language governing permissions and
* limitations under the License.
*
* SPDX-License-Identifier: Apache-2.0

.SUBCKT sky130_fd_sc_hd__fah_1 A B CI VGND VNB VNB net59 COUT SUM
*.PININFO A:I B:I CI:I VGND:I VNB:I VNB:I net59:I COUT:O SUM:O
MMIN2 COUT net195 VGND VNB sky130_fd_pr__nfet_01v8 m=1 w=0.65u l=0.15u mult=1 sa=0.265
+ sb=0.265 sd=0.28 area=0.063 perim=1.14
MMIN3 SUM net123 VGND VNB sky130_fd_pr__nfet_01v8 m=1 w=0.65u l=0.15u mult=1 sa=0.265
+ sb=0.265 sd=0.28 area=0.063 perim=1.14
MI6 CIb mid2 net195 VNB sky130_fd_pr__nfet_01v8 m=1 w=0.64u l=0.15u mult=1 sa=0.265
+ sb=0.265 sd=0.28 area=0.063 perim=1.14
MI5 Bb mid1 net195 VNB sky130_fd_pr__nfet_01v8 m=1 w=0.64u l=0.15u mult=1 sa=0.265
+ sb=0.265 sd=0.28 area=0.063 perim=1.14
MI2 CIbb mid2 net123 VNB sky130_fd_pr__nfet_01v8 m=1 w=0.64u l=0.15u mult=1 sa=0.265
+ sb=0.265 sd=0.28 area=0.063 perim=1.14
MI649 CIb mid1 net123 VNB sky130_fd_pr__nfet_01v8 m=1 w=0.64u l=0.15u mult=1 sa=0.265
+ sb=0.265 sd=0.28 area=0.063 perim=1.14
MI17 Bb B VGND VNB sky130_fd_pr__nfet_01v8 m=1 w=0.65u l=0.15u mult=1 sa=0.265
+ sb=0.265 sd=0.28 area=0.063 perim=1.14
MI46 CIbb CIb VGND VNB sky130_fd_pr__nfet_01v8 m=1 w=0.64u l=0.15u mult=1 sa=0.265
+ sb=0.265 sd=0.28 area=0.063 perim=1.14
MI44 CIb CI VGND VNB sky130_fd_pr__nfet_01v8 m=1 w=0.64u l=0.15u mult=1 sa=0.265
+ sb=0.265 sd=0.28 area=0.063 perim=1.14
MI8 Ab2 A VGND VNB sky130_fd_pr__nfet_01v8 m=1 w=0.64u l=0.15u mult=1 sa=0.265
+ sb=0.265 sd=0.28 area=0.063 perim=1.14
MI9 Abb2 Ab2 VGND VNB sky130_fd_pr__nfet_01v8 m=1 w=0.65u l=0.15u mult=1 sa=0.265
+ sb=0.265 sd=0.28 area=0.063 perim=1.14
MI14 Ab1 A VGND VNB sky130_fd_pr__nfet_01v8 m=1 w=0.64u l=0.15u mult=1 sa=0.265
+ sb=0.265 sd=0.28 area=0.063 perim=1.14
MI20 Abb2 B mid1 VNB sky130_fd_pr__nfet_01v8 m=1 w=0.64u l=0.15u mult=1 sa=0.265
+ sb=0.265 sd=0.28 area=0.063 perim=1.14
MI21 Ab1 Bb mid1 VNB sky130_fd_pr__nfet_01v8 m=1 w=0.64u l=0.15u mult=1 sa=0.265
+ sb=0.265 sd=0.28 area=0.063 perim=1.14
MI24 Abb2 Bb mid2 VNB sky130_fd_pr__nfet_01v8 m=1 w=0.64u l=0.15u mult=1 sa=0.265
+ sb=0.265 sd=0.28 area=0.063 perim=1.14
MI25 Ab1 B mid2 VNB sky130_fd_pr__nfet_01v8 m=1 w=0.64u l=0.15u mult=1 sa=0.265
+ sb=0.265 sd=0.28 area=0.063 perim=1.14
MMIP2 COUT net195 net59 VNB sky130_fd_pr__pfet_01v8_hvt m=1 w=1.0u l=0.15u mult=1
+ sa=0.265 sb=0.265 sd=0.28 area=0.063 perim=1.14
MMIP3 SUM net123 net59 VNB sky130_fd_pr__pfet_01v8_hvt m=1 w=1.0u l=0.15u mult=1
+ sa=0.265 sb=0.265 sd=0.28 area=0.063 perim=1.14
MI4 CIb mid1 net195 VNB sky130_fd_pr__pfet_01v8_hvt m=1 w=0.84u l=0.15u mult=1
+ sa=0.265 sb=0.265 sd=0.28 area=0.063 perim=1.14
MI3 Bb mid2 net195 VNB sky130_fd_pr__pfet_01v8_hvt m=1 w=0.84u l=0.15u mult=1 sa=0.265
+ sb=0.265 sd=0.28 area=0.063 perim=1.14
MI1 CIbb mid1 net123 VNB sky130_fd_pr__pfet_01v8_hvt m=1 w=0.84u l=0.15u mult=1
+ sa=0.265 sb=0.265 sd=0.28 area=0.063 perim=1.14
MI650 CIb mid2 net123 VNB sky130_fd_pr__pfet_01v8_hvt m=1 w=0.84u l=0.15u mult=1
+ sa=0.265 sb=0.265 sd=0.28 area=0.063 perim=1.14
MI16 Bb B net59 VNB sky130_fd_pr__pfet_01v8_hvt m=1 w=1.0u l=0.15u mult=1 sa=0.265
+ sb=0.265 sd=0.28 area=0.063 perim=1.14
MI47 CIbb CIb net59 VNB sky130_fd_pr__pfet_01v8_hvt m=1 w=1.0u l=0.15u mult=1 sa=0.265
+ sb=0.265 sd=0.28 area=0.063 perim=1.14
MI45 CIb CI net59 VNB sky130_fd_pr__pfet_01v8_hvt m=1 w=1.0u l=0.15u mult=1 sa=0.265
+ sb=0.265 sd=0.28 area=0.063 perim=1.14
MI12 Ab2 A net59 VNB sky130_fd_pr__pfet_01v8_hvt m=1 w=1.0u l=0.15u mult=1 sa=0.265
+ sb=0.265 sd=0.28 area=0.063 perim=1.14
MI13 Abb2 Ab2 net59 VNB sky130_fd_pr__pfet_01v8_hvt m=1 w=1.0u l=0.15u mult=1 sa=0.265
+ sb=0.265 sd=0.28 area=0.063 perim=1.14
MI19 Ab1 A net59 VNB sky130_fd_pr__pfet_01v8_hvt m=1 w=1.0u l=0.15u mult=1 sa=0.265
+ sb=0.265 sd=0.28 area=0.063 perim=1.14
MI22 Abb2 Bb mid1 VNB sky130_fd_pr__pfet_01v8_hvt m=1 w=0.84u l=0.15u mult=1 sa=0.265
+ sb=0.265 sd=0.28 area=0.063 perim=1.14
MI23 Ab1 B mid1 VNB sky130_fd_pr__pfet_01v8_hvt m=1 w=0.84u l=0.15u mult=1 sa=0.265
+ sb=0.265 sd=0.28 area=0.063 perim=1.14
MI26 Abb2 B mid2 VNB sky130_fd_pr__pfet_01v8_hvt m=1 w=0.84u l=0.15u mult=1 sa=0.265
+ sb=0.265 sd=0.28 area=0.063 perim=1.14
MI27 Ab1 Bb mid2 VNB sky130_fd_pr__pfet_01v8_hvt m=1 w=0.84u l=0.15u mult=1 sa=0.265
+ sb=0.265 sd=0.28 area=0.063 perim=1.14
.ENDS sky130_fd_sc_hd__fah_1
* Copyright 2020 The SkyWater PDK Authors
*
* Licensed under the Apache License, Version 2.0 (the "License");
* you may not use this file except in compliance with the License.
* You may obtain a copy of the License at
*
*     https:  www.apache.org licenses LICENSE-2.0
*
* Unless required by applicable law or agreed to in writing, software
* distributed under the License is distributed on an "AS IS" BASIS,
* WITHOUT WARRANTIES OR CONDITIONS OF ANY KIND, either express or implied.
* See the License for the specific language governing permissions and
* limitations under the License.
*
* SPDX-License-Identifier: Apache-2.0

.SUBCKT sky130_fd_sc_hd__fahcin_1 A B CIN VGND VNB VNB net59 COUT SUM
*.PININFO A:I B:I CIN:I VGND:I VNB:I VNB:I net59:I COUT:O SUM:O
MMIP3 SUM net144 net59 VNB sky130_fd_pr__pfet_01v8_hvt m=1 w=1.0u l=0.15u mult=1
+ sa=0.265 sb=0.265 sd=0.28 area=0.063 perim=1.14
MI32 Bbb Bb net59 VNB sky130_fd_pr__pfet_01v8_hvt m=1 w=1.0u l=0.15u mult=1 sa=0.265
+ sb=0.265 sd=0.28 area=0.063 perim=1.14
MI27 Ab Bb mid2 VNB sky130_fd_pr__pfet_01v8_hvt m=1 w=0.84u l=0.15u mult=1 sa=0.265
+ sb=0.265 sd=0.28 area=0.063 perim=1.14
MI26 Abb B mid2 VNB sky130_fd_pr__pfet_01v8_hvt m=1 w=0.84u l=0.15u mult=1 sa=0.265
+ sb=0.265 sd=0.28 area=0.063 perim=1.14
MI22 Abb Bb mid1 VNB sky130_fd_pr__pfet_01v8_hvt m=1 w=0.84u l=0.15u mult=1 sa=0.265
+ sb=0.265 sd=0.28 area=0.063 perim=1.14
MI23 Ab B mid1 VNB sky130_fd_pr__pfet_01v8_hvt m=1 w=0.84u l=0.15u mult=1 sa=0.265
+ sb=0.265 sd=0.28 area=0.063 perim=1.14
MI19 CINb1 CIN net59 VNB sky130_fd_pr__pfet_01v8_hvt m=1 w=1.0u l=0.15u mult=1 sa=0.265
+ sb=0.265 sd=0.28 area=0.063 perim=1.14
MI13 CINbb2 CINb2 net59 VNB sky130_fd_pr__pfet_01v8_hvt m=1 w=1.0u l=0.15u mult=1
+ sa=0.265 sb=0.265 sd=0.28 area=0.063 perim=1.14
MI47 Abb Ab net59 VNB sky130_fd_pr__pfet_01v8_hvt m=1 w=1.0u l=0.15u mult=1 sa=0.265
+ sb=0.265 sd=0.28 area=0.063 perim=1.14
MI12 CINb2 CIN net59 VNB sky130_fd_pr__pfet_01v8_hvt m=1 w=1.0u l=0.15u mult=1 sa=0.265
+ sb=0.265 sd=0.28 area=0.063 perim=1.14
MI16 Bb B net59 VNB sky130_fd_pr__pfet_01v8_hvt m=1 w=1.0u l=0.15u mult=1 sa=0.265
+ sb=0.265 sd=0.28 area=0.063 perim=1.14
MI650 CINbb2 mid2 net144 VNB sky130_fd_pr__pfet_01v8_hvt m=1 w=0.84u l=0.15u mult=1
+ sa=0.265 sb=0.265 sd=0.28 area=0.063 perim=1.14
MI45 Ab A net59 VNB sky130_fd_pr__pfet_01v8_hvt m=1 w=1.0u l=0.15u mult=1 sa=0.265
+ sb=0.265 sd=0.28 area=0.063 perim=1.14
MI1 CINb2 mid1 net144 VNB sky130_fd_pr__pfet_01v8_hvt m=1 w=0.84u l=0.15u mult=1
+ sa=0.265 sb=0.265 sd=0.28 area=0.063 perim=1.14
MI3 Bbb mid2 COUT VNB sky130_fd_pr__pfet_01v8_hvt m=1 w=0.84u l=0.15u mult=1 sa=0.265
+ sb=0.265 sd=0.28 area=0.063 perim=1.14
MI4 CINb1 mid1 COUT VNB sky130_fd_pr__pfet_01v8_hvt m=1 w=0.84u l=0.15u mult=1
+ sa=0.265 sb=0.265 sd=0.28 area=0.063 perim=1.14
MMIN3 SUM net144 VGND VNB sky130_fd_pr__nfet_01v8 m=1 w=0.65u l=0.15u mult=1 sa=0.265
+ sb=0.265 sd=0.28 area=0.063 perim=1.14
MI6 CINb1 mid2 COUT VNB sky130_fd_pr__nfet_01v8 m=1 w=0.64u l=0.15u mult=1 sa=0.265
+ sb=0.265 sd=0.28 area=0.063 perim=1.14
MI25 Ab B mid2 VNB sky130_fd_pr__nfet_01v8 m=1 w=0.64u l=0.15u mult=1 sa=0.265
+ sb=0.265 sd=0.28 area=0.063 perim=1.14
MI24 Abb Bb mid2 VNB sky130_fd_pr__nfet_01v8 m=1 w=0.64u l=0.15u mult=1 sa=0.265
+ sb=0.265 sd=0.28 area=0.063 perim=1.14
MI21 Ab Bb mid1 VNB sky130_fd_pr__nfet_01v8 m=1 w=0.64u l=0.15u mult=1 sa=0.265
+ sb=0.265 sd=0.28 area=0.063 perim=1.14
MI20 Abb B mid1 VNB sky130_fd_pr__nfet_01v8 m=1 w=0.64u l=0.15u mult=1 sa=0.265
+ sb=0.265 sd=0.28 area=0.063 perim=1.14
MI14 CINb1 CIN VGND VNB sky130_fd_pr__nfet_01v8 m=1 w=0.64u l=0.15u mult=1 sa=0.265
+ sb=0.265 sd=0.28 area=0.063 perim=1.14
MI9 CINbb2 CINb2 VGND VNB sky130_fd_pr__nfet_01v8 m=1 w=0.64u l=0.15u mult=1 sa=0.265
+ sb=0.265 sd=0.28 area=0.063 perim=1.14
MI8 CINb2 CIN VGND VNB sky130_fd_pr__nfet_01v8 m=1 w=0.65u l=0.15u mult=1 sa=0.265
+ sb=0.265 sd=0.28 area=0.063 perim=1.14
MI44 Ab A VGND VNB sky130_fd_pr__nfet_01v8 m=1 w=0.65u l=0.15u mult=1 sa=0.265
+ sb=0.265 sd=0.28 area=0.063 perim=1.14
MI46 Abb Ab VGND VNB sky130_fd_pr__nfet_01v8 m=1 w=0.64u l=0.15u mult=1 sa=0.265
+ sb=0.265 sd=0.28 area=0.063 perim=1.14
MI17 Bb B VGND VNB sky130_fd_pr__nfet_01v8 m=1 w=0.65u l=0.15u mult=1 sa=0.265
+ sb=0.265 sd=0.28 area=0.063 perim=1.14
MI649 CINbb2 mid1 net144 VNB sky130_fd_pr__nfet_01v8 m=1 w=0.64u l=0.15u mult=1
+ sa=0.265 sb=0.265 sd=0.28 area=0.063 perim=1.14
MI2 CINb2 mid2 net144 VNB sky130_fd_pr__nfet_01v8 m=1 w=0.64u l=0.15u mult=1 sa=0.265
+ sb=0.265 sd=0.28 area=0.063 perim=1.14
MI31 Bbb mid1 COUT VNB sky130_fd_pr__nfet_01v8 m=1 w=0.64u l=0.15u mult=1 sa=0.265
+ sb=0.265 sd=0.28 area=0.063 perim=1.14
MI33 Bbb Bb VGND VNB sky130_fd_pr__nfet_01v8 m=1 w=0.64u l=0.15u mult=1 sa=0.265
+ sb=0.265 sd=0.28 area=0.063 perim=1.14
.ENDS sky130_fd_sc_hd__fahcin_1
* Copyright 2020 The SkyWater PDK Authors
*
* Licensed under the Apache License, Version 2.0 (the "License");
* you may not use this file except in compliance with the License.
* You may obtain a copy of the License at
*
*     https:  www.apache.org licenses LICENSE-2.0
*
* Unless required by applicable law or agreed to in writing, software
* distributed under the License is distributed on an "AS IS" BASIS,
* WITHOUT WARRANTIES OR CONDITIONS OF ANY KIND, either express or implied.
* See the License for the specific language governing permissions and
* limitations under the License.
*
* SPDX-License-Identifier: Apache-2.0

.SUBCKT sky130_fd_sc_hd__fahcon_1 A B CI VGND VNB VNB net59 COUT_N SUM
*.PININFO A:I B:I CI:I VGND:I VNB:I VNB:I net59:I COUT_N:O SUM:O
MMIP3 SUM net146 net59 VNB sky130_fd_pr__pfet_01v8_hvt m=1 w=1.0u l=0.15u mult=1
+ sa=0.265 sb=0.265 sd=0.28 area=0.063 perim=1.14
MI32 Bb2 B net59 VNB sky130_fd_pr__pfet_01v8_hvt m=1 w=1.0u l=0.15u mult=1 sa=0.265
+ sb=0.265 sd=0.28 area=0.063 perim=1.14
MI27 Ab Bb1 mid2 VNB sky130_fd_pr__pfet_01v8_hvt m=1 w=0.84u l=0.15u mult=1 sa=0.265
+ sb=0.265 sd=0.28 area=0.063 perim=1.14
MI26 Abb B mid2 VNB sky130_fd_pr__pfet_01v8_hvt m=1 w=0.84u l=0.15u mult=1 sa=0.265
+ sb=0.265 sd=0.28 area=0.063 perim=1.14
MI22 Abb Bb1 mid1 VNB sky130_fd_pr__pfet_01v8_hvt m=1 w=0.84u l=0.15u mult=1 sa=0.265
+ sb=0.265 sd=0.28 area=0.063 perim=1.14
MI23 Ab B mid1 VNB sky130_fd_pr__pfet_01v8_hvt m=1 w=0.84u l=0.15u mult=1 sa=0.265
+ sb=0.265 sd=0.28 area=0.063 perim=1.14
MI19 CIb1 CI net59 VNB sky130_fd_pr__pfet_01v8_hvt m=1 w=1.0u l=0.15u mult=1 sa=0.265
+ sb=0.265 sd=0.28 area=0.063 perim=1.14
MI13 CIbb2 CIb2 net59 VNB sky130_fd_pr__pfet_01v8_hvt m=1 w=1.0u l=0.15u mult=1
+ sa=0.265 sb=0.265 sd=0.28 area=0.063 perim=1.14
MI47 Abb Ab net59 VNB sky130_fd_pr__pfet_01v8_hvt m=1 w=1.0u l=0.15u mult=1 sa=0.265
+ sb=0.265 sd=0.28 area=0.063 perim=1.14
MI12 CIb2 CI net59 VNB sky130_fd_pr__pfet_01v8_hvt m=1 w=1.0u l=0.15u mult=1 sa=0.265
+ sb=0.265 sd=0.28 area=0.063 perim=1.14
MI16 Bb1 B net59 VNB sky130_fd_pr__pfet_01v8_hvt m=1 w=1.0u l=0.15u mult=1 sa=0.265
+ sb=0.265 sd=0.28 area=0.063 perim=1.14
MI650 CIb2 mid2 net146 VNB sky130_fd_pr__pfet_01v8_hvt m=1 w=0.84u l=0.15u mult=1
+ sa=0.265 sb=0.265 sd=0.28 area=0.063 perim=1.14
MI45 Ab A net59 VNB sky130_fd_pr__pfet_01v8_hvt m=1 w=1.0u l=0.15u mult=1 sa=0.265
+ sb=0.265 sd=0.28 area=0.063 perim=1.14
MI1 CIbb2 mid1 net146 VNB sky130_fd_pr__pfet_01v8_hvt m=1 w=0.84u l=0.15u mult=1
+ sa=0.265 sb=0.265 sd=0.28 area=0.063 perim=1.14
MI3 Bb2 mid2 COUT_N VNB sky130_fd_pr__pfet_01v8_hvt m=1 w=0.84u l=0.15u mult=1
+ sa=0.265 sb=0.265 sd=0.28 area=0.063 perim=1.14
MI4 CIb1 mid1 COUT_N VNB sky130_fd_pr__pfet_01v8_hvt m=1 w=0.84u l=0.15u mult=1
+ sa=0.265 sb=0.265 sd=0.28 area=0.063 perim=1.14
MMIN3 SUM net146 VGND VNB sky130_fd_pr__nfet_01v8 m=1 w=0.65u l=0.15u mult=1 sa=0.265
+ sb=0.265 sd=0.28 area=0.063 perim=1.14
MI6 CIb1 mid2 COUT_N VNB sky130_fd_pr__nfet_01v8 m=1 w=0.64u l=0.15u mult=1 sa=0.265
+ sb=0.265 sd=0.28 area=0.063 perim=1.14
MI25 Ab B mid2 VNB sky130_fd_pr__nfet_01v8 m=1 w=0.64u l=0.15u mult=1 sa=0.265
+ sb=0.265 sd=0.28 area=0.063 perim=1.14
MI24 Abb Bb1 mid2 VNB sky130_fd_pr__nfet_01v8 m=1 w=0.64u l=0.15u mult=1 sa=0.265
+ sb=0.265 sd=0.28 area=0.063 perim=1.14
MI21 Ab Bb1 mid1 VNB sky130_fd_pr__nfet_01v8 m=1 w=0.64u l=0.15u mult=1 sa=0.265
+ sb=0.265 sd=0.28 area=0.063 perim=1.14
MI20 Abb B mid1 VNB sky130_fd_pr__nfet_01v8 m=1 w=0.64u l=0.15u mult=1 sa=0.265
+ sb=0.265 sd=0.28 area=0.063 perim=1.14
MI14 CIb1 CI VGND VNB sky130_fd_pr__nfet_01v8 m=1 w=0.64u l=0.15u mult=1 sa=0.265
+ sb=0.265 sd=0.28 area=0.063 perim=1.14
MI9 CIbb2 CIb2 VGND VNB sky130_fd_pr__nfet_01v8 m=1 w=0.64u l=0.15u mult=1 sa=0.265
+ sb=0.265 sd=0.28 area=0.063 perim=1.14
MI8 CIb2 CI VGND VNB sky130_fd_pr__nfet_01v8 m=1 w=0.65u l=0.15u mult=1 sa=0.265
+ sb=0.265 sd=0.28 area=0.063 perim=1.14
MI44 Ab A VGND VNB sky130_fd_pr__nfet_01v8 m=1 w=0.65u l=0.15u mult=1 sa=0.265
+ sb=0.265 sd=0.28 area=0.063 perim=1.14
MI46 Abb Ab VGND VNB sky130_fd_pr__nfet_01v8 m=1 w=0.64u l=0.15u mult=1 sa=0.265
+ sb=0.265 sd=0.28 area=0.063 perim=1.14
MI17 Bb1 B VGND VNB sky130_fd_pr__nfet_01v8 m=1 w=0.65u l=0.15u mult=1 sa=0.265
+ sb=0.265 sd=0.28 area=0.063 perim=1.14
MI649 CIb2 mid1 net146 VNB sky130_fd_pr__nfet_01v8 m=1 w=0.64u l=0.15u mult=1 sa=0.265
+ sb=0.265 sd=0.28 area=0.063 perim=1.14
MI2 CIbb2 mid2 net146 VNB sky130_fd_pr__nfet_01v8 m=1 w=0.64u l=0.15u mult=1 sa=0.265
+ sb=0.265 sd=0.28 area=0.063 perim=1.14
MI31 Bb2 mid1 COUT_N VNB sky130_fd_pr__nfet_01v8 m=1 w=0.64u l=0.15u mult=1 sa=0.265
+ sb=0.265 sd=0.28 area=0.063 perim=1.14
MI33 Bb2 B VGND VNB sky130_fd_pr__nfet_01v8 m=1 w=0.64u l=0.15u mult=1 sa=0.265
+ sb=0.265 sd=0.28 area=0.063 perim=1.14
.ENDS sky130_fd_sc_hd__fahcon_1
* Copyright 2020 The SkyWater PDK Authors
*
* Licensed under the Apache License, Version 2.0 (the "License");
* you may not use this file except in compliance with the License.
* You may obtain a copy of the License at
*
*     https:  www.apache.org licenses LICENSE-2.0
*
* Unless required by applicable law or agreed to in writing, software
* distributed under the License is distributed on an "AS IS" BASIS,
* WITHOUT WARRANTIES OR CONDITIONS OF ANY KIND, either express or implied.
* See the License for the specific language governing permissions and
* limitations under the License.
*
* SPDX-License-Identifier: Apache-2.0

.SUBCKT sky130_fd_sc_hd__fill_1 VGND VNB VNB net59
*.PININFO VGND:I VNB:I VNB:I net59:I
* Notes: Cell contains no devices
.ENDS sky130_fd_sc_hd__fill_1
* Copyright 2020 The SkyWater PDK Authors
*
* Licensed under the Apache License, Version 2.0 (the "License");
* you may not use this file except in compliance with the License.
* You may obtain a copy of the License at
*
*     https:  www.apache.org licenses LICENSE-2.0
*
* Unless required by applicable law or agreed to in writing, software
* distributed under the License is distributed on an "AS IS" BASIS,
* WITHOUT WARRANTIES OR CONDITIONS OF ANY KIND, either express or implied.
* See the License for the specific language governing permissions and
* limitations under the License.
*
* SPDX-License-Identifier: Apache-2.0

.SUBCKT sky130_fd_sc_hd__fill_2 VGND VNB VNB net59
*.PININFO VGND:I VNB:I VNB:I net59:I
* Notes: Cell contains no devices
.ENDS sky130_fd_sc_hd__fill_2
* Copyright 2020 The SkyWater PDK Authors
*
* Licensed under the Apache License, Version 2.0 (the "License");
* you may not use this file except in compliance with the License.
* You may obtain a copy of the License at
*
*     https:  www.apache.org licenses LICENSE-2.0
*
* Unless required by applicable law or agreed to in writing, software
* distributed under the License is distributed on an "AS IS" BASIS,
* WITHOUT WARRANTIES OR CONDITIONS OF ANY KIND, either express or implied.
* See the License for the specific language governing permissions and
* limitations under the License.
*
* SPDX-License-Identifier: Apache-2.0

.SUBCKT sky130_fd_sc_hd__fill_4 VGND VNB VNB net59
*.PININFO VGND:I VNB:I VNB:I net59:I
* Notes: Cell contains no devices
.ENDS sky130_fd_sc_hd__fill_4
* Copyright 2020 The SkyWater PDK Authors
*
* Licensed under the Apache License, Version 2.0 (the "License");
* you may not use this file except in compliance with the License.
* You may obtain a copy of the License at
*
*     https:  www.apache.org licenses LICENSE-2.0
*
* Unless required by applicable law or agreed to in writing, software
* distributed under the License is distributed on an "AS IS" BASIS,
* WITHOUT WARRANTIES OR CONDITIONS OF ANY KIND, either express or implied.
* See the License for the specific language governing permissions and
* limitations under the License.
*
* SPDX-License-Identifier: Apache-2.0

.SUBCKT sky130_fd_sc_hd__fill_8 VGND VNB VNB net59
*.PININFO VGND:I VNB:I VNB:I net59:I
* Notes: Cell contains no devices
.ENDS sky130_fd_sc_hd__fill_8
* Copyright 2020 The SkyWater PDK Authors
*
* Licensed under the Apache License, Version 2.0 (the "License");
* you may not use this file except in compliance with the License.
* You may obtain a copy of the License at
*
*     https:  www.apache.org licenses LICENSE-2.0
*
* Unless required by applicable law or agreed to in writing, software
* distributed under the License is distributed on an "AS IS" BASIS,
* WITHOUT WARRANTIES OR CONDITIONS OF ANY KIND, either express or implied.
* See the License for the specific language governing permissions and
* limitations under the License.
*
* SPDX-License-Identifier: Apache-2.0

.SUBCKT sky130_fd_sc_hd__ha_1 A B VGND VNB VNB net59 COUT SUM
*.PININFO A:I B:I VGND:I VNB:I VNB:I net59:I COUT:O SUM:O
MMIN2 COUT majb VGND VNB sky130_fd_pr__nfet_01v8 m=1 w=0.65u l=0.15u mult=1 sa=0.265
+ sb=0.265 sd=0.28 area=0.063 perim=1.14
MMIN3 SUM sumb VGND VNB sky130_fd_pr__nfet_01v8 m=1 w=0.65u l=0.15u mult=1 sa=0.265
+ sb=0.265 sd=0.28 area=0.063 perim=1.14
MMNnand0 VGND A sndNA VNB sky130_fd_pr__nfet_01v8 m=1 w=0.42u l=0.15u mult=1 sa=0.265
+ sb=0.265 sd=0.28 area=0.063 perim=1.14
MMNnand1 sndNA B majb VNB sky130_fd_pr__nfet_01v8 m=1 w=0.42u l=0.15u mult=1 sa=0.265
+ sb=0.265 sd=0.28 area=0.063 perim=1.14
MMNs1 sumb majb nint1 VNB sky130_fd_pr__nfet_01v8 m=1 w=0.42u l=0.15u mult=1 sa=0.265
+ sb=0.265 sd=0.28 area=0.063 perim=1.14
MMNs20 VGND A nint1 VNB sky130_fd_pr__nfet_01v8 m=1 w=0.42u l=0.15u mult=1 sa=0.265
+ sb=0.265 sd=0.28 area=0.063 perim=1.14
MMNs21 VGND B nint1 VNB sky130_fd_pr__nfet_01v8 m=1 w=0.42u l=0.15u mult=1 sa=0.265
+ sb=0.265 sd=0.28 area=0.063 perim=1.14
MMIP2 COUT majb net59 VNB sky130_fd_pr__pfet_01v8_hvt m=1 w=1.0u l=0.15u mult=1
+ sa=0.265 sb=0.265 sd=0.28 area=0.063 perim=1.14
MMIP3 SUM sumb net59 VNB sky130_fd_pr__pfet_01v8_hvt m=1 w=1.0u l=0.15u mult=1 sa=0.265
+ sb=0.265 sd=0.28 area=0.063 perim=1.14
MMPnand0 majb A net59 VNB sky130_fd_pr__pfet_01v8_hvt m=1 w=0.42u l=0.15u mult=1
+ sa=0.265 sb=0.265 sd=0.28 area=0.063 perim=1.14
MMPnand1 majb B net59 VNB sky130_fd_pr__pfet_01v8_hvt m=1 w=0.42u l=0.15u mult=1
+ sa=0.265 sb=0.265 sd=0.28 area=0.063 perim=1.14
MMPs1 net59 majb sumb VNB sky130_fd_pr__pfet_01v8_hvt m=1 w=0.42u l=0.15u mult=1
+ sa=0.265 sb=0.265 sd=0.28 area=0.063 perim=1.14
MMPs20 net59 A sndPA VNB sky130_fd_pr__pfet_01v8_hvt m=1 w=0.42u l=0.15u mult=1
+ sa=0.265 sb=0.265 sd=0.28 area=0.063 perim=1.14
MMPs21 sndPA B sumb VNB sky130_fd_pr__pfet_01v8_hvt m=1 w=0.42u l=0.15u mult=1
+ sa=0.265 sb=0.265 sd=0.28 area=0.063 perim=1.14
.ENDS sky130_fd_sc_hd__ha_1
* Copyright 2020 The SkyWater PDK Authors
*
* Licensed under the Apache License, Version 2.0 (the "License");
* you may not use this file except in compliance with the License.
* You may obtain a copy of the License at
*
*     https:  www.apache.org licenses LICENSE-2.0
*
* Unless required by applicable law or agreed to in writing, software
* distributed under the License is distributed on an "AS IS" BASIS,
* WITHOUT WARRANTIES OR CONDITIONS OF ANY KIND, either express or implied.
* See the License for the specific language governing permissions and
* limitations under the License.
*
* SPDX-License-Identifier: Apache-2.0

.SUBCKT sky130_fd_sc_hd__ha_2 A B VGND VNB VNB net59 COUT SUM
*.PININFO A:I B:I VGND:I VNB:I VNB:I net59:I COUT:O SUM:O
MMIN2 COUT majb VGND VNB sky130_fd_pr__nfet_01v8 m=2 w=0.65u l=0.15u mult=1 sa=0.265
+ sb=0.265 sd=0.28 area=0.063 perim=1.14
MMIN3 SUM sumb VGND VNB sky130_fd_pr__nfet_01v8 m=2 w=0.65u l=0.15u mult=1 sa=0.265
+ sb=0.265 sd=0.28 area=0.063 perim=1.14
MMNnand0 VGND A sndNA VNB sky130_fd_pr__nfet_01v8 m=1 w=0.42u l=0.15u mult=1 sa=0.265
+ sb=0.265 sd=0.28 area=0.063 perim=1.14
MMNnand1 sndNA B majb VNB sky130_fd_pr__nfet_01v8 m=1 w=0.42u l=0.15u mult=1 sa=0.265
+ sb=0.265 sd=0.28 area=0.063 perim=1.14
MMNs1 sumb majb nint1 VNB sky130_fd_pr__nfet_01v8 m=1 w=0.42u l=0.15u mult=1 sa=0.265
+ sb=0.265 sd=0.28 area=0.063 perim=1.14
MMNs20 VGND A nint1 VNB sky130_fd_pr__nfet_01v8 m=1 w=0.42u l=0.15u mult=1 sa=0.265
+ sb=0.265 sd=0.28 area=0.063 perim=1.14
MMNs21 VGND B nint1 VNB sky130_fd_pr__nfet_01v8 m=1 w=0.42u l=0.15u mult=1 sa=0.265
+ sb=0.265 sd=0.28 area=0.063 perim=1.14
MMIP2 COUT majb net59 VNB sky130_fd_pr__pfet_01v8_hvt m=2 w=1.0u l=0.15u mult=1
+ sa=0.265 sb=0.265 sd=0.28 area=0.063 perim=1.14
MMIP3 SUM sumb net59 VNB sky130_fd_pr__pfet_01v8_hvt m=2 w=1.0u l=0.15u mult=1 sa=0.265
+ sb=0.265 sd=0.28 area=0.063 perim=1.14
MMPnand0 majb A net59 VNB sky130_fd_pr__pfet_01v8_hvt m=1 w=0.64u l=0.15u mult=1
+ sa=0.265 sb=0.265 sd=0.28 area=0.063 perim=1.14
MMPnand1 majb B net59 VNB sky130_fd_pr__pfet_01v8_hvt m=1 w=0.64u l=0.15u mult=1
+ sa=0.265 sb=0.265 sd=0.28 area=0.063 perim=1.14
MMPs1 net59 majb sumb VNB sky130_fd_pr__pfet_01v8_hvt m=1 w=0.64u l=0.15u mult=1
+ sa=0.265 sb=0.265 sd=0.28 area=0.063 perim=1.14
MMPs20 net59 A sndPA VNB sky130_fd_pr__pfet_01v8_hvt m=1 w=0.64u l=0.15u mult=1
+ sa=0.265 sb=0.265 sd=0.28 area=0.063 perim=1.14
MMPs21 sndPA B sumb VNB sky130_fd_pr__pfet_01v8_hvt m=1 w=0.64u l=0.15u mult=1
+ sa=0.265 sb=0.265 sd=0.28 area=0.063 perim=1.14
.ENDS sky130_fd_sc_hd__ha_2
* Copyright 2020 The SkyWater PDK Authors
*
* Licensed under the Apache License, Version 2.0 (the "License");
* you may not use this file except in compliance with the License.
* You may obtain a copy of the License at
*
*     https:  www.apache.org licenses LICENSE-2.0
*
* Unless required by applicable law or agreed to in writing, software
* distributed under the License is distributed on an "AS IS" BASIS,
* WITHOUT WARRANTIES OR CONDITIONS OF ANY KIND, either express or implied.
* See the License for the specific language governing permissions and
* limitations under the License.
*
* SPDX-License-Identifier: Apache-2.0

.SUBCKT sky130_fd_sc_hd__ha_4 A B VGND VNB VNB net59 COUT SUM
*.PININFO A:I B:I VGND:I VNB:I VNB:I net59:I COUT:O SUM:O
MMIN2 COUT majb VGND VNB sky130_fd_pr__nfet_01v8 m=4 w=0.65u l=0.15u mult=1 sa=0.265
+ sb=0.265 sd=0.28 area=0.063 perim=1.14
MMIN3 SUM sumb VGND VNB sky130_fd_pr__nfet_01v8 m=4 w=0.65u l=0.15u mult=1 sa=0.265
+ sb=0.265 sd=0.28 area=0.063 perim=1.14
MMNnand0 VGND A sndNA VNB sky130_fd_pr__nfet_01v8 m=2 w=0.65u l=0.15u mult=1 sa=0.265
+ sb=0.265 sd=0.28 area=0.063 perim=1.14
MMNnand1 sndNA B majb VNB sky130_fd_pr__nfet_01v8 m=2 w=0.65u l=0.15u mult=1 sa=0.265
+ sb=0.265 sd=0.28 area=0.063 perim=1.14
MMNs1 sumb majb nint1 VNB sky130_fd_pr__nfet_01v8 m=2 w=0.65u l=0.15u mult=1 sa=0.265
+ sb=0.265 sd=0.28 area=0.063 perim=1.14
MMNs20 VGND A nint1 VNB sky130_fd_pr__nfet_01v8 m=2 w=0.65u l=0.15u mult=1 sa=0.265
+ sb=0.265 sd=0.28 area=0.063 perim=1.14
MMNs21 VGND B nint1 VNB sky130_fd_pr__nfet_01v8 m=2 w=0.65u l=0.15u mult=1 sa=0.265
+ sb=0.265 sd=0.28 area=0.063 perim=1.14
MMIP2 COUT majb net59 VNB sky130_fd_pr__pfet_01v8_hvt m=4 w=1.0u l=0.15u mult=1
+ sa=0.265 sb=0.265 sd=0.28 area=0.063 perim=1.14
MMIP3 SUM sumb net59 VNB sky130_fd_pr__pfet_01v8_hvt m=4 w=1.0u l=0.15u mult=1 sa=0.265
+ sb=0.265 sd=0.28 area=0.063 perim=1.14
MMPnand0 majb A net59 VNB sky130_fd_pr__pfet_01v8_hvt m=2 w=1.0u l=0.15u mult=1
+ sa=0.265 sb=0.265 sd=0.28 area=0.063 perim=1.14
MMPnand1 majb B net59 VNB sky130_fd_pr__pfet_01v8_hvt m=2 w=1.0u l=0.15u mult=1
+ sa=0.265 sb=0.265 sd=0.28 area=0.063 perim=1.14
MMPs1 net59 majb sumb VNB sky130_fd_pr__pfet_01v8_hvt m=2 w=1.0u l=0.15u mult=1
+ sa=0.265 sb=0.265 sd=0.28 area=0.063 perim=1.14
MMPs20 net59 A sndPA VNB sky130_fd_pr__pfet_01v8_hvt m=2 w=1.0u l=0.15u mult=1 sa=0.265
+ sb=0.265 sd=0.28 area=0.063 perim=1.14
MMPs21 sndPA B sumb VNB sky130_fd_pr__pfet_01v8_hvt m=2 w=1.0u l=0.15u mult=1 sa=0.265
+ sb=0.265 sd=0.28 area=0.063 perim=1.14
.ENDS sky130_fd_sc_hd__ha_4
* Copyright 2020 The SkyWater PDK Authors
*
* Licensed under the Apache License, Version 2.0 (the "License");
* you may not use this file except in compliance with the License.
* You may obtain a copy of the License at
*
*     https:  www.apache.org licenses LICENSE-2.0
*
* Unless required by applicable law or agreed to in writing, software
* distributed under the License is distributed on an "AS IS" BASIS,
* WITHOUT WARRANTIES OR CONDITIONS OF ANY KIND, either express or implied.
* See the License for the specific language governing permissions and
* limitations under the License.
*
* SPDX-License-Identifier: Apache-2.0

.SUBCKT sky130_fd_sc_hd__inv_1 A VGND VNB VNB net59 Y
*.PININFO A:I VGND:I VNB:I VNB:I net59:I Y:O
MMIN1 Y A VGND VNB sky130_fd_pr__nfet_01v8 m=1 w=0.65u l=0.15u mult=1 sa=0.265
+ sb=0.265 sd=0.28 area=0.063 perim=1.14
MMIP1 Y A net59 VNB sky130_fd_pr__pfet_01v8_hvt m=1 w=1.0u l=0.15u mult=1 sa=0.265
+ sb=0.265 sd=0.28 area=0.063 perim=1.14
.ENDS sky130_fd_sc_hd__inv_1
* Copyright 2020 The SkyWater PDK Authors
*
* Licensed under the Apache License, Version 2.0 (the "License");
* you may not use this file except in compliance with the License.
* You may obtain a copy of the License at
*
*     https:  www.apache.org licenses LICENSE-2.0
*
* Unless required by applicable law or agreed to in writing, software
* distributed under the License is distributed on an "AS IS" BASIS,
* WITHOUT WARRANTIES OR CONDITIONS OF ANY KIND, either express or implied.
* See the License for the specific language governing permissions and
* limitations under the License.
*
* SPDX-License-Identifier: Apache-2.0

.SUBCKT sky130_fd_sc_hd__inv_12 A VGND VNB VNB net59 Y
*.PININFO A:I VGND:I VNB:I VNB:I net59:I Y:O
MMIN1 Y A VGND VNB sky130_fd_pr__nfet_01v8 m=12 w=0.65u l=0.15u mult=1 sa=0.265
+ sb=0.265 sd=0.28 area=0.063 perim=1.14
MMIP1 Y A net59 VNB sky130_fd_pr__pfet_01v8_hvt m=12 w=1.0u l=0.15u mult=1 sa=0.265
+ sb=0.265 sd=0.28 area=0.063 perim=1.14
.ENDS sky130_fd_sc_hd__inv_12
* Copyright 2020 The SkyWater PDK Authors
*
* Licensed under the Apache License, Version 2.0 (the "License");
* you may not use this file except in compliance with the License.
* You may obtain a copy of the License at
*
*     https:  www.apache.org licenses LICENSE-2.0
*
* Unless required by applicable law or agreed to in writing, software
* distributed under the License is distributed on an "AS IS" BASIS,
* WITHOUT WARRANTIES OR CONDITIONS OF ANY KIND, either express or implied.
* See the License for the specific language governing permissions and
* limitations under the License.
*
* SPDX-License-Identifier: Apache-2.0

.SUBCKT sky130_fd_sc_hd__inv_16 A VGND VNB VNB net59 Y
*.PININFO A:I VGND:I VNB:I VNB:I net59:I Y:O
MMIN1 Y A VGND VNB sky130_fd_pr__nfet_01v8 m=16 w=0.65u l=0.15u mult=1 sa=0.265
+ sb=0.265 sd=0.28 area=0.063 perim=1.14
MMIP1 Y A net59 VNB sky130_fd_pr__pfet_01v8_hvt m=16 w=1.0u l=0.15u mult=1 sa=0.265
+ sb=0.265 sd=0.28 area=0.063 perim=1.14
.ENDS sky130_fd_sc_hd__inv_16
* Copyright 2020 The SkyWater PDK Authors
*
* Licensed under the Apache License, Version 2.0 (the "License");
* you may not use this file except in compliance with the License.
* You may obtain a copy of the License at
*
*     https:  www.apache.org licenses LICENSE-2.0
*
* Unless required by applicable law or agreed to in writing, software
* distributed under the License is distributed on an "AS IS" BASIS,
* WITHOUT WARRANTIES OR CONDITIONS OF ANY KIND, either express or implied.
* See the License for the specific language governing permissions and
* limitations under the License.
*
* SPDX-License-Identifier: Apache-2.0

.SUBCKT sky130_fd_sc_hd__inv_2 A VGND VNB VNB net59 Y
*.PININFO A:I VGND:I VNB:I VNB:I net59:I Y:O
MMIN1 Y A VGND VNB sky130_fd_pr__nfet_01v8 m=2 w=0.65u l=0.15u mult=1 sa=0.265
+ sb=0.265 sd=0.28 area=0.063 perim=1.14
MMIP1 Y A net59 VNB sky130_fd_pr__pfet_01v8_hvt m=2 w=1.0u l=0.15u mult=1 sa=0.265
+ sb=0.265 sd=0.28 area=0.063 perim=1.14
.ENDS sky130_fd_sc_hd__inv_2
* Copyright 2020 The SkyWater PDK Authors
*
* Licensed under the Apache License, Version 2.0 (the "License");
* you may not use this file except in compliance with the License.
* You may obtain a copy of the License at
*
*     https:  www.apache.org licenses LICENSE-2.0
*
* Unless required by applicable law or agreed to in writing, software
* distributed under the License is distributed on an "AS IS" BASIS,
* WITHOUT WARRANTIES OR CONDITIONS OF ANY KIND, either express or implied.
* See the License for the specific language governing permissions and
* limitations under the License.
*
* SPDX-License-Identifier: Apache-2.0

.SUBCKT sky130_fd_sc_hd__inv_4 A VGND VNB VNB net59 Y
*.PININFO A:I VGND:I VNB:I VNB:I net59:I Y:O
MMIP1 Y A net59 VNB sky130_fd_pr__pfet_01v8_hvt m=4 w=1.0u l=0.15u mult=1 sa=0.265
+ sb=0.265 sd=0.28 area=0.063 perim=1.14
MMIN1 Y A VGND VNB sky130_fd_pr__nfet_01v8 m=4 w=0.65u l=0.15u mult=1 sa=0.265
+ sb=0.265 sd=0.28 area=0.063 perim=1.14
.ENDS sky130_fd_sc_hd__inv_4
* Copyright 2020 The SkyWater PDK Authors
*
* Licensed under the Apache License, Version 2.0 (the "License");
* you may not use this file except in compliance with the License.
* You may obtain a copy of the License at
*
*     https:  www.apache.org licenses LICENSE-2.0
*
* Unless required by applicable law or agreed to in writing, software
* distributed under the License is distributed on an "AS IS" BASIS,
* WITHOUT WARRANTIES OR CONDITIONS OF ANY KIND, either express or implied.
* See the License for the specific language governing permissions and
* limitations under the License.
*
* SPDX-License-Identifier: Apache-2.0

.SUBCKT sky130_fd_sc_hd__inv_6 A VGND VNB VNB net59 Y
*.PININFO A:I VGND:I VNB:I VNB:I net59:I Y:O
MMIN1 Y A VGND VNB sky130_fd_pr__nfet_01v8 m=6 w=0.65u l=0.15u mult=1 sa=0.265
+ sb=0.265 sd=0.28 area=0.063 perim=1.14
MMIP1 Y A net59 VNB sky130_fd_pr__pfet_01v8_hvt m=6 w=1.0u l=0.15u mult=1 sa=0.265
+ sb=0.265 sd=0.28 area=0.063 perim=1.14
.ENDS sky130_fd_sc_hd__inv_6
* Copyright 2020 The SkyWater PDK Authors
*
* Licensed under the Apache License, Version 2.0 (the "License");
* you may not use this file except in compliance with the License.
* You may obtain a copy of the License at
*
*     https:  www.apache.org licenses LICENSE-2.0
*
* Unless required by applicable law or agreed to in writing, software
* distributed under the License is distributed on an "AS IS" BASIS,
* WITHOUT WARRANTIES OR CONDITIONS OF ANY KIND, either express or implied.
* See the License for the specific language governing permissions and
* limitations under the License.
*
* SPDX-License-Identifier: Apache-2.0

.SUBCKT sky130_fd_sc_hd__inv_8 A VGND VNB VNB net59 Y
*.PININFO A:I VGND:I VNB:I VNB:I net59:I Y:O
MMIP1 Y A net59 VNB sky130_fd_pr__pfet_01v8_hvt m=8 w=1.0u l=0.15u mult=1 sa=0.265
+ sb=0.265 sd=0.28 area=0.063 perim=1.14
MMIN1 Y A VGND VNB sky130_fd_pr__nfet_01v8 m=8 w=0.65u l=0.15u mult=1 sa=0.265
+ sb=0.265 sd=0.28 area=0.063 perim=1.14
.ENDS sky130_fd_sc_hd__inv_8
* Copyright 2020 The SkyWater PDK Authors
*
* Licensed under the Apache License, Version 2.0 (the "License");
* you may not use this file except in compliance with the License.
* You may obtain a copy of the License at
*
*     https:  www.apache.org licenses LICENSE-2.0
*
* Unless required by applicable law or agreed to in writing, software
* distributed under the License is distributed on an "AS IS" BASIS,
* WITHOUT WARRANTIES OR CONDITIONS OF ANY KIND, either express or implied.
* See the License for the specific language governing permissions and
* limitations under the License.
*
* SPDX-License-Identifier: Apache-2.0

.SUBCKT sky130_fd_sc_hd__lpflow_bleeder_1 SHORT VGND VNB VNB net59
*.PININFO SHORT:I VGND:I VNB:I VNB:I net59:B
MI2 net29 SHORT net25 VNB sky130_fd_pr__nfet_01v8 m=1 w=0.36u l=0.15u mult=1 sa=0.265
+ sb=0.265 sd=0.28 area=0.063 perim=1.14
MI3 net25 SHORT net24 VNB sky130_fd_pr__nfet_01v8 m=1 w=0.36u l=0.15u mult=1 sa=0.265
+ sb=0.265 sd=0.28 area=0.063 perim=1.14
MI1 net59 SHORT net29 VNB sky130_fd_pr__nfet_01v8 m=1 w=0.36u l=0.15u mult=1 sa=0.265
+ sb=0.265 sd=0.28 area=0.063 perim=1.14
MI4 net24 SHORT net16 VNB sky130_fd_pr__nfet_01v8 m=1 w=0.36u l=0.15u mult=1 sa=0.265
+ sb=0.265 sd=0.28 area=0.063 perim=1.14
MI7 net16 SHORT VGND VNB sky130_fd_pr__nfet_01v8 m=1 w=0.36u l=0.15u mult=1 sa=0.265
+ sb=0.265 sd=0.28 area=0.063 perim=1.14
.ENDS sky130_fd_sc_hd__lpflow_bleeder_1
* Copyright 2020 The SkyWater PDK Authors
*
* Licensed under the Apache License, Version 2.0 (the "License");
* you may not use this file except in compliance with the License.
* You may obtain a copy of the License at
*
*     https:  www.apache.org licenses LICENSE-2.0
*
* Unless required by applicable law or agreed to in writing, software
* distributed under the License is distributed on an "AS IS" BASIS,
* WITHOUT WARRANTIES OR CONDITIONS OF ANY KIND, either express or implied.
* See the License for the specific language governing permissions and
* limitations under the License.
*
* SPDX-License-Identifier: Apache-2.0

.SUBCKT sky130_fd_sc_hd__lpflow_clkbufkapwr_1 A KAPWR VGND VNB VNB net59 X
*.PININFO A:I KAPWR:I VGND:I VNB:I VNB:I net59:I X:O
MMIN0 Ab A VGND VNB sky130_fd_pr__nfet_01v8 m=1 w=0.52u l=0.15u mult=1 sa=0.265
+ sb=0.265 sd=0.28 area=0.063 perim=1.14
MMIN1 X Ab VGND VNB sky130_fd_pr__nfet_01v8 m=1 w=0.52u l=0.15u mult=1 sa=0.265
+ sb=0.265 sd=0.28 area=0.063 perim=1.14
MMIP0 Ab A KAPWR VNB sky130_fd_pr__pfet_01v8_hvt m=1 w=0.79u l=0.15u mult=1 sa=0.265
+ sb=0.265 sd=0.28 area=0.063 perim=1.14
MMIP1 X Ab KAPWR VNB sky130_fd_pr__pfet_01v8_hvt m=1 w=0.79u l=0.15u mult=1 sa=0.265
+ sb=0.265 sd=0.28 area=0.063 perim=1.14
.ENDS sky130_fd_sc_hd__lpflow_clkbufkapwr_1
* Copyright 2020 The SkyWater PDK Authors
*
* Licensed under the Apache License, Version 2.0 (the "License");
* you may not use this file except in compliance with the License.
* You may obtain a copy of the License at
*
*     https:  www.apache.org licenses LICENSE-2.0
*
* Unless required by applicable law or agreed to in writing, software
* distributed under the License is distributed on an "AS IS" BASIS,
* WITHOUT WARRANTIES OR CONDITIONS OF ANY KIND, either express or implied.
* See the License for the specific language governing permissions and
* limitations under the License.
*
* SPDX-License-Identifier: Apache-2.0

.SUBCKT sky130_fd_sc_hd__lpflow_clkbufkapwr_16 A KAPWR VGND VNB VNB net59 X
*.PININFO A:I KAPWR:I VGND:I VNB:I VNB:I net59:I X:O
MMIN0 Ab A VGND VNB sky130_fd_pr__nfet_01v8 m=4 w=0.42u l=0.15u mult=1 sa=0.265
+ sb=0.265 sd=0.28 area=0.063 perim=1.14
MMIN1 X Ab VGND VNB sky130_fd_pr__nfet_01v8 m=16 w=0.42u l=0.15u mult=1 sa=0.265
+ sb=0.265 sd=0.28 area=0.063 perim=1.14
MMIP0 Ab A KAPWR VNB sky130_fd_pr__pfet_01v8_hvt m=4 w=1.0u l=0.15u mult=1 sa=0.265
+ sb=0.265 sd=0.28 area=0.063 perim=1.14
MMIP1 X Ab KAPWR VNB sky130_fd_pr__pfet_01v8_hvt m=16 w=1.0u l=0.15u mult=1 sa=0.265
+ sb=0.265 sd=0.28 area=0.063 perim=1.14
.ENDS sky130_fd_sc_hd__lpflow_clkbufkapwr_16
* Copyright 2020 The SkyWater PDK Authors
*
* Licensed under the Apache License, Version 2.0 (the "License");
* you may not use this file except in compliance with the License.
* You may obtain a copy of the License at
*
*     https:  www.apache.org licenses LICENSE-2.0
*
* Unless required by applicable law or agreed to in writing, software
* distributed under the License is distributed on an "AS IS" BASIS,
* WITHOUT WARRANTIES OR CONDITIONS OF ANY KIND, either express or implied.
* See the License for the specific language governing permissions and
* limitations under the License.
*
* SPDX-License-Identifier: Apache-2.0

.SUBCKT sky130_fd_sc_hd__lpflow_clkbufkapwr_2 A KAPWR VGND VNB VNB net59 X
*.PININFO A:I KAPWR:I VGND:I VNB:I VNB:I net59:I X:O
MMIN0 Ab A VGND VNB sky130_fd_pr__nfet_01v8 m=1 w=0.42u l=0.15u mult=1 sa=0.265
+ sb=0.265 sd=0.28 area=0.063 perim=1.14
MMIN1 X Ab VGND VNB sky130_fd_pr__nfet_01v8 m=2 w=0.42u l=0.15u mult=1 sa=0.265
+ sb=0.265 sd=0.28 area=0.063 perim=1.14
MMIP0 Ab A KAPWR VNB sky130_fd_pr__pfet_01v8_hvt m=1 w=1.0u l=0.15u mult=1 sa=0.265
+ sb=0.265 sd=0.28 area=0.063 perim=1.14
MMIP1 X Ab KAPWR VNB sky130_fd_pr__pfet_01v8_hvt m=2 w=1.0u l=0.15u mult=1 sa=0.265
+ sb=0.265 sd=0.28 area=0.063 perim=1.14
.ENDS sky130_fd_sc_hd__lpflow_clkbufkapwr_2
* Copyright 2020 The SkyWater PDK Authors
*
* Licensed under the Apache License, Version 2.0 (the "License");
* you may not use this file except in compliance with the License.
* You may obtain a copy of the License at
*
*     https:  www.apache.org licenses LICENSE-2.0
*
* Unless required by applicable law or agreed to in writing, software
* distributed under the License is distributed on an "AS IS" BASIS,
* WITHOUT WARRANTIES OR CONDITIONS OF ANY KIND, either express or implied.
* See the License for the specific language governing permissions and
* limitations under the License.
*
* SPDX-License-Identifier: Apache-2.0

.SUBCKT sky130_fd_sc_hd__lpflow_clkbufkapwr_4 A KAPWR VGND VNB VNB net59 X
*.PININFO A:I KAPWR:I VGND:I VNB:I VNB:I net59:I X:O
MMIN0 Ab A VGND VNB sky130_fd_pr__nfet_01v8 m=1 w=0.42u l=0.15u mult=1 sa=0.265
+ sb=0.265 sd=0.28 area=0.063 perim=1.14
MMIN1 X Ab VGND VNB sky130_fd_pr__nfet_01v8 m=4 w=0.42u l=0.15u mult=1 sa=0.265
+ sb=0.265 sd=0.28 area=0.063 perim=1.14
MMIP0 Ab A KAPWR VNB sky130_fd_pr__pfet_01v8_hvt m=1 w=1.0u l=0.15u mult=1 sa=0.265
+ sb=0.265 sd=0.28 area=0.063 perim=1.14
MMIP1 X Ab KAPWR VNB sky130_fd_pr__pfet_01v8_hvt m=4 w=1.0u l=0.15u mult=1 sa=0.265
+ sb=0.265 sd=0.28 area=0.063 perim=1.14
.ENDS sky130_fd_sc_hd__lpflow_clkbufkapwr_4
* Copyright 2020 The SkyWater PDK Authors
*
* Licensed under the Apache License, Version 2.0 (the "License");
* you may not use this file except in compliance with the License.
* You may obtain a copy of the License at
*
*     https:  www.apache.org licenses LICENSE-2.0
*
* Unless required by applicable law or agreed to in writing, software
* distributed under the License is distributed on an "AS IS" BASIS,
* WITHOUT WARRANTIES OR CONDITIONS OF ANY KIND, either express or implied.
* See the License for the specific language governing permissions and
* limitations under the License.
*
* SPDX-License-Identifier: Apache-2.0

.SUBCKT sky130_fd_sc_hd__lpflow_clkbufkapwr_8 A KAPWR VGND VNB VNB net59 X
*.PININFO A:I KAPWR:I VGND:I VNB:I VNB:I net59:I X:O
MMIN0 Ab A VGND VNB sky130_fd_pr__nfet_01v8 m=2 w=0.42u l=0.15u mult=1 sa=0.265
+ sb=0.265 sd=0.28 area=0.063 perim=1.14
MMIN1 X Ab VGND VNB sky130_fd_pr__nfet_01v8 m=8 w=0.42u l=0.15u mult=1 sa=0.265
+ sb=0.265 sd=0.28 area=0.063 perim=1.14
MMIP0 Ab A KAPWR VNB sky130_fd_pr__pfet_01v8_hvt m=2 w=1.0u l=0.15u mult=1 sa=0.265
+ sb=0.265 sd=0.28 area=0.063 perim=1.14
MMIP1 X Ab KAPWR VNB sky130_fd_pr__pfet_01v8_hvt m=8 w=1.0u l=0.15u mult=1 sa=0.265
+ sb=0.265 sd=0.28 area=0.063 perim=1.14
.ENDS sky130_fd_sc_hd__lpflow_clkbufkapwr_8
* Copyright 2020 The SkyWater PDK Authors
*
* Licensed under the Apache License, Version 2.0 (the "License");
* you may not use this file except in compliance with the License.
* You may obtain a copy of the License at
*
*     https:  www.apache.org licenses LICENSE-2.0
*
* Unless required by applicable law or agreed to in writing, software
* distributed under the License is distributed on an "AS IS" BASIS,
* WITHOUT WARRANTIES OR CONDITIONS OF ANY KIND, either express or implied.
* See the License for the specific language governing permissions and
* limitations under the License.
*
* SPDX-License-Identifier: Apache-2.0

.SUBCKT sky130_fd_sc_hd__lpflow_clkinvkapwr_1 A KAPWR VGND VNB VNB net59 Y
*.PININFO A:I KAPWR:I VGND:I VNB:I VNB:I net59:I Y:O
MMIN0 Y A VGND VNB sky130_fd_pr__nfet_01v8 m=1 w=0.42u l=0.15u mult=1 sa=0.265
+ sb=0.265 sd=0.28 area=0.063 perim=1.14
MMIP0 Y A KAPWR VNB sky130_fd_pr__pfet_01v8_hvt m=2 w=0.84u l=0.15u mult=1 sa=0.265
+ sb=0.265 sd=0.28 area=0.063 perim=1.14
.ENDS sky130_fd_sc_hd__lpflow_clkinvkapwr_1
* Copyright 2020 The SkyWater PDK Authors
*
* Licensed under the Apache License, Version 2.0 (the "License");
* you may not use this file except in compliance with the License.
* You may obtain a copy of the License at
*
*     https:  www.apache.org licenses LICENSE-2.0
*
* Unless required by applicable law or agreed to in writing, software
* distributed under the License is distributed on an "AS IS" BASIS,
* WITHOUT WARRANTIES OR CONDITIONS OF ANY KIND, either express or implied.
* See the License for the specific language governing permissions and
* limitations under the License.
*
* SPDX-License-Identifier: Apache-2.0

.SUBCKT sky130_fd_sc_hd__lpflow_clkinvkapwr_16 A KAPWR VGND VNB VNB net59 Y
*.PININFO A:I KAPWR:I VGND:I VNB:I VNB:I net59:I Y:O
MMIN0 Y A VGND VNB sky130_fd_pr__nfet_01v8 m=16 w=0.42u l=0.15u mult=1 sa=0.265
+ sb=0.265 sd=0.28 area=0.063 perim=1.14
MMIP0 Y A KAPWR VNB sky130_fd_pr__pfet_01v8_hvt m=24 w=1.0u l=0.15u mult=1 sa=0.265
+ sb=0.265 sd=0.28 area=0.063 perim=1.14
.ENDS sky130_fd_sc_hd__lpflow_clkinvkapwr_16
* Copyright 2020 The SkyWater PDK Authors
*
* Licensed under the Apache License, Version 2.0 (the "License");
* you may not use this file except in compliance with the License.
* You may obtain a copy of the License at
*
*     https:  www.apache.org licenses LICENSE-2.0
*
* Unless required by applicable law or agreed to in writing, software
* distributed under the License is distributed on an "AS IS" BASIS,
* WITHOUT WARRANTIES OR CONDITIONS OF ANY KIND, either express or implied.
* See the License for the specific language governing permissions and
* limitations under the License.
*
* SPDX-License-Identifier: Apache-2.0

.SUBCKT sky130_fd_sc_hd__lpflow_clkinvkapwr_2 A KAPWR VGND VNB VNB net59 Y
*.PININFO A:I KAPWR:I VGND:I VNB:I VNB:I net59:I Y:O
MMIN0 Y A VGND VNB sky130_fd_pr__nfet_01v8 m=2 w=0.42u l=0.15u mult=1 sa=0.265
+ sb=0.265 sd=0.28 area=0.063 perim=1.14
MMIP0 Y A KAPWR VNB sky130_fd_pr__pfet_01v8_hvt m=3 w=1.0u l=0.15u mult=1 sa=0.265
+ sb=0.265 sd=0.28 area=0.063 perim=1.14
.ENDS sky130_fd_sc_hd__lpflow_clkinvkapwr_2
* Copyright 2020 The SkyWater PDK Authors
*
* Licensed under the Apache License, Version 2.0 (the "License");
* you may not use this file except in compliance with the License.
* You may obtain a copy of the License at
*
*     https:  www.apache.org licenses LICENSE-2.0
*
* Unless required by applicable law or agreed to in writing, software
* distributed under the License is distributed on an "AS IS" BASIS,
* WITHOUT WARRANTIES OR CONDITIONS OF ANY KIND, either express or implied.
* See the License for the specific language governing permissions and
* limitations under the License.
*
* SPDX-License-Identifier: Apache-2.0

.SUBCKT sky130_fd_sc_hd__lpflow_clkinvkapwr_4 A KAPWR VGND VNB VNB net59 Y
*.PININFO A:I KAPWR:I VGND:I VNB:I VNB:I net59:I Y:O
MMIN0 Y A VGND VNB sky130_fd_pr__nfet_01v8 m=4 w=0.42u l=0.15u mult=1 sa=0.265
+ sb=0.265 sd=0.28 area=0.063 perim=1.14
MMIP0 Y A KAPWR VNB sky130_fd_pr__pfet_01v8_hvt m=6 w=1.0u l=0.15u mult=1 sa=0.265
+ sb=0.265 sd=0.28 area=0.063 perim=1.14
.ENDS sky130_fd_sc_hd__lpflow_clkinvkapwr_4
* Copyright 2020 The SkyWater PDK Authors
*
* Licensed under the Apache License, Version 2.0 (the "License");
* you may not use this file except in compliance with the License.
* You may obtain a copy of the License at
*
*     https:  www.apache.org licenses LICENSE-2.0
*
* Unless required by applicable law or agreed to in writing, software
* distributed under the License is distributed on an "AS IS" BASIS,
* WITHOUT WARRANTIES OR CONDITIONS OF ANY KIND, either express or implied.
* See the License for the specific language governing permissions and
* limitations under the License.
*
* SPDX-License-Identifier: Apache-2.0

.SUBCKT sky130_fd_sc_hd__lpflow_clkinvkapwr_8 A KAPWR VGND VNB VNB net59 Y
*.PININFO A:I KAPWR:I VGND:I VNB:I VNB:I net59:I Y:O
MMIN0 Y A VGND VNB sky130_fd_pr__nfet_01v8 m=8 w=0.42u l=0.15u mult=1 sa=0.265
+ sb=0.265 sd=0.28 area=0.063 perim=1.14
MMIP0 Y A KAPWR VNB sky130_fd_pr__pfet_01v8_hvt m=12 w=1.0u l=0.15u mult=1 sa=0.265
+ sb=0.265 sd=0.28 area=0.063 perim=1.14
.ENDS sky130_fd_sc_hd__lpflow_clkinvkapwr_8
* Copyright 2020 The SkyWater PDK Authors
*
* Licensed under the Apache License, Version 2.0 (the "License");
* you may not use this file except in compliance with the License.
* You may obtain a copy of the License at
*
*     https:  www.apache.org licenses LICENSE-2.0
*
* Unless required by applicable law or agreed to in writing, software
* distributed under the License is distributed on an "AS IS" BASIS,
* WITHOUT WARRANTIES OR CONDITIONS OF ANY KIND, either express or implied.
* See the License for the specific language governing permissions and
* limitations under the License.
*
* SPDX-License-Identifier: Apache-2.0

.SUBCKT sky130_fd_sc_hd__lpflow_decapkapwr_12 KAPWR VGND VNB VNB net59
*.PININFO KAPWR:I VGND:I VNB:I VNB:I net59:I
MI1 VGND KAPWR VGND VNB sky130_fd_pr__nfet_01v8 m=1 w=0.55u l=4.73u mult=1 sa=0.265
+ sb=0.265 sd=0.28 area=0.063 perim=1.14
MI2 KAPWR VGND KAPWR VNB sky130_fd_pr__pfet_01v8_hvt m=1 w=0.87u l=4.73u mult=1
+ sa=0.265 sb=0.265 sd=0.28 area=0.063 perim=1.14
.ENDS sky130_fd_sc_hd__lpflow_decapkapwr_12
* Copyright 2020 The SkyWater PDK Authors
*
* Licensed under the Apache License, Version 2.0 (the "License");
* you may not use this file except in compliance with the License.
* You may obtain a copy of the License at
*
*     https:  www.apache.org licenses LICENSE-2.0
*
* Unless required by applicable law or agreed to in writing, software
* distributed under the License is distributed on an "AS IS" BASIS,
* WITHOUT WARRANTIES OR CONDITIONS OF ANY KIND, either express or implied.
* See the License for the specific language governing permissions and
* limitations under the License.
*
* SPDX-License-Identifier: Apache-2.0

.SUBCKT sky130_fd_sc_hd__lpflow_decapkapwr_3 KAPWR VGND VNB VNB net59
*.PININFO KAPWR:I VGND:I VNB:I VNB:I net59:I
MI1 VGND KAPWR VGND VNB sky130_fd_pr__nfet_01v8 m=1 w=0.55u l=0.59u mult=1 sa=0.265
+ sb=0.265 sd=0.28 area=0.063 perim=1.14
MI2 KAPWR VGND KAPWR VNB sky130_fd_pr__pfet_01v8_hvt m=1 w=0.87u l=0.59u mult=1
+ sa=0.265 sb=0.265 sd=0.28 area=0.063 perim=1.14
.ENDS sky130_fd_sc_hd__lpflow_decapkapwr_3
* Copyright 2020 The SkyWater PDK Authors
*
* Licensed under the Apache License, Version 2.0 (the "License");
* you may not use this file except in compliance with the License.
* You may obtain a copy of the License at
*
*     https:  www.apache.org licenses LICENSE-2.0
*
* Unless required by applicable law or agreed to in writing, software
* distributed under the License is distributed on an "AS IS" BASIS,
* WITHOUT WARRANTIES OR CONDITIONS OF ANY KIND, either express or implied.
* See the License for the specific language governing permissions and
* limitations under the License.
*
* SPDX-License-Identifier: Apache-2.0

.SUBCKT sky130_fd_sc_hd__lpflow_decapkapwr_4 KAPWR VGND VNB VNB net59
*.PININFO KAPWR:I VGND:I VNB:I VNB:I net59:I
MI1 VGND KAPWR VGND VNB sky130_fd_pr__nfet_01v8 m=1 w=0.55u l=1.05u mult=1 sa=0.265
+ sb=0.265 sd=0.28 area=0.063 perim=1.14
MI2 KAPWR VGND KAPWR VNB sky130_fd_pr__pfet_01v8_hvt m=1 w=0.87u l=1.05u mult=1
+ sa=0.265 sb=0.265 sd=0.28 area=0.063 perim=1.14
.ENDS sky130_fd_sc_hd__lpflow_decapkapwr_4
* Copyright 2020 The SkyWater PDK Authors
*
* Licensed under the Apache License, Version 2.0 (the "License");
* you may not use this file except in compliance with the License.
* You may obtain a copy of the License at
*
*     https:  www.apache.org licenses LICENSE-2.0
*
* Unless required by applicable law or agreed to in writing, software
* distributed under the License is distributed on an "AS IS" BASIS,
* WITHOUT WARRANTIES OR CONDITIONS OF ANY KIND, either express or implied.
* See the License for the specific language governing permissions and
* limitations under the License.
*
* SPDX-License-Identifier: Apache-2.0

.SUBCKT sky130_fd_sc_hd__lpflow_decapkapwr_6 KAPWR VGND VNB VNB net59
*.PININFO KAPWR:I VGND:I VNB:I VNB:I net59:I
MI1 VGND KAPWR VGND VNB sky130_fd_pr__nfet_01v8 m=1 w=0.55u l=1.97u mult=1 sa=0.265
+ sb=0.265 sd=0.28 area=0.063 perim=1.14
MI2 KAPWR VGND KAPWR VNB sky130_fd_pr__pfet_01v8_hvt m=1 w=0.87u l=1.97u mult=1
+ sa=0.265 sb=0.265 sd=0.28 area=0.063 perim=1.14
.ENDS sky130_fd_sc_hd__lpflow_decapkapwr_6
* Copyright 2020 The SkyWater PDK Authors
*
* Licensed under the Apache License, Version 2.0 (the "License");
* you may not use this file except in compliance with the License.
* You may obtain a copy of the License at
*
*     https:  www.apache.org licenses LICENSE-2.0
*
* Unless required by applicable law or agreed to in writing, software
* distributed under the License is distributed on an "AS IS" BASIS,
* WITHOUT WARRANTIES OR CONDITIONS OF ANY KIND, either express or implied.
* See the License for the specific language governing permissions and
* limitations under the License.
*
* SPDX-License-Identifier: Apache-2.0

.SUBCKT sky130_fd_sc_hd__lpflow_decapkapwr_8 KAPWR VGND VNB VNB net59
*.PININFO KAPWR:I VGND:I VNB:I VNB:I net59:I
MI1 VGND KAPWR VGND VNB sky130_fd_pr__nfet_01v8 m=1 w=0.55u l=2.89u mult=1 sa=0.265
+ sb=0.265 sd=0.28 area=0.063 perim=1.14
MI2 KAPWR VGND KAPWR VNB sky130_fd_pr__pfet_01v8_hvt m=1 w=0.87u l=2.89u mult=1
+ sa=0.265 sb=0.265 sd=0.28 area=0.063 perim=1.14
.ENDS sky130_fd_sc_hd__lpflow_decapkapwr_8
* Copyright 2020 The SkyWater PDK Authors
*
* Licensed under the Apache License, Version 2.0 (the "License");
* you may not use this file except in compliance with the License.
* You may obtain a copy of the License at
*
*     https:  www.apache.org licenses LICENSE-2.0
*
* Unless required by applicable law or agreed to in writing, software
* distributed under the License is distributed on an "AS IS" BASIS,
* WITHOUT WARRANTIES OR CONDITIONS OF ANY KIND, either express or implied.
* See the License for the specific language governing permissions and
* limitations under the License.
*
* SPDX-License-Identifier: Apache-2.0

.SUBCKT sky130_fd_sc_hd__lpflow_inputiso0n_1 A SLEEP_B VGND VNB VNB net59 X
*.PININFO A:I SLEEP_B:I VGND:I VNB:I VNB:I net59:I X:O
MI14 X net36 VGND VNB sky130_fd_pr__nfet_01v8 m=1 w=0.65u l=0.15u mult=1 sa=0.265
+ sb=0.265 sd=0.28 area=0.063 perim=1.14
MMN0 net36 A sndA VNB sky130_fd_pr__nfet_01v8 m=1 w=0.42u l=0.15u mult=1 sa=0.265
+ sb=0.265 sd=0.28 area=0.063 perim=1.14
MI13 sndA SLEEP_B VGND VNB sky130_fd_pr__nfet_01v8 m=1 w=0.42u l=0.15u mult=1 sa=0.265
+ sb=0.265 sd=0.28 area=0.063 perim=1.14
MMP1 net36 SLEEP_B net59 VNB sky130_fd_pr__pfet_01v8_hvt m=1 w=0.42u l=0.15u mult=1
+ sa=0.265 sb=0.265 sd=0.28 area=0.063 perim=1.14
MI19 X net36 net59 VNB sky130_fd_pr__pfet_01v8_hvt m=1 w=1.0u l=0.15u mult=1 sa=0.265
+ sb=0.265 sd=0.28 area=0.063 perim=1.14
MI17 net36 A net59 VNB sky130_fd_pr__pfet_01v8_hvt m=1 w=0.42u l=0.15u mult=1 sa=0.265
+ sb=0.265 sd=0.28 area=0.063 perim=1.14
.ENDS sky130_fd_sc_hd__lpflow_inputiso0n_1
* Copyright 2020 The SkyWater PDK Authors
*
* Licensed under the Apache License, Version 2.0 (the "License");
* you may not use this file except in compliance with the License.
* You may obtain a copy of the License at
*
*     https:  www.apache.org licenses LICENSE-2.0
*
* Unless required by applicable law or agreed to in writing, software
* distributed under the License is distributed on an "AS IS" BASIS,
* WITHOUT WARRANTIES OR CONDITIONS OF ANY KIND, either express or implied.
* See the License for the specific language governing permissions and
* limitations under the License.
*
* SPDX-License-Identifier: Apache-2.0

.SUBCKT sky130_fd_sc_hd__lpflow_inputiso0p_1 A SLEEP VGND VNB VNB net59 X
*.PININFO A:I SLEEP:I VGND:I VNB:I VNB:I net59:I X:O
MI8 net36 A net59 VNB sky130_fd_pr__pfet_01v8_hvt m=1 w=0.42u l=0.15u mult=1 sa=0.265
+ sb=0.265 sd=0.28 area=0.063 perim=1.14
MI7 net36 sleepb net59 VNB sky130_fd_pr__pfet_01v8_hvt m=1 w=0.42u l=0.15u mult=1
+ sa=0.265 sb=0.265 sd=0.28 area=0.063 perim=1.14
MI20 X net36 net59 VNB sky130_fd_pr__pfet_01v8_hvt m=1 w=1.0u l=0.15u mult=1 sa=0.265
+ sb=0.265 sd=0.28 area=0.063 perim=1.14
MI19 sleepb SLEEP net59 VNB sky130_fd_pr__pfet_01v8_hvt m=1 w=0.42u l=0.15u mult=1
+ sa=0.265 sb=0.265 sd=0.28 area=0.063 perim=1.14
MI10 net36 sleepb sndA VNB sky130_fd_pr__nfet_01v8 m=1 w=0.42u l=0.15u mult=1 sa=0.265
+ sb=0.265 sd=0.28 area=0.063 perim=1.14
MI21 X net36 VGND VNB sky130_fd_pr__nfet_01v8 m=1 w=0.65u l=0.15u mult=1 sa=0.265
+ sb=0.265 sd=0.28 area=0.063 perim=1.14
MI18 sleepb SLEEP VGND VNB sky130_fd_pr__nfet_01v8 m=1 w=0.42u l=0.15u mult=1 sa=0.265
+ sb=0.265 sd=0.28 area=0.063 perim=1.14
MI11 sndA A VGND VNB sky130_fd_pr__nfet_01v8 m=1 w=0.42u l=0.15u mult=1 sa=0.265
+ sb=0.265 sd=0.28 area=0.063 perim=1.14
.ENDS sky130_fd_sc_hd__lpflow_inputiso0p_1
* Copyright 2020 The SkyWater PDK Authors
*
* Licensed under the Apache License, Version 2.0 (the "License");
* you may not use this file except in compliance with the License.
* You may obtain a copy of the License at
*
*     https:  www.apache.org licenses LICENSE-2.0
*
* Unless required by applicable law or agreed to in writing, software
* distributed under the License is distributed on an "AS IS" BASIS,
* WITHOUT WARRANTIES OR CONDITIONS OF ANY KIND, either express or implied.
* See the License for the specific language governing permissions and
* limitations under the License.
*
* SPDX-License-Identifier: Apache-2.0

.SUBCKT sky130_fd_sc_hd__lpflow_inputiso1n_1 A SLEEP_B VGND VNB VNB net59 X
*.PININFO A:I SLEEP_B:I VGND:I VNB:I VNB:I net59:I X:O
MI23 net59 A sndPA VNB sky130_fd_pr__pfet_01v8_hvt m=1 w=0.42u l=0.15u mult=1 sa=0.265
+ sb=0.265 sd=0.28 area=0.063 perim=1.14
MI8 net59 net44 X VNB sky130_fd_pr__pfet_01v8_hvt m=1 w=1.0u l=0.15u mult=1 sa=0.265
+ sb=0.265 sd=0.28 area=0.063 perim=1.14
MMIP0 net56 SLEEP_B net59 VNB sky130_fd_pr__pfet_01v8_hvt m=1 w=0.42u l=0.15u mult=1
+ sa=0.265 sb=0.265 sd=0.28 area=0.063 perim=1.14
MI7 sndPA net56 net44 VNB sky130_fd_pr__pfet_01v8_hvt m=1 w=0.42u l=0.15u mult=1
+ sa=0.265 sb=0.265 sd=0.28 area=0.063 perim=1.14
MMIN0 net56 SLEEP_B VGND VNB sky130_fd_pr__nfet_01v8 m=1 w=0.42u l=0.15u mult=1
+ sa=0.265 sb=0.265 sd=0.28 area=0.063 perim=1.14
MI25 net44 A VGND VNB sky130_fd_pr__nfet_01v8 m=1 w=0.42u l=0.15u mult=1 sa=0.265
+ sb=0.265 sd=0.28 area=0.063 perim=1.14
MMIN2 X net44 VGND VNB sky130_fd_pr__nfet_01v8 m=1 w=0.65u l=0.15u mult=1 sa=0.265
+ sb=0.265 sd=0.28 area=0.063 perim=1.14
MI9 net44 net56 VGND VNB sky130_fd_pr__nfet_01v8 m=1 w=0.42u l=0.15u mult=1 sa=0.265
+ sb=0.265 sd=0.28 area=0.063 perim=1.14
.ENDS sky130_fd_sc_hd__lpflow_inputiso1n_1
* Copyright 2020 The SkyWater PDK Authors
*
* Licensed under the Apache License, Version 2.0 (the "License");
* you may not use this file except in compliance with the License.
* You may obtain a copy of the License at
*
*     https:  www.apache.org licenses LICENSE-2.0
*
* Unless required by applicable law or agreed to in writing, software
* distributed under the License is distributed on an "AS IS" BASIS,
* WITHOUT WARRANTIES OR CONDITIONS OF ANY KIND, either express or implied.
* See the License for the specific language governing permissions and
* limitations under the License.
*
* SPDX-License-Identifier: Apache-2.0

.SUBCKT sky130_fd_sc_hd__lpflow_inputiso1p_1 A SLEEP VGND VNB VNB net59 X
*.PININFO A:I SLEEP:I VGND:I VNB:I VNB:I net59:I X:O
MMP0 net59 SLEEP sndPA VNB sky130_fd_pr__pfet_01v8_hvt m=1 w=0.42u l=0.15u mult=1
+ sa=0.265 sb=0.265 sd=0.28 area=0.063 perim=1.14
MI7 sndPA A net36 VNB sky130_fd_pr__pfet_01v8_hvt m=1 w=0.42u l=0.15u mult=1 sa=0.265
+ sb=0.265 sd=0.28 area=0.063 perim=1.14
MI15 net59 net36 X VNB sky130_fd_pr__pfet_01v8_hvt m=1 w=1.0u l=0.15u mult=1 sa=0.265
+ sb=0.265 sd=0.28 area=0.063 perim=1.14
MI10 net36 A VGND VNB sky130_fd_pr__nfet_01v8 m=1 w=0.42u l=0.15u mult=1 sa=0.265
+ sb=0.265 sd=0.28 area=0.063 perim=1.14
MI16 net36 SLEEP VGND VNB sky130_fd_pr__nfet_01v8 m=1 w=0.42u l=0.15u mult=1 sa=0.265
+ sb=0.265 sd=0.28 area=0.063 perim=1.14
MI14 X net36 VGND VNB sky130_fd_pr__nfet_01v8 m=1 w=0.65u l=0.15u mult=1 sa=0.265
+ sb=0.265 sd=0.28 area=0.063 perim=1.14
.ENDS sky130_fd_sc_hd__lpflow_inputiso1p_1
* Copyright 2020 The SkyWater PDK Authors
*
* Licensed under the Apache License, Version 2.0 (the "License");
* you may not use this file except in compliance with the License.
* You may obtain a copy of the License at
*
*     https:  www.apache.org licenses LICENSE-2.0
*
* Unless required by applicable law or agreed to in writing, software
* distributed under the License is distributed on an "AS IS" BASIS,
* WITHOUT WARRANTIES OR CONDITIONS OF ANY KIND, either express or implied.
* See the License for the specific language governing permissions and
* limitations under the License.
*
* SPDX-License-Identifier: Apache-2.0

.SUBCKT sky130_fd_sc_hd__lpflow_inputisolatch_1 D SLEEP_B VGND VNB VNB net59 Q
*.PININFO D:I SLEEP_B:I VGND:I VNB:I VNB:I net59:I Q:O
MI677 Q s0 VGND VNB sky130_fd_pr__nfet_01v8 m=1 w=0.65u l=0.15u mult=1 sa=0.265
+ sb=0.265 sd=0.28 area=0.063 perim=1.14
MI636 sleepneg sleeppos VGND VNB sky130_fd_pr__nfet_01v8 m=1 w=0.42u l=0.15u mult=1
+ sa=0.265 sb=0.265 sd=0.28 area=0.063 perim=1.14
MI674 net39 s0 VGND VNB sky130_fd_pr__nfet_01v8 m=1 w=0.65u l=0.15u mult=1 sa=0.265
+ sb=0.265 sd=0.28 area=0.063 perim=1.14
MI19 s0 sleepneg net49 VNB sky130_fd_pr__nfet_01v8 m=1 w=0.36u l=0.15u mult=1 sa=0.265
+ sb=0.265 sd=0.28 area=0.063 perim=1.14
MI20 net49 D VGND VNB sky130_fd_pr__nfet_01v8 m=1 w=0.42u l=0.15u mult=1 sa=0.265
+ sb=0.265 sd=0.28 area=0.063 perim=1.14
MI655 s0 sleeppos net38 VNB sky130_fd_pr__nfet_01v8 m=1 w=0.36u l=0.15u mult=1
+ sa=0.265 sb=0.265 sd=0.28 area=0.063 perim=1.14
MI654 net38 net39 VGND VNB sky130_fd_pr__nfet_01v8 m=1 w=0.36u l=0.15u mult=1 sa=0.265
+ sb=0.265 sd=0.28 area=0.063 perim=1.14
MI670 sleeppos SLEEP_B VGND VNB sky130_fd_pr__nfet_01v8 m=1 w=0.42u l=0.15u mult=1
+ sa=0.265 sb=0.265 sd=0.28 area=0.063 perim=1.14
MI643 sleeppos SLEEP_B net59 VNB sky130_fd_pr__pfet_01v8_hvt m=1 w=0.55u l=0.15u mult=1
+ sa=0.265 sb=0.265 sd=0.28 area=0.063 perim=1.14
MI635 sleepneg sleeppos net59 VNB sky130_fd_pr__pfet_01v8_hvt m=1 w=0.55u l=0.15u
+ mult=1 sa=0.265 sb=0.265 sd=0.28 area=0.063
+ perim=1.14
MI662 net86 net39 net59 VNB sky130_fd_pr__pfet_01v8_hvt m=1 w=0.42u l=0.15u mult=1
+ sa=0.265 sb=0.265 sd=0.28 area=0.063 perim=1.14
MI664 s0 sleepneg net86 VNB sky130_fd_pr__pfet_01v8_hvt m=1 w=0.42u l=0.15u mult=1
+ sa=0.265 sb=0.265 sd=0.28 area=0.063 perim=1.14
MI658 net39 s0 net59 VNB sky130_fd_pr__pfet_01v8_hvt m=1 w=1.0u l=0.15u mult=1 sa=0.265
+ sb=0.265 sd=0.28 area=0.063 perim=1.14
MI663 Q s0 net59 VNB sky130_fd_pr__pfet_01v8_hvt m=1 w=1.0u l=0.15u mult=1 sa=0.265
+ sb=0.265 sd=0.28 area=0.063 perim=1.14
MI17 s0 sleeppos net69 VNB sky130_fd_pr__pfet_01v8_hvt m=1 w=0.42u l=0.15u mult=1
+ sa=0.265 sb=0.265 sd=0.28 area=0.063 perim=1.14
MI18 net69 D net59 VNB sky130_fd_pr__pfet_01v8_hvt m=1 w=0.64u l=0.15u mult=1 sa=0.265
+ sb=0.265 sd=0.28 area=0.063 perim=1.14
.ENDS sky130_fd_sc_hd__lpflow_inputisolatch_1
* Copyright 2020 The SkyWater PDK Authors
*
* Licensed under the Apache License, Version 2.0 (the "License");
* you may not use this file except in compliance with the License.
* You may obtain a copy of the License at
*
*     https:  www.apache.org licenses LICENSE-2.0
*
* Unless required by applicable law or agreed to in writing, software
* distributed under the License is distributed on an "AS IS" BASIS,
* WITHOUT WARRANTIES OR CONDITIONS OF ANY KIND, either express or implied.
* See the License for the specific language governing permissions and
* limitations under the License.
*
* SPDX-License-Identifier: Apache-2.0

.SUBCKT sky130_fd_sc_hd__lpflow_isobufsrc_1 A SLEEP VGND VNB VNB net59 X
*.PININFO A:I SLEEP:I VGND:I VNB:I VNB:I net59:I X:O
MMP0 net59 SLEEP sndPA VNB sky130_fd_pr__pfet_01v8_hvt m=1 w=1.0u l=0.15u mult=1
+ sa=0.265 sb=0.265 sd=0.28 area=0.063 perim=1.14
MMP1 sndPA Ab X VNB sky130_fd_pr__pfet_01v8_hvt m=1 w=1.0u l=0.15u mult=1 sa=0.265
+ sb=0.265 sd=0.28 area=0.063 perim=1.14
MMIP1 Ab A net59 VNB sky130_fd_pr__pfet_01v8_hvt m=1 w=0.42u l=0.15u mult=1 sa=0.265
+ sb=0.265 sd=0.28 area=0.063 perim=1.14
MMN0 X SLEEP VGND VNB sky130_fd_pr__nfet_01v8 m=1 w=0.65u l=0.15u mult=1 sa=0.265
+ sb=0.265 sd=0.28 area=0.063 perim=1.14
MMN1 X Ab VGND VNB sky130_fd_pr__nfet_01v8 m=1 w=0.65u l=0.15u mult=1 sa=0.265
+ sb=0.265 sd=0.28 area=0.063 perim=1.14
MMIN1 Ab A VGND VNB sky130_fd_pr__nfet_01v8 m=1 w=0.42u l=0.15u mult=1 sa=0.265
+ sb=0.265 sd=0.28 area=0.063 perim=1.14
.ENDS sky130_fd_sc_hd__lpflow_isobufsrc_1
* Copyright 2020 The SkyWater PDK Authors
*
* Licensed under the Apache License, Version 2.0 (the "License");
* you may not use this file except in compliance with the License.
* You may obtain a copy of the License at
*
*     https:  www.apache.org licenses LICENSE-2.0
*
* Unless required by applicable law or agreed to in writing, software
* distributed under the License is distributed on an "AS IS" BASIS,
* WITHOUT WARRANTIES OR CONDITIONS OF ANY KIND, either express or implied.
* See the License for the specific language governing permissions and
* limitations under the License.
*
* SPDX-License-Identifier: Apache-2.0

.SUBCKT sky130_fd_sc_hd__lpflow_isobufsrc_16 A SLEEP VGND VNB VNB net59 X
*.PININFO A:I SLEEP:I VGND:I VNB:I VNB:I net59:I X:O
MMP0 net59 Ab sndPA VNB sky130_fd_pr__pfet_01v8_hvt m=16 w=1.0u l=0.15u mult=1 sa=0.265
+ sb=0.265 sd=0.28 area=0.063 perim=1.14
MMP1 sndPA SLEEP X VNB sky130_fd_pr__pfet_01v8_hvt m=16 w=1.0u l=0.15u mult=1 sa=0.265
+ sb=0.265 sd=0.28 area=0.063 perim=1.14
MMIP1 Ab A net59 VNB sky130_fd_pr__pfet_01v8_hvt m=4 w=1.0u l=0.15u mult=1 sa=0.265
+ sb=0.265 sd=0.28 area=0.063 perim=1.14
MMN0 X SLEEP VGND VNB sky130_fd_pr__nfet_01v8 m=16 w=0.65u l=0.15u mult=1 sa=0.265
+ sb=0.265 sd=0.28 area=0.063 perim=1.14
MMN1 X Ab VGND VNB sky130_fd_pr__nfet_01v8 m=16 w=0.65u l=0.15u mult=1 sa=0.265
+ sb=0.265 sd=0.28 area=0.063 perim=1.14
MMIN1 Ab A VGND VNB sky130_fd_pr__nfet_01v8 m=4 w=0.65u l=0.15u mult=1 sa=0.265
+ sb=0.265 sd=0.28 area=0.063 perim=1.14
.ENDS sky130_fd_sc_hd__lpflow_isobufsrc_16
* Copyright 2020 The SkyWater PDK Authors
*
* Licensed under the Apache License, Version 2.0 (the "License");
* you may not use this file except in compliance with the License.
* You may obtain a copy of the License at
*
*     https:  www.apache.org licenses LICENSE-2.0
*
* Unless required by applicable law or agreed to in writing, software
* distributed under the License is distributed on an "AS IS" BASIS,
* WITHOUT WARRANTIES OR CONDITIONS OF ANY KIND, either express or implied.
* See the License for the specific language governing permissions and
* limitations under the License.
*
* SPDX-License-Identifier: Apache-2.0

.SUBCKT sky130_fd_sc_hd__lpflow_isobufsrc_2 A SLEEP VGND VNB VNB net59 X
*.PININFO A:I SLEEP:I VGND:I VNB:I VNB:I net59:I X:O
MMP0 net59 SLEEP sndPA VNB sky130_fd_pr__pfet_01v8_hvt m=2 w=1.0u l=0.15u mult=1
+ sa=0.265 sb=0.265 sd=0.28 area=0.063 perim=1.14
MMP1 sndPA Ab X VNB sky130_fd_pr__pfet_01v8_hvt m=2 w=1.0u l=0.15u mult=1 sa=0.265
+ sb=0.265 sd=0.28 area=0.063 perim=1.14
MMIP1 Ab A net59 VNB sky130_fd_pr__pfet_01v8_hvt m=1 w=0.42u l=0.15u mult=1 sa=0.265
+ sb=0.265 sd=0.28 area=0.063 perim=1.14
MMN0 X SLEEP VGND VNB sky130_fd_pr__nfet_01v8 m=2 w=0.65u l=0.15u mult=1 sa=0.265
+ sb=0.265 sd=0.28 area=0.063 perim=1.14
MMN1 X Ab VGND VNB sky130_fd_pr__nfet_01v8 m=2 w=0.65u l=0.15u mult=1 sa=0.265
+ sb=0.265 sd=0.28 area=0.063 perim=1.14
MMIN1 Ab A VGND VNB sky130_fd_pr__nfet_01v8 m=1 w=0.42u l=0.15u mult=1 sa=0.265
+ sb=0.265 sd=0.28 area=0.063 perim=1.14
.ENDS sky130_fd_sc_hd__lpflow_isobufsrc_2
* Copyright 2020 The SkyWater PDK Authors
*
* Licensed under the Apache License, Version 2.0 (the "License");
* you may not use this file except in compliance with the License.
* You may obtain a copy of the License at
*
*     https:  www.apache.org licenses LICENSE-2.0
*
* Unless required by applicable law or agreed to in writing, software
* distributed under the License is distributed on an "AS IS" BASIS,
* WITHOUT WARRANTIES OR CONDITIONS OF ANY KIND, either express or implied.
* See the License for the specific language governing permissions and
* limitations under the License.
*
* SPDX-License-Identifier: Apache-2.0

.SUBCKT sky130_fd_sc_hd__lpflow_isobufsrc_4 A SLEEP VGND VNB VNB net59 X
*.PININFO A:I SLEEP:I VGND:I VNB:I VNB:I net59:I X:O
MMP0 net59 SLEEP sndPA VNB sky130_fd_pr__pfet_01v8_hvt m=4 w=1.0u l=0.15u mult=1
+ sa=0.265 sb=0.265 sd=0.28 area=0.063 perim=1.14
MMP1 sndPA Ab X VNB sky130_fd_pr__pfet_01v8_hvt m=4 w=1.0u l=0.15u mult=1 sa=0.265
+ sb=0.265 sd=0.28 area=0.063 perim=1.14
MMIP1 Ab A net59 VNB sky130_fd_pr__pfet_01v8_hvt m=1 w=1.0u l=0.15u mult=1 sa=0.265
+ sb=0.265 sd=0.28 area=0.063 perim=1.14
MMN0 X SLEEP VGND VNB sky130_fd_pr__nfet_01v8 m=4 w=0.65u l=0.15u mult=1 sa=0.265
+ sb=0.265 sd=0.28 area=0.063 perim=1.14
MMN1 X Ab VGND VNB sky130_fd_pr__nfet_01v8 m=4 w=0.65u l=0.15u mult=1 sa=0.265
+ sb=0.265 sd=0.28 area=0.063 perim=1.14
MMIN1 Ab A VGND VNB sky130_fd_pr__nfet_01v8 m=1 w=0.65u l=0.15u mult=1 sa=0.265
+ sb=0.265 sd=0.28 area=0.063 perim=1.14
.ENDS sky130_fd_sc_hd__lpflow_isobufsrc_4
* Copyright 2020 The SkyWater PDK Authors
*
* Licensed under the Apache License, Version 2.0 (the "License");
* you may not use this file except in compliance with the License.
* You may obtain a copy of the License at
*
*     https:  www.apache.org licenses LICENSE-2.0
*
* Unless required by applicable law or agreed to in writing, software
* distributed under the License is distributed on an "AS IS" BASIS,
* WITHOUT WARRANTIES OR CONDITIONS OF ANY KIND, either express or implied.
* See the License for the specific language governing permissions and
* limitations under the License.
*
* SPDX-License-Identifier: Apache-2.0

.SUBCKT sky130_fd_sc_hd__lpflow_isobufsrc_8 A SLEEP VGND VNB VNB net59 X
*.PININFO A:I SLEEP:I VGND:I VNB:I VNB:I net59:I X:O
MMP0 net59 Ab sndPA VNB sky130_fd_pr__pfet_01v8_hvt m=8 w=1.0u l=0.15u mult=1 sa=0.265
+ sb=0.265 sd=0.28 area=0.063 perim=1.14
MMP1 sndPA SLEEP X VNB sky130_fd_pr__pfet_01v8_hvt m=8 w=1.0u l=0.15u mult=1 sa=0.265
+ sb=0.265 sd=0.28 area=0.063 perim=1.14
MMIP1 Ab A net59 VNB sky130_fd_pr__pfet_01v8_hvt m=2 w=1.0u l=0.15u mult=1 sa=0.265
+ sb=0.265 sd=0.28 area=0.063 perim=1.14
MMN0 X SLEEP VGND VNB sky130_fd_pr__nfet_01v8 m=8 w=0.65u l=0.15u mult=1 sa=0.265
+ sb=0.265 sd=0.28 area=0.063 perim=1.14
MMN1 X Ab VGND VNB sky130_fd_pr__nfet_01v8 m=8 w=0.65u l=0.15u mult=1 sa=0.265
+ sb=0.265 sd=0.28 area=0.063 perim=1.14
MMIN1 Ab A VGND VNB sky130_fd_pr__nfet_01v8 m=2 w=0.65u l=0.15u mult=1 sa=0.265
+ sb=0.265 sd=0.28 area=0.063 perim=1.14
.ENDS sky130_fd_sc_hd__lpflow_isobufsrc_8
* Copyright 2020 The SkyWater PDK Authors
*
* Licensed under the Apache License, Version 2.0 (the "License");
* you may not use this file except in compliance with the License.
* You may obtain a copy of the License at
*
*     https:  www.apache.org licenses LICENSE-2.0
*
* Unless required by applicable law or agreed to in writing, software
* distributed under the License is distributed on an "AS IS" BASIS,
* WITHOUT WARRANTIES OR CONDITIONS OF ANY KIND, either express or implied.
* See the License for the specific language governing permissions and
* limitations under the License.
*
* SPDX-License-Identifier: Apache-2.0

.SUBCKT sky130_fd_sc_hd__lpflow_isobufsrckapwr_16 A SLEEP KAPWR VGND VNB VNB net59 X
*.PININFO A:I SLEEP:I KAPWR:I VGND:I VNB:I VNB:I net59:I X:O
MMP0 net59 SLEEP sndPA VNB sky130_fd_pr__pfet_01v8_hvt m=4 w=1.0u l=0.15u mult=1
+ sa=0.265 sb=0.265 sd=0.28 area=0.063 perim=1.14
MMP1 sndPA net58 net66 VNB sky130_fd_pr__pfet_01v8_hvt m=4 w=1.0u l=0.15u mult=1
+ sa=0.265 sb=0.265 sd=0.28 area=0.063 perim=1.14
MMIP1 net58 A net59 VNB sky130_fd_pr__pfet_01v8_hvt m=1 w=1.0u l=0.15u mult=1 sa=0.265
+ sb=0.265 sd=0.28 area=0.063 perim=1.14
MMIP0 Ab net66 KAPWR VNB sky130_fd_pr__pfet_01v8_hvt m=4 w=1.0u l=0.15u mult=1
+ sa=0.265 sb=0.265 sd=0.28 area=0.063 perim=1.14
MI9 X Ab KAPWR VNB sky130_fd_pr__pfet_01v8_hvt m=16 w=1.0u l=0.15u mult=1 sa=0.265
+ sb=0.265 sd=0.28 area=0.063 perim=1.14
MMN0 net66 SLEEP VGND VNB sky130_fd_pr__nfet_01v8 m=4 w=0.65u l=0.15u mult=1 sa=0.265
+ sb=0.265 sd=0.28 area=0.063 perim=1.14
MMN1 net66 net58 VGND VNB sky130_fd_pr__nfet_01v8 m=4 w=0.65u l=0.15u mult=1 sa=0.265
+ sb=0.265 sd=0.28 area=0.063 perim=1.14
MMIN1 net58 A VGND VNB sky130_fd_pr__nfet_01v8 m=1 w=0.65u l=0.15u mult=1 sa=0.265
+ sb=0.265 sd=0.28 area=0.063 perim=1.14
MMIN0 Ab net66 VGND VNB sky130_fd_pr__nfet_01v8 m=4 w=0.42u l=0.15u mult=1 sa=0.265
+ sb=0.265 sd=0.28 area=0.063 perim=1.14
MI8 X Ab VGND VNB sky130_fd_pr__nfet_01v8 m=16 w=0.42u l=0.15u mult=1 sa=0.265
+ sb=0.265 sd=0.28 area=0.063 perim=1.14
.ENDS sky130_fd_sc_hd__lpflow_isobufsrckapwr_16
* Copyright 2020 The SkyWater PDK Authors
*
* Licensed under the Apache License, Version 2.0 (the "License");
* you may not use this file except in compliance with the License.
* You may obtain a copy of the License at
*
*     https:  www.apache.org licenses LICENSE-2.0
*
* Unless required by applicable law or agreed to in writing, software
* distributed under the License is distributed on an "AS IS" BASIS,
* WITHOUT WARRANTIES OR CONDITIONS OF ANY KIND, either express or implied.
* See the License for the specific language governing permissions and
* limitations under the License.
*
* SPDX-License-Identifier: Apache-2.0

.SUBCKT sky130_fd_sc_hd__lpflow_lsbuf_lh_hl_isowell_tap_1 A VGND VNB VPWRIN net59 X
*.PININFO A:I VGND:I VNB:I VPWRIN:I net59:I X:O
M1000 X a_1028_32# net59 VNB sky130_fd_pr__pfet_01v8_hvt w=790000u l=150000u
+ ad=2.1725e+11p pd=2.13e+06u as=4.7795e+11p ps=4.37e+06u
M1001 net59 a_620_911# a_714_58# VNB sky130_fd_pr__pfet_01v8_hvt w=790000u l=150000u
+ ad=0p pd=0u as=2.1725e+11p ps=2.13e+06u
M1002 a_1028_32# a_620_911# net59 VNB sky130_fd_pr__pfet_01v8_hvt w=790000u l=150000u
+ ad=2.133e+11p pd=2.12e+06u as=0p ps=0u
M1003 X a_1028_32# VGND VGND sky130_fd_pr__nfet_01v8 w=650000u l=150000u
+ ad=1.8525e+11p pd=1.87e+06u as=1.4178e+12p ps=1.319e+07u
M1004 a_620_911# a_505_297# VGND VGND sky130_fd_pr__nfet_01v8 w=650000u l=150000u
+ ad=3.64e+11p pd=3.72e+06u as=0p ps=0u
M1005 a_714_58# A VGND VGND sky130_fd_pr__nfet_01v8 w=650000u l=150000u ad=3.64e+11p
+ pd=3.72e+06u as=0p ps=0u
M1006 a_714_58# A VGND VGND sky130_fd_pr__nfet_01v8 w=650000u l=150000u ad=0p pd=0u
+ as=0p ps=0u
M1007 VGND a_505_297# a_620_911# VGND sky130_fd_pr__nfet_01v8 w=650000u l=150000u
+ ad=0p pd=0u as=0p ps=0u
M1008 a_1028_32# a_620_911# VGND VGND sky130_fd_pr__nfet_01v8 w=650000u l=150000u
+ ad=1.7225e+11p pd=1.83e+06u as=0p ps=0u
M1009 a_505_297# A VPWRIN VPWRIN sky130_fd_pr__pfet_01v8_hvt w=1e+06u l=150000u
+ ad=2.75e+11p pd=2.55e+06u as=2.75e+11p ps=2.55e+06u
M1010 a_505_297# A VGND VGND sky130_fd_pr__nfet_01v8 w=420000u l=150000u
+ ad=1.113e+11p pd=1.37e+06u as=0p ps=0u
M1011 VGND A a_714_58# VGND sky130_fd_pr__nfet_01v8 w=650000u l=150000u ad=0p pd=0u
+ as=0p ps=0u
M1012 VGND A a_714_58# VGND sky130_fd_pr__nfet_01v8 w=650000u l=150000u ad=0p pd=0u
+ as=0p ps=0u
M1013 VGND a_505_297# a_620_911# VGND sky130_fd_pr__nfet_01v8 w=650000u l=150000u
+ ad=0p pd=0u as=0p ps=0u
M1014 a_620_911# a_505_297# VGND VGND sky130_fd_pr__nfet_01v8 w=650000u l=150000u
+ ad=0p pd=0u as=0p ps=0u
M1015 net59 a_714_58# a_620_911# VNB sky130_fd_pr__pfet_01v8_hvt w=790000u l=150000u
+ ad=0p pd=0u as=2.1725e+11p ps=2.13e+06u
.ENDS sky130_fd_sc_hd__lpflow_lsbuf_lh_hl_isowell_tap_1
* Copyright 2020 The SkyWater PDK Authors
*
* Licensed under the Apache License, Version 2.0 (the "License");
* you may not use this file except in compliance with the License.
* You may obtain a copy of the License at
*
*     https:  www.apache.org licenses LICENSE-2.0
*
* Unless required by applicable law or agreed to in writing, software
* distributed under the License is distributed on an "AS IS" BASIS,
* WITHOUT WARRANTIES OR CONDITIONS OF ANY KIND, either express or implied.
* See the License for the specific language governing permissions and
* limitations under the License.
*
* SPDX-License-Identifier: Apache-2.0

.SUBCKT sky130_fd_sc_hd__lpflow_lsbuf_lh_hl_isowell_tap_2 A VGND VNB VPWRIN net59 X
*.PININFO A:I VGND:I VNB:I VPWRIN:I net59:I X:O
M1000 net59 a_620_911# a_714_47# VNB sky130_fd_pr__pfet_01v8_hvt w=790000u l=150000u
+ ad=8.352e+11p pd=7.41e+06u as=2.1725e+11p ps=2.13e+06u
M1001 a_1032_911# a_620_911# net59 VNB sky130_fd_pr__pfet_01v8_hvt w=790000u
+ l=150000u ad=2.133e+11p pd=2.12e+06u as=0p ps=0u
M1002 a_620_911# a_505_297# VGND VGND sky130_fd_pr__nfet_01v8 w=650000u l=150000u
+ ad=3.64e+11p pd=3.72e+06u as=1.62905e+12p ps=1.514e+07u
M1003 a_714_47# A VGND VGND sky130_fd_pr__nfet_01v8 w=650000u l=150000u ad=3.64e+11p
+ pd=3.72e+06u as=0p ps=0u
M1004 a_714_47# A VGND VGND sky130_fd_pr__nfet_01v8 w=650000u l=150000u ad=0p pd=0u
+ as=0p ps=0u
M1005 X a_1032_911# VGND VGND sky130_fd_pr__nfet_01v8 w=650000u l=150000u
+ ad=2.405e+11p pd=2.04e+06u as=0p ps=0u
M1006 net59 a_1032_911# X VNB sky130_fd_pr__pfet_01v8_hvt w=1e+06u l=150000u ad=0p
+ pd=0u as=3.7e+11p ps=2.74e+06u
M1007 VGND A a_714_47# VGND sky130_fd_pr__nfet_01v8 w=650000u l=150000u ad=0p pd=0u
+ as=0p ps=0u
M1008 VGND a_505_297# a_620_911# VGND sky130_fd_pr__nfet_01v8 w=650000u l=150000u
+ ad=0p pd=0u as=0p ps=0u
M1009 a_1032_911# a_620_911# VGND VGND sky130_fd_pr__nfet_01v8 w=650000u l=150000u
+ ad=1.7225e+11p pd=1.83e+06u as=0p ps=0u
M1010 VGND A a_714_47# VGND sky130_fd_pr__nfet_01v8 w=650000u l=150000u ad=0p pd=0u
+ as=0p ps=0u
M1011 a_505_297# A VPWRIN VPWRIN sky130_fd_pr__pfet_01v8_hvt w=1e+06u l=150000u
+ ad=2.75e+11p pd=2.55e+06u as=2.75e+11p ps=2.55e+06u
M1012 a_505_297# A VGND VGND sky130_fd_pr__nfet_01v8 w=420000u l=150000u
+ ad=1.113e+11p pd=1.37e+06u as=0p ps=0u
M1013 X a_1032_911# net59 VNB sky130_fd_pr__pfet_01v8_hvt w=1e+06u l=150000u ad=0p
+ pd=0u as=0p ps=0u
M1014 VGND a_1032_911# X VGND sky130_fd_pr__nfet_01v8 w=650000u l=150000u ad=0p
+ pd=0u as=0p ps=0u
M1015 VGND a_505_297# a_620_911# VGND sky130_fd_pr__nfet_01v8 w=650000u l=150000u
+ ad=0p pd=0u as=0p ps=0u
M1016 a_620_911# a_505_297# VGND VGND sky130_fd_pr__nfet_01v8 w=650000u l=150000u
+ ad=0p pd=0u as=0p ps=0u
M1017 net59 a_714_47# a_620_911# VNB sky130_fd_pr__pfet_01v8_hvt w=790000u l=150000u
+ ad=0p pd=0u as=2.1725e+11p ps=2.13e+06u
.ENDS sky130_fd_sc_hd__lpflow_lsbuf_lh_hl_isowell_tap_2
* Copyright 2020 The SkyWater PDK Authors
*
* Licensed under the Apache License, Version 2.0 (the "License");
* you may not use this file except in compliance with the License.
* You may obtain a copy of the License at
*
*     https:  www.apache.org licenses LICENSE-2.0
*
* Unless required by applicable law or agreed to in writing, software
* distributed under the License is distributed on an "AS IS" BASIS,
* WITHOUT WARRANTIES OR CONDITIONS OF ANY KIND, either express or implied.
* See the License for the specific language governing permissions and
* limitations under the License.
*
* SPDX-License-Identifier: Apache-2.0

.SUBCKT sky130_fd_sc_hd__lpflow_lsbuf_lh_hl_isowell_tap_4 A VGND VNB VPWRIN net59 X
*.PININFO A:I VGND:I VNB:I VPWRIN:I net59:I X:O
M1000 net59 a_620_911# a_714_47# VNB sky130_fd_pr__pfet_01v8_hvt w=790000u l=150000u
+ ad=1.1152e+12p pd=9.97e+06u as=2.1725e+11p ps=2.13e+06u
M1001 a_1032_911# a_620_911# net59 VNB sky130_fd_pr__pfet_01v8_hvt w=790000u
+ l=150000u ad=2.133e+11p pd=2.12e+06u as=0p ps=0u
M1002 X a_1032_911# net59 VNB sky130_fd_pr__pfet_01v8_hvt w=1e+06u l=150000u
+ ad=6.5e+11p pd=5.3e+06u as=0p ps=0u
M1003 a_620_911# a_505_297# VGND VGND sky130_fd_pr__nfet_01v8 w=650000u l=150000u
+ ad=3.64e+11p pd=3.72e+06u as=1.81105e+12p ps=1.7e+07u
M1004 a_714_47# A VGND VGND sky130_fd_pr__nfet_01v8 w=650000u l=150000u ad=3.64e+11p
+ pd=3.72e+06u as=0p ps=0u
M1005 a_714_47# A VGND VGND sky130_fd_pr__nfet_01v8 w=650000u l=150000u ad=0p pd=0u
+ as=0p ps=0u
M1006 X a_1032_911# VGND VGND sky130_fd_pr__nfet_01v8 w=650000u l=150000u
+ ad=4.225e+11p pd=3.9e+06u as=0p ps=0u
M1007 X a_1032_911# VGND VGND sky130_fd_pr__nfet_01v8 w=650000u l=150000u ad=0p
+ pd=0u as=0p ps=0u
M1008 net59 a_1032_911# X VNB sky130_fd_pr__pfet_01v8_hvt w=1e+06u l=150000u ad=0p
+ pd=0u as=0p ps=0u
M1009 VGND A a_714_47# VGND sky130_fd_pr__nfet_01v8 w=650000u l=150000u ad=0p pd=0u
+ as=0p ps=0u
M1010 VGND a_505_297# a_620_911# VGND sky130_fd_pr__nfet_01v8 w=650000u l=150000u
+ ad=0p pd=0u as=0p ps=0u
M1011 a_1032_911# a_620_911# VGND VGND sky130_fd_pr__nfet_01v8 w=650000u l=150000u
+ ad=1.7225e+11p pd=1.83e+06u as=0p ps=0u
M1012 VGND A a_714_47# VGND sky130_fd_pr__nfet_01v8 w=650000u l=150000u ad=0p pd=0u
+ as=0p ps=0u
M1013 a_505_297# A VPWRIN VPWRIN sky130_fd_pr__pfet_01v8_hvt w=1e+06u l=150000u
+ ad=2.75e+11p pd=2.55e+06u as=2.75e+11p ps=2.55e+06u
M1014 a_505_297# A VGND VGND sky130_fd_pr__nfet_01v8 w=420000u l=150000u
+ ad=1.113e+11p pd=1.37e+06u as=0p ps=0u
M1015 X a_1032_911# net59 VNB sky130_fd_pr__pfet_01v8_hvt w=1e+06u l=150000u ad=0p
+ pd=0u as=0p ps=0u
M1016 net59 a_1032_911# X VNB sky130_fd_pr__pfet_01v8_hvt w=1e+06u l=150000u ad=0p
+ pd=0u as=0p ps=0u
M1017 VGND a_1032_911# X VGND sky130_fd_pr__nfet_01v8 w=650000u l=150000u ad=0p
+ pd=0u as=0p ps=0u
M1018 VGND a_1032_911# X VGND sky130_fd_pr__nfet_01v8 w=650000u l=150000u ad=0p
+ pd=0u as=0p ps=0u
M1019 VGND a_505_297# a_620_911# VGND sky130_fd_pr__nfet_01v8 w=650000u l=150000u
+ ad=0p pd=0u as=0p ps=0u
M1020 a_620_911# a_505_297# VGND VGND sky130_fd_pr__nfet_01v8 w=650000u l=150000u
+ ad=0p pd=0u as=0p ps=0u
M1021 net59 a_714_47# a_620_911# VNB sky130_fd_pr__pfet_01v8_hvt w=790000u l=150000u
+ ad=0p pd=0u as=2.1725e+11p ps=2.13e+06u
.ENDS sky130_fd_sc_hd__lpflow_lsbuf_lh_hl_isowell_tap_4
* Copyright 2020 The SkyWater PDK Authors
*
* Licensed under the Apache License, Version 2.0 (the "License");
* you may not use this file except in compliance with the License.
* You may obtain a copy of the License at
*
*     https:  www.apache.org licenses LICENSE-2.0
*
* Unless required by applicable law or agreed to in writing, software
* distributed under the License is distributed on an "AS IS" BASIS,
* WITHOUT WARRANTIES OR CONDITIONS OF ANY KIND, either express or implied.
* See the License for the specific language governing permissions and
* limitations under the License.
*
* SPDX-License-Identifier: Apache-2.0

.SUBCKT sky130_fd_sc_hd__lpflow_lsbuf_lh_isowell_4 A LOWLVPWR VGND VNB VNB net59 X
*.PININFO A:I LOWLVPWR:I VGND:I VNB:I VNB:I net59:I X:O
MI2 net72 cross1 net59 VNB sky130_fd_pr__pfet_01v8_hvt m=1 w=0.79u l=0.15u mult=1
+ sa=0.265 sb=0.265 sd=0.28 area=0.063 perim=1.14
MI3 cross1 net72 net59 VNB sky130_fd_pr__pfet_01v8_hvt m=1 w=0.79u l=0.15u mult=1
+ sa=0.265 sb=0.265 sd=0.28 area=0.063 perim=1.14
MI20 Ab A LOWLVPWR LOWLVPWR sky130_fd_pr__pfet_01v8_hvt m=1 w=1.0u l=0.15u mult=1
+ sa=0.265 sb=0.265 sd=0.28 area=0.063 perim=1.14
MI24 X net60 net59 VNB sky130_fd_pr__pfet_01v8_hvt m=4 w=1.0u l=0.15u mult=1 sa=0.265
+ sb=0.265 sd=0.28 area=0.063 perim=1.14
MI28 net60 cross1 net59 VNB sky130_fd_pr__pfet_01v8_hvt m=1 w=0.79u l=0.15u mult=1
+ sa=0.265 sb=0.265 sd=0.28 area=0.063 perim=1.14
MI5 cross1 Ab VGND VNB sky130_fd_pr__nfet_01v8 m=4 w=0.65u l=0.15u mult=1 sa=0.265
+ sb=0.265 sd=0.28 area=0.063 perim=1.14
MI4 net72 A VGND VNB sky130_fd_pr__nfet_01v8 m=4 w=0.65u l=0.15u mult=1 sa=0.265
+ sb=0.265 sd=0.28 area=0.063 perim=1.14
MI23 Ab A VGND VNB sky130_fd_pr__nfet_01v8 m=1 w=0.42u l=0.15u mult=1 sa=0.265
+ sb=0.265 sd=0.28 area=0.063 perim=1.14
MI25 X net60 VGND VNB sky130_fd_pr__nfet_01v8 m=4 w=0.65u l=0.15u mult=1 sa=0.265
+ sb=0.265 sd=0.28 area=0.063 perim=1.14
MI29 net60 cross1 VGND VNB sky130_fd_pr__nfet_01v8 m=1 w=0.65u l=0.15u mult=1 sa=0.265
+ sb=0.265 sd=0.28 area=0.063 perim=1.14
.ENDS sky130_fd_sc_hd__lpflow_lsbuf_lh_isowell_4
* Copyright 2020 The SkyWater PDK Authors
*
* Licensed under the Apache License, Version 2.0 (the "License");
* you may not use this file except in compliance with the License.
* You may obtain a copy of the License at
*
*     https:  www.apache.org licenses LICENSE-2.0
*
* Unless required by applicable law or agreed to in writing, software
* distributed under the License is distributed on an "AS IS" BASIS,
* WITHOUT WARRANTIES OR CONDITIONS OF ANY KIND, either express or implied.
* See the License for the specific language governing permissions and
* limitations under the License.
*
* SPDX-License-Identifier: Apache-2.0

.SUBCKT sky130_fd_sc_hd__lpflow_lsbuf_lh_isowell_tap_1 A LOWLVPWR VGND VNB net59 X
*.PININFO A:I LOWLVPWR:I VGND:I VNB:I net59:I X:O
M1000 X a_1028_32# net59 VNB sky130_fd_pr__pfet_01v8_hvt w=790000u l=150000u
+ ad=2.1725e+11p pd=2.13e+06u as=4.7795e+11p ps=4.37e+06u
M1001 net59 a_620_911# a_714_58# VNB sky130_fd_pr__pfet_01v8_hvt w=790000u l=150000u
+ ad=0p pd=0u as=2.1725e+11p ps=2.13e+06u
M1002 a_1028_32# a_620_911# net59 VNB sky130_fd_pr__pfet_01v8_hvt w=790000u l=150000u
+ ad=2.133e+11p pd=2.12e+06u as=0p ps=0u
M1003 X a_1028_32# VGND VGND sky130_fd_pr__nfet_01v8 w=650000u l=150000u
+ ad=1.8525e+11p pd=1.87e+06u as=1.4178e+12p ps=1.319e+07u
M1004 a_620_911# a_505_297# VGND VGND sky130_fd_pr__nfet_01v8 w=650000u l=150000u
+ ad=3.64e+11p pd=3.72e+06u as=0p ps=0u
M1005 a_714_58# A VGND VGND sky130_fd_pr__nfet_01v8 w=650000u l=150000u ad=3.64e+11p
+ pd=3.72e+06u as=0p ps=0u
M1006 a_714_58# A VGND VGND sky130_fd_pr__nfet_01v8 w=650000u l=150000u ad=0p pd=0u
+ as=0p ps=0u
M1007 VGND a_505_297# a_620_911# VGND sky130_fd_pr__nfet_01v8 w=650000u l=150000u
+ ad=0p pd=0u as=0p ps=0u
M1008 a_1028_32# a_620_911# VGND VGND sky130_fd_pr__nfet_01v8 w=650000u l=150000u
+ ad=1.7225e+11p pd=1.83e+06u as=0p ps=0u
M1009 a_505_297# A LOWLVPWR LOWLVPWR sky130_fd_pr__pfet_01v8_hvt w=1e+06u l=150000u
+ ad=2.75e+11p pd=2.55e+06u as=2.75e+11p ps=2.55e+06u
M1010 a_505_297# A VGND VGND sky130_fd_pr__nfet_01v8 w=420000u l=150000u
+ ad=1.113e+11p pd=1.37e+06u as=0p ps=0u
M1011 VGND A a_714_58# VGND sky130_fd_pr__nfet_01v8 w=650000u l=150000u ad=0p pd=0u
+ as=0p ps=0u
M1012 VGND A a_714_58# VGND sky130_fd_pr__nfet_01v8 w=650000u l=150000u ad=0p pd=0u
+ as=0p ps=0u
M1013 VGND a_505_297# a_620_911# VGND sky130_fd_pr__nfet_01v8 w=650000u l=150000u
+ ad=0p pd=0u as=0p ps=0u
M1014 a_620_911# a_505_297# VGND VGND sky130_fd_pr__nfet_01v8 w=650000u l=150000u
+ ad=0p pd=0u as=0p ps=0u
M1015 net59 a_714_58# a_620_911# VNB sky130_fd_pr__pfet_01v8_hvt w=790000u l=150000u
+ ad=0p pd=0u as=2.1725e+11p ps=2.13e+06u
.ENDS sky130_fd_sc_hd__lpflow_lsbuf_lh_isowell_tap_1
* Copyright 2020 The SkyWater PDK Authors
*
* Licensed under the Apache License, Version 2.0 (the "License");
* you may not use this file except in compliance with the License.
* You may obtain a copy of the License at
*
*     https:  www.apache.org licenses LICENSE-2.0
*
* Unless required by applicable law or agreed to in writing, software
* distributed under the License is distributed on an "AS IS" BASIS,
* WITHOUT WARRANTIES OR CONDITIONS OF ANY KIND, either express or implied.
* See the License for the specific language governing permissions and
* limitations under the License.
*
* SPDX-License-Identifier: Apache-2.0

.SUBCKT sky130_fd_sc_hd__lpflow_lsbuf_lh_isowell_tap_2 A LOWLVPWR VGND VNB net59 X
*.PININFO A:I LOWLVPWR:I VGND:I VNB:I net59:I X:O
M1000 net59 a_620_911# a_714_47# VNB sky130_fd_pr__pfet_01v8_hvt w=790000u l=150000u
+ ad=8.352e+11p pd=7.41e+06u as=2.1725e+11p ps=2.13e+06u
M1001 a_1032_911# a_620_911# net59 VNB sky130_fd_pr__pfet_01v8_hvt w=790000u
+ l=150000u ad=2.133e+11p pd=2.12e+06u as=0p ps=0u
M1002 a_620_911# a_505_297# VGND VGND sky130_fd_pr__nfet_01v8 w=650000u l=150000u
+ ad=3.64e+11p pd=3.72e+06u as=1.62905e+12p ps=1.514e+07u
M1003 a_714_47# A VGND VGND sky130_fd_pr__nfet_01v8 w=650000u l=150000u ad=3.64e+11p
+ pd=3.72e+06u as=0p ps=0u
M1004 a_714_47# A VGND VGND sky130_fd_pr__nfet_01v8 w=650000u l=150000u ad=0p pd=0u
+ as=0p ps=0u
M1005 X a_1032_911# VGND VGND sky130_fd_pr__nfet_01v8 w=650000u l=150000u
+ ad=2.405e+11p pd=2.04e+06u as=0p ps=0u
M1006 net59 a_1032_911# X VNB sky130_fd_pr__pfet_01v8_hvt w=1e+06u l=150000u ad=0p
+ pd=0u as=3.7e+11p ps=2.74e+06u
M1007 VGND A a_714_47# VGND sky130_fd_pr__nfet_01v8 w=650000u l=150000u ad=0p pd=0u
+ as=0p ps=0u
M1008 VGND a_505_297# a_620_911# VGND sky130_fd_pr__nfet_01v8 w=650000u l=150000u
+ ad=0p pd=0u as=0p ps=0u
M1009 a_1032_911# a_620_911# VGND VGND sky130_fd_pr__nfet_01v8 w=650000u l=150000u
+ ad=1.7225e+11p pd=1.83e+06u as=0p ps=0u
M1010 VGND A a_714_47# VGND sky130_fd_pr__nfet_01v8 w=650000u l=150000u ad=0p pd=0u
+ as=0p ps=0u
M1011 a_505_297# A LOWLVPWR LOWLVPWR sky130_fd_pr__pfet_01v8_hvt w=1e+06u l=150000u
+ ad=2.75e+11p pd=2.55e+06u as=2.75e+11p ps=2.55e+06u
M1012 a_505_297# A VGND VGND sky130_fd_pr__nfet_01v8 w=420000u l=150000u
+ ad=1.113e+11p pd=1.37e+06u as=0p ps=0u
M1013 X a_1032_911# net59 VNB sky130_fd_pr__pfet_01v8_hvt w=1e+06u l=150000u ad=0p
+ pd=0u as=0p ps=0u
M1014 VGND a_1032_911# X VGND sky130_fd_pr__nfet_01v8 w=650000u l=150000u ad=0p
+ pd=0u as=0p ps=0u
M1015 VGND a_505_297# a_620_911# VGND sky130_fd_pr__nfet_01v8 w=650000u l=150000u
+ ad=0p pd=0u as=0p ps=0u
M1016 a_620_911# a_505_297# VGND VGND sky130_fd_pr__nfet_01v8 w=650000u l=150000u
+ ad=0p pd=0u as=0p ps=0u
M1017 net59 a_714_47# a_620_911# VNB sky130_fd_pr__pfet_01v8_hvt w=790000u l=150000u
+ ad=0p pd=0u as=2.1725e+11p ps=2.13e+06u
.ENDS sky130_fd_sc_hd__lpflow_lsbuf_lh_isowell_tap_2
* Copyright 2020 The SkyWater PDK Authors
*
* Licensed under the Apache License, Version 2.0 (the "License");
* you may not use this file except in compliance with the License.
* You may obtain a copy of the License at
*
*     https:  www.apache.org licenses LICENSE-2.0
*
* Unless required by applicable law or agreed to in writing, software
* distributed under the License is distributed on an "AS IS" BASIS,
* WITHOUT WARRANTIES OR CONDITIONS OF ANY KIND, either express or implied.
* See the License for the specific language governing permissions and
* limitations under the License.
*
* SPDX-License-Identifier: Apache-2.0

.SUBCKT sky130_fd_sc_hd__lpflow_lsbuf_lh_isowell_tap_4 A LOWLVPWR VGND VNB net59 X
*.PININFO A:I LOWLVPWR:I VGND:I VNB:I net59:I X:O
M1000 net59 a_620_911# a_714_47# VNB sky130_fd_pr__pfet_01v8_hvt w=790000u l=150000u
+ ad=1.1152e+12p pd=9.97e+06u as=2.1725e+11p ps=2.13e+06u
M1001 a_1032_911# a_620_911# net59 VNB sky130_fd_pr__pfet_01v8_hvt w=790000u
+ l=150000u ad=2.133e+11p pd=2.12e+06u as=0p ps=0u
M1002 X a_1032_911# net59 VNB sky130_fd_pr__pfet_01v8_hvt w=1e+06u l=150000u
+ ad=6.5e+11p pd=5.3e+06u as=0p ps=0u
M1003 a_620_911# a_505_297# VGND VGND sky130_fd_pr__nfet_01v8 w=650000u l=150000u
+ ad=3.64e+11p pd=3.72e+06u as=1.81105e+12p ps=1.7e+07u
M1004 a_714_47# A VGND VGND sky130_fd_pr__nfet_01v8 w=650000u l=150000u ad=3.64e+11p
+ pd=3.72e+06u as=0p ps=0u
M1005 a_714_47# A VGND VGND sky130_fd_pr__nfet_01v8 w=650000u l=150000u ad=0p pd=0u
+ as=0p ps=0u
M1006 X a_1032_911# VGND VGND sky130_fd_pr__nfet_01v8 w=650000u l=150000u
+ ad=4.225e+11p pd=3.9e+06u as=0p ps=0u
M1007 X a_1032_911# VGND VGND sky130_fd_pr__nfet_01v8 w=650000u l=150000u ad=0p
+ pd=0u as=0p ps=0u
M1008 net59 a_1032_911# X VNB sky130_fd_pr__pfet_01v8_hvt w=1e+06u l=150000u ad=0p
+ pd=0u as=0p ps=0u
M1009 VGND A a_714_47# VGND sky130_fd_pr__nfet_01v8 w=650000u l=150000u ad=0p pd=0u
+ as=0p ps=0u
M1010 VGND a_505_297# a_620_911# VGND sky130_fd_pr__nfet_01v8 w=650000u l=150000u
+ ad=0p pd=0u as=0p ps=0u
M1011 a_1032_911# a_620_911# VGND VGND sky130_fd_pr__nfet_01v8 w=650000u l=150000u
+ ad=1.7225e+11p pd=1.83e+06u as=0p ps=0u
M1012 VGND A a_714_47# VGND sky130_fd_pr__nfet_01v8 w=650000u l=150000u ad=0p pd=0u
+ as=0p ps=0u
M1013 a_505_297# A LOWLVPWR LOWLVPWR sky130_fd_pr__pfet_01v8_hvt w=1e+06u l=150000u
+ ad=2.75e+11p pd=2.55e+06u as=2.75e+11p ps=2.55e+06u
M1014 a_505_297# A VGND VGND sky130_fd_pr__nfet_01v8 w=420000u l=150000u
+ ad=1.113e+11p pd=1.37e+06u as=0p ps=0u
M1015 X a_1032_911# net59 VNB sky130_fd_pr__pfet_01v8_hvt w=1e+06u l=150000u ad=0p
+ pd=0u as=0p ps=0u
M1016 net59 a_1032_911# X VNB sky130_fd_pr__pfet_01v8_hvt w=1e+06u l=150000u ad=0p
+ pd=0u as=0p ps=0u
M1017 VGND a_1032_911# X VGND sky130_fd_pr__nfet_01v8 w=650000u l=150000u ad=0p
+ pd=0u as=0p ps=0u
M1018 VGND a_1032_911# X VGND sky130_fd_pr__nfet_01v8 w=650000u l=150000u ad=0p
+ pd=0u as=0p ps=0u
M1019 VGND a_505_297# a_620_911# VGND sky130_fd_pr__nfet_01v8 w=650000u l=150000u
+ ad=0p pd=0u as=0p ps=0u
M1020 a_620_911# a_505_297# VGND VGND sky130_fd_pr__nfet_01v8 w=650000u l=150000u
+ ad=0p pd=0u as=0p ps=0u
M1021 net59 a_714_47# a_620_911# VNB sky130_fd_pr__pfet_01v8_hvt w=790000u l=150000u
+ ad=0p pd=0u as=2.1725e+11p ps=2.13e+06u
.ENDS sky130_fd_sc_hd__lpflow_lsbuf_lh_isowell_tap_4
* Copyright 2020 The SkyWater PDK Authors
*
* Licensed under the Apache License, Version 2.0 (the "License");
* you may not use this file except in compliance with the License.
* You may obtain a copy of the License at
*
*     https:  www.apache.org licenses LICENSE-2.0
*
* Unless required by applicable law or agreed to in writing, software
* distributed under the License is distributed on an "AS IS" BASIS,
* WITHOUT WARRANTIES OR CONDITIONS OF ANY KIND, either express or implied.
* See the License for the specific language governing permissions and
* limitations under the License.
*
* SPDX-License-Identifier: Apache-2.0

.SUBCKT sky130_fd_sc_hd__macro_sparecell VGND VNB VNB net59 LO
*.PININFO VGND:I VNB:I VNB:I net59:I LO:O
XI6 nor2right invright VGND VNB VNB net59   sky130_fd_sc_hd__inv_2
XI7 nor2left invleft VGND VNB VNB net59   sky130_fd_sc_hd__inv_2
XI4 nd2right nd2right nor2right VGND VNB VNB net59
+ sky130_fd_sc_hd__nor2_2
XI5 nd2left nd2left nor2left VGND VNB VNB net59
+ sky130_fd_sc_hd__nor2_2
XI2 LO LO nd2right VGND VNB VNB net59   sky130_fd_sc_hd__nand2_2
XI3 LO LO nd2left VGND VNB VNB net59   sky130_fd_sc_hd__nand2_2
.ENDS sky130_fd_sc_hd__macro_sparecell
* Copyright 2020 The SkyWater PDK Authors
*
* Licensed under the Apache License, Version 2.0 (the "License");
* you may not use this file except in compliance with the License.
* You may obtain a copy of the License at
*
*     https:  www.apache.org licenses LICENSE-2.0
*
* Unless required by applicable law or agreed to in writing, software
* distributed under the License is distributed on an "AS IS" BASIS,
* WITHOUT WARRANTIES OR CONDITIONS OF ANY KIND, either express or implied.
* See the License for the specific language governing permissions and
* limitations under the License.
*
* SPDX-License-Identifier: Apache-2.0

.SUBCKT sky130_fd_sc_hd__maj3_1 A B C VGND VNB VNB net59 X
*.PININFO A:I B:I C:I VGND:I VNB:I VNB:I net59:I X:O
MMIN2 X y VGND VNB sky130_fd_pr__nfet_01v8 m=1 w=0.65u l=0.15u mult=1 sa=0.265
+ sb=0.265 sd=0.28 area=0.063 perim=1.14
MMN10 y B sndNBa VNB sky130_fd_pr__nfet_01v8 m=1 w=0.42u l=0.15u mult=1 sa=0.265
+ sb=0.265 sd=0.28 area=0.063 perim=1.14
MMN11 sndNBa A VGND VNB sky130_fd_pr__nfet_01v8 m=1 w=0.42u l=0.15u mult=1 sa=0.265
+ sb=0.265 sd=0.28 area=0.063 perim=1.14
MMN20 y B sndNBc VNB sky130_fd_pr__nfet_01v8 m=1 w=0.42u l=0.15u mult=1 sa=0.265
+ sb=0.265 sd=0.28 area=0.063 perim=1.14
MMN21 sndNBc C VGND VNB sky130_fd_pr__nfet_01v8 m=1 w=0.42u l=0.15u mult=1 sa=0.265
+ sb=0.265 sd=0.28 area=0.063 perim=1.14
MMN30 y C sndNCa VNB sky130_fd_pr__nfet_01v8 m=1 w=0.42u l=0.15u mult=1 sa=0.265
+ sb=0.265 sd=0.28 area=0.063 perim=1.14
MMN31 sndNCa A VGND VNB sky130_fd_pr__nfet_01v8 m=1 w=0.42u l=0.15u mult=1 sa=0.265
+ sb=0.265 sd=0.28 area=0.063 perim=1.14
MMIP2 X y net59 VNB sky130_fd_pr__pfet_01v8_hvt m=1 w=1.0u l=0.15u mult=1 sa=0.265
+ sb=0.265 sd=0.28 area=0.063 perim=1.14
MMP10 net59 A sndPAb VNB sky130_fd_pr__pfet_01v8_hvt m=1 w=0.42u l=0.15u mult=1
+ sa=0.265 sb=0.265 sd=0.28 area=0.063 perim=1.14
MMP11 sndPAb B y VNB sky130_fd_pr__pfet_01v8_hvt m=1 w=0.42u l=0.15u mult=1 sa=0.265
+ sb=0.265 sd=0.28 area=0.063 perim=1.14
MMP20 net59 C sndPCb VNB sky130_fd_pr__pfet_01v8_hvt m=1 w=0.42u l=0.15u mult=1
+ sa=0.265 sb=0.265 sd=0.28 area=0.063 perim=1.14
MMP21 sndPCb B y VNB sky130_fd_pr__pfet_01v8_hvt m=1 w=0.42u l=0.15u mult=1 sa=0.265
+ sb=0.265 sd=0.28 area=0.063 perim=1.14
MMP30 net59 A sndPAc VNB sky130_fd_pr__pfet_01v8_hvt m=1 w=0.42u l=0.15u mult=1
+ sa=0.265 sb=0.265 sd=0.28 area=0.063 perim=1.14
MMP31 sndPAc C y VNB sky130_fd_pr__pfet_01v8_hvt m=1 w=0.42u l=0.15u mult=1 sa=0.265
+ sb=0.265 sd=0.28 area=0.063 perim=1.14
.ENDS sky130_fd_sc_hd__maj3_1
* Copyright 2020 The SkyWater PDK Authors
*
* Licensed under the Apache License, Version 2.0 (the "License");
* you may not use this file except in compliance with the License.
* You may obtain a copy of the License at
*
*     https:  www.apache.org licenses LICENSE-2.0
*
* Unless required by applicable law or agreed to in writing, software
* distributed under the License is distributed on an "AS IS" BASIS,
* WITHOUT WARRANTIES OR CONDITIONS OF ANY KIND, either express or implied.
* See the License for the specific language governing permissions and
* limitations under the License.
*
* SPDX-License-Identifier: Apache-2.0

.SUBCKT sky130_fd_sc_hd__maj3_2 A B C VGND VNB VNB net59 X
*.PININFO A:I B:I C:I VGND:I VNB:I VNB:I net59:I X:O
MMIN2 X y VGND VNB sky130_fd_pr__nfet_01v8 m=2 w=0.65u l=0.15u mult=1 sa=0.265
+ sb=0.265 sd=0.28 area=0.063 perim=1.14
MMN10 y B sndNBa VNB sky130_fd_pr__nfet_01v8 m=1 w=0.42u l=0.15u mult=1 sa=0.265
+ sb=0.265 sd=0.28 area=0.063 perim=1.14
MMN11 sndNBa A VGND VNB sky130_fd_pr__nfet_01v8 m=1 w=0.42u l=0.15u mult=1 sa=0.265
+ sb=0.265 sd=0.28 area=0.063 perim=1.14
MMN20 y B sndNBc VNB sky130_fd_pr__nfet_01v8 m=1 w=0.42u l=0.15u mult=1 sa=0.265
+ sb=0.265 sd=0.28 area=0.063 perim=1.14
MMN21 sndNBc C VGND VNB sky130_fd_pr__nfet_01v8 m=1 w=0.42u l=0.15u mult=1 sa=0.265
+ sb=0.265 sd=0.28 area=0.063 perim=1.14
MMN30 y C sndNCa VNB sky130_fd_pr__nfet_01v8 m=1 w=0.42u l=0.15u mult=1 sa=0.265
+ sb=0.265 sd=0.28 area=0.063 perim=1.14
MMN31 sndNCa A VGND VNB sky130_fd_pr__nfet_01v8 m=1 w=0.42u l=0.15u mult=1 sa=0.265
+ sb=0.265 sd=0.28 area=0.063 perim=1.14
MMIP2 X y net59 VNB sky130_fd_pr__pfet_01v8_hvt m=2 w=1.0u l=0.15u mult=1 sa=0.265
+ sb=0.265 sd=0.28 area=0.063 perim=1.14
MMP10 net59 A sndPAb VNB sky130_fd_pr__pfet_01v8_hvt m=1 w=0.64u l=0.15u mult=1
+ sa=0.265 sb=0.265 sd=0.28 area=0.063 perim=1.14
MMP11 sndPAb B y VNB sky130_fd_pr__pfet_01v8_hvt m=1 w=0.64u l=0.15u mult=1 sa=0.265
+ sb=0.265 sd=0.28 area=0.063 perim=1.14
MMP20 net59 C sndPCb VNB sky130_fd_pr__pfet_01v8_hvt m=1 w=0.64u l=0.15u mult=1
+ sa=0.265 sb=0.265 sd=0.28 area=0.063 perim=1.14
MMP21 sndPCb B y VNB sky130_fd_pr__pfet_01v8_hvt m=1 w=0.64u l=0.15u mult=1 sa=0.265
+ sb=0.265 sd=0.28 area=0.063 perim=1.14
MMP30 net59 A sndPAc VNB sky130_fd_pr__pfet_01v8_hvt m=1 w=0.64u l=0.15u mult=1
+ sa=0.265 sb=0.265 sd=0.28 area=0.063 perim=1.14
MMP31 sndPAc C y VNB sky130_fd_pr__pfet_01v8_hvt m=1 w=0.64u l=0.15u mult=1 sa=0.265
+ sb=0.265 sd=0.28 area=0.063 perim=1.14
.ENDS sky130_fd_sc_hd__maj3_2
* Copyright 2020 The SkyWater PDK Authors
*
* Licensed under the Apache License, Version 2.0 (the "License");
* you may not use this file except in compliance with the License.
* You may obtain a copy of the License at
*
*     https:  www.apache.org licenses LICENSE-2.0
*
* Unless required by applicable law or agreed to in writing, software
* distributed under the License is distributed on an "AS IS" BASIS,
* WITHOUT WARRANTIES OR CONDITIONS OF ANY KIND, either express or implied.
* See the License for the specific language governing permissions and
* limitations under the License.
*
* SPDX-License-Identifier: Apache-2.0

.SUBCKT sky130_fd_sc_hd__maj3_4 A B C VGND VNB VNB net59 X
*.PININFO A:I B:I C:I VGND:I VNB:I VNB:I net59:I X:O
MMIN2 X y VGND VNB sky130_fd_pr__nfet_01v8 m=4 w=0.65u l=0.15u mult=1 sa=0.265
+ sb=0.265 sd=0.28 area=0.063 perim=1.14
MMN10 y B sndNBa VNB sky130_fd_pr__nfet_01v8 m=1 w=0.65u l=0.15u mult=1 sa=0.265
+ sb=0.265 sd=0.28 area=0.063 perim=1.14
MMN11 sndNBa A VGND VNB sky130_fd_pr__nfet_01v8 m=1 w=0.65u l=0.15u mult=1 sa=0.265
+ sb=0.265 sd=0.28 area=0.063 perim=1.14
MMN20 y B sndNBc VNB sky130_fd_pr__nfet_01v8 m=1 w=0.65u l=0.15u mult=1 sa=0.265
+ sb=0.265 sd=0.28 area=0.063 perim=1.14
MMN21 sndNBc C VGND VNB sky130_fd_pr__nfet_01v8 m=1 w=0.65u l=0.15u mult=1 sa=0.265
+ sb=0.265 sd=0.28 area=0.063 perim=1.14
MMN30 y C sndNCa VNB sky130_fd_pr__nfet_01v8 m=1 w=0.65u l=0.15u mult=1 sa=0.265
+ sb=0.265 sd=0.28 area=0.063 perim=1.14
MMN31 sndNCa A VGND VNB sky130_fd_pr__nfet_01v8 m=1 w=0.65u l=0.15u mult=1 sa=0.265
+ sb=0.265 sd=0.28 area=0.063 perim=1.14
MMIP2 X y net59 VNB sky130_fd_pr__pfet_01v8_hvt m=4 w=1.0u l=0.15u mult=1 sa=0.265
+ sb=0.265 sd=0.28 area=0.063 perim=1.14
MMP10 net59 A sndPAb VNB sky130_fd_pr__pfet_01v8_hvt m=1 w=1.0u l=0.15u mult=1 sa=0.265
+ sb=0.265 sd=0.28 area=0.063 perim=1.14
MMP11 sndPAb B y VNB sky130_fd_pr__pfet_01v8_hvt m=1 w=1.0u l=0.15u mult=1 sa=0.265
+ sb=0.265 sd=0.28 area=0.063 perim=1.14
MMP20 net59 C sndPCb VNB sky130_fd_pr__pfet_01v8_hvt m=1 w=1.0u l=0.15u mult=1 sa=0.265
+ sb=0.265 sd=0.28 area=0.063 perim=1.14
MMP21 sndPCb B y VNB sky130_fd_pr__pfet_01v8_hvt m=1 w=1.0u l=0.15u mult=1 sa=0.265
+ sb=0.265 sd=0.28 area=0.063 perim=1.14
MMP30 net59 A sndPAc VNB sky130_fd_pr__pfet_01v8_hvt m=1 w=1.0u l=0.15u mult=1 sa=0.265
+ sb=0.265 sd=0.28 area=0.063 perim=1.14
MMP31 sndPAc C y VNB sky130_fd_pr__pfet_01v8_hvt m=1 w=1.0u l=0.15u mult=1 sa=0.265
+ sb=0.265 sd=0.28 area=0.063 perim=1.14
.ENDS sky130_fd_sc_hd__maj3_4
* Copyright 2020 The SkyWater PDK Authors
*
* Licensed under the Apache License, Version 2.0 (the "License");
* you may not use this file except in compliance with the License.
* You may obtain a copy of the License at
*
*     https:  www.apache.org licenses LICENSE-2.0
*
* Unless required by applicable law or agreed to in writing, software
* distributed under the License is distributed on an "AS IS" BASIS,
* WITHOUT WARRANTIES OR CONDITIONS OF ANY KIND, either express or implied.
* See the License for the specific language governing permissions and
* limitations under the License.
*
* SPDX-License-Identifier: Apache-2.0

.SUBCKT sky130_fd_sc_hd__mux2_1 A0 A1 S VGND VNB VNB net59 X
*.PININFO A0:I A1:I S:I VGND:I VNB:I VNB:I net59:I X:O
MMNA00 xb A0 smdNA0 VNB sky130_fd_pr__nfet_01v8 m=1 w=0.42u l=0.15u mult=1 sa=0.265
+ sb=0.265 sd=0.28 area=0.063 perim=1.14
MMNA01 smdNA0 Sb VGND VNB sky130_fd_pr__nfet_01v8 m=1 w=0.42u l=0.15u mult=1 sa=0.265
+ sb=0.265 sd=0.28 area=0.063 perim=1.14
MMNA10 xb A1 sndNA1 VNB sky130_fd_pr__nfet_01v8 m=1 w=0.42u l=0.15u mult=1 sa=0.265
+ sb=0.265 sd=0.28 area=0.063 perim=1.14
MMNA11 sndNA1 S VGND VNB sky130_fd_pr__nfet_01v8 m=1 w=0.42u l=0.15u mult=1 sa=0.265
+ sb=0.265 sd=0.28 area=0.063 perim=1.14
MMIN1 Sb S VGND VNB sky130_fd_pr__nfet_01v8 m=1 w=0.42u l=0.15u mult=1 sa=0.265
+ sb=0.265 sd=0.28 area=0.063 perim=1.14
MMIN2 X xb VGND VNB sky130_fd_pr__nfet_01v8 m=1 w=0.65u l=0.15u mult=1 sa=0.265
+ sb=0.265 sd=0.28 area=0.063 perim=1.14
MMPA00 net59 S sndPS VNB sky130_fd_pr__pfet_01v8_hvt m=1 w=0.42u l=0.15u mult=1
+ sa=0.265 sb=0.265 sd=0.28 area=0.063 perim=1.14
MMPA01 sndPS A0 xb VNB sky130_fd_pr__pfet_01v8_hvt m=1 w=0.42u l=0.15u mult=1 sa=0.265
+ sb=0.265 sd=0.28 area=0.063 perim=1.14
MMPA10 net59 Sb sndPSb VNB sky130_fd_pr__pfet_01v8_hvt m=1 w=0.42u l=0.15u mult=1
+ sa=0.265 sb=0.265 sd=0.28 area=0.063 perim=1.14
MMPA11 sndPSb A1 xb VNB sky130_fd_pr__pfet_01v8_hvt m=1 w=0.42u l=0.15u mult=1
+ sa=0.265 sb=0.265 sd=0.28 area=0.063 perim=1.14
MMIP1 Sb S net59 VNB sky130_fd_pr__pfet_01v8_hvt m=1 w=0.42u l=0.15u mult=1 sa=0.265
+ sb=0.265 sd=0.28 area=0.063 perim=1.14
MMIP2 X xb net59 VNB sky130_fd_pr__pfet_01v8_hvt m=1 w=1.0u l=0.15u mult=1 sa=0.265
+ sb=0.265 sd=0.28 area=0.063 perim=1.14
.ENDS sky130_fd_sc_hd__mux2_1
* Copyright 2020 The SkyWater PDK Authors
*
* Licensed under the Apache License, Version 2.0 (the "License");
* you may not use this file except in compliance with the License.
* You may obtain a copy of the License at
*
*     https:  www.apache.org licenses LICENSE-2.0
*
* Unless required by applicable law or agreed to in writing, software
* distributed under the License is distributed on an "AS IS" BASIS,
* WITHOUT WARRANTIES OR CONDITIONS OF ANY KIND, either express or implied.
* See the License for the specific language governing permissions and
* limitations under the License.
*
* SPDX-License-Identifier: Apache-2.0

.SUBCKT sky130_fd_sc_hd__mux2_2 A0 A1 S VGND VNB VNB net59 X
*.PININFO A0:I A1:I S:I VGND:I VNB:I VNB:I net59:I X:O
MMNA00 xb A0 smdNA0 VNB sky130_fd_pr__nfet_01v8 m=1 w=0.42u l=0.15u mult=1 sa=0.265
+ sb=0.265 sd=0.28 area=0.063 perim=1.14
MMNA01 smdNA0 Sb VGND VNB sky130_fd_pr__nfet_01v8 m=1 w=0.42u l=0.15u mult=1 sa=0.265
+ sb=0.265 sd=0.28 area=0.063 perim=1.14
MMNA10 xb A1 sndNA1 VNB sky130_fd_pr__nfet_01v8 m=1 w=0.42u l=0.15u mult=1 sa=0.265
+ sb=0.265 sd=0.28 area=0.063 perim=1.14
MMNA11 sndNA1 S VGND VNB sky130_fd_pr__nfet_01v8 m=1 w=0.42u l=0.15u mult=1 sa=0.265
+ sb=0.265 sd=0.28 area=0.063 perim=1.14
MMIN1 Sb S VGND VNB sky130_fd_pr__nfet_01v8 m=1 w=0.42u l=0.15u mult=1 sa=0.265
+ sb=0.265 sd=0.28 area=0.063 perim=1.14
MMIN2 X xb VGND VNB sky130_fd_pr__nfet_01v8 m=2 w=0.65u l=0.15u mult=1 sa=0.265
+ sb=0.265 sd=0.28 area=0.063 perim=1.14
MMPA00 net59 S sndPS VNB sky130_fd_pr__pfet_01v8_hvt m=1 w=0.64u l=0.15u mult=1
+ sa=0.265 sb=0.265 sd=0.28 area=0.063 perim=1.14
MMPA01 sndPS A0 xb VNB sky130_fd_pr__pfet_01v8_hvt m=1 w=0.64u l=0.15u mult=1 sa=0.265
+ sb=0.265 sd=0.28 area=0.063 perim=1.14
MMPA10 net59 Sb sndPSb VNB sky130_fd_pr__pfet_01v8_hvt m=1 w=0.64u l=0.15u mult=1
+ sa=0.265 sb=0.265 sd=0.28 area=0.063 perim=1.14
MMPA11 sndPSb A1 xb VNB sky130_fd_pr__pfet_01v8_hvt m=1 w=0.64u l=0.15u mult=1
+ sa=0.265 sb=0.265 sd=0.28 area=0.063 perim=1.14
MMIP1 Sb S net59 VNB sky130_fd_pr__pfet_01v8_hvt m=1 w=0.64u l=0.15u mult=1 sa=0.265
+ sb=0.265 sd=0.28 area=0.063 perim=1.14
MMIP2 X xb net59 VNB sky130_fd_pr__pfet_01v8_hvt m=2 w=1.0u l=0.15u mult=1 sa=0.265
+ sb=0.265 sd=0.28 area=0.063 perim=1.14
.ENDS sky130_fd_sc_hd__mux2_2
* Copyright 2020 The SkyWater PDK Authors
*
* Licensed under the Apache License, Version 2.0 (the "License");
* you may not use this file except in compliance with the License.
* You may obtain a copy of the License at
*
*     https:  www.apache.org licenses LICENSE-2.0
*
* Unless required by applicable law or agreed to in writing, software
* distributed under the License is distributed on an "AS IS" BASIS,
* WITHOUT WARRANTIES OR CONDITIONS OF ANY KIND, either express or implied.
* See the License for the specific language governing permissions and
* limitations under the License.
*
* SPDX-License-Identifier: Apache-2.0

.SUBCKT sky130_fd_sc_hd__mux2_4 A0 A1 S VGND VNB VNB net59 X
*.PININFO A0:I A1:I S:I VGND:I VNB:I VNB:I net59:I X:O
MMNA00 xb A0 smdNA0 VNB sky130_fd_pr__nfet_01v8 m=1 w=0.65u l=0.15u mult=1 sa=0.265
+ sb=0.265 sd=0.28 area=0.063 perim=1.14
MMNA01 smdNA0 Sb VGND VNB sky130_fd_pr__nfet_01v8 m=1 w=0.65u l=0.15u mult=1 sa=0.265
+ sb=0.265 sd=0.28 area=0.063 perim=1.14
MMNA10 xb A1 sndNA1 VNB sky130_fd_pr__nfet_01v8 m=1 w=0.65u l=0.15u mult=1 sa=0.265
+ sb=0.265 sd=0.28 area=0.063 perim=1.14
MMNA11 sndNA1 S VGND VNB sky130_fd_pr__nfet_01v8 m=1 w=0.65u l=0.15u mult=1 sa=0.265
+ sb=0.265 sd=0.28 area=0.063 perim=1.14
MMIN1 Sb S VGND VNB sky130_fd_pr__nfet_01v8 m=1 w=0.65u l=0.15u mult=1 sa=0.265
+ sb=0.265 sd=0.28 area=0.063 perim=1.14
MMIN2 X xb VGND VNB sky130_fd_pr__nfet_01v8 m=4 w=0.65u l=0.15u mult=1 sa=0.265
+ sb=0.265 sd=0.28 area=0.063 perim=1.14
MMPA00 net59 S sndPS VNB sky130_fd_pr__pfet_01v8_hvt m=1 w=1.0u l=0.15u mult=1 sa=0.265
+ sb=0.265 sd=0.28 area=0.063 perim=1.14
MMPA01 sndPS A0 xb VNB sky130_fd_pr__pfet_01v8_hvt m=1 w=1.0u l=0.15u mult=1 sa=0.265
+ sb=0.265 sd=0.28 area=0.063 perim=1.14
MMPA10 net59 Sb sndPSb VNB sky130_fd_pr__pfet_01v8_hvt m=1 w=1.0u l=0.15u mult=1
+ sa=0.265 sb=0.265 sd=0.28 area=0.063 perim=1.14
MMPA11 sndPSb A1 xb VNB sky130_fd_pr__pfet_01v8_hvt m=1 w=1.0u l=0.15u mult=1 sa=0.265
+ sb=0.265 sd=0.28 area=0.063 perim=1.14
MMIP1 Sb S net59 VNB sky130_fd_pr__pfet_01v8_hvt m=1 w=1.0u l=0.15u mult=1 sa=0.265
+ sb=0.265 sd=0.28 area=0.063 perim=1.14
MMIP2 X xb net59 VNB sky130_fd_pr__pfet_01v8_hvt m=4 w=1.0u l=0.15u mult=1 sa=0.265
+ sb=0.265 sd=0.28 area=0.063 perim=1.14
.ENDS sky130_fd_sc_hd__mux2_4
* Copyright 2020 The SkyWater PDK Authors
*
* Licensed under the Apache License, Version 2.0 (the "License");
* you may not use this file except in compliance with the License.
* You may obtain a copy of the License at
*
*     https:  www.apache.org licenses LICENSE-2.0
*
* Unless required by applicable law or agreed to in writing, software
* distributed under the License is distributed on an "AS IS" BASIS,
* WITHOUT WARRANTIES OR CONDITIONS OF ANY KIND, either express or implied.
* See the License for the specific language governing permissions and
* limitations under the License.
*
* SPDX-License-Identifier: Apache-2.0

.SUBCKT sky130_fd_sc_hd__mux2_8 A0 A1 S VGND VNB VNB net59 X
*.PININFO A0:I A1:I S:I VGND:I VNB:I VNB:I net59:I X:O
MMNA00 xb A0 smdNA0 VNB sky130_fd_pr__nfet_01v8 m=2 w=0.64u l=0.15u mult=1 sa=0.265
+ sb=0.265 sd=0.28 area=0.063 perim=1.14
MMNA01 smdNA0 Sb VGND VNB sky130_fd_pr__nfet_01v8 m=2 w=0.64u l=0.15u mult=1 sa=0.265
+ sb=0.265 sd=0.28 area=0.063 perim=1.14
MMNA10 xb A1 sndNA1 VNB sky130_fd_pr__nfet_01v8 m=2 w=0.64u l=0.15u mult=1 sa=0.265
+ sb=0.265 sd=0.28 area=0.063 perim=1.14
MMNA11 sndNA1 S VGND VNB sky130_fd_pr__nfet_01v8 m=2 w=0.64u l=0.15u mult=1 sa=0.265
+ sb=0.265 sd=0.28 area=0.063 perim=1.14
MMIN1 Sb S VGND VNB sky130_fd_pr__nfet_01v8 m=1 w=0.65u l=0.15u mult=1 sa=0.265
+ sb=0.265 sd=0.28 area=0.063 perim=1.14
MMIN2 X xb VGND VNB sky130_fd_pr__nfet_01v8 m=8 w=0.65u l=0.15u mult=1 sa=0.265
+ sb=0.265 sd=0.28 area=0.063 perim=1.14
MMPA00 net59 S sndPS VNB sky130_fd_pr__pfet_01v8_hvt m=2 w=1.0u l=0.15u mult=1 sa=0.265
+ sb=0.265 sd=0.28 area=0.063 perim=1.14
MMPA01 sndPS A0 xb VNB sky130_fd_pr__pfet_01v8_hvt m=2 w=1.0u l=0.15u mult=1 sa=0.265
+ sb=0.265 sd=0.28 area=0.063 perim=1.14
MMPA10 net59 Sb sndPSb VNB sky130_fd_pr__pfet_01v8_hvt m=2 w=1.0u l=0.15u mult=1
+ sa=0.265 sb=0.265 sd=0.28 area=0.063 perim=1.14
MMPA11 sndPSb A1 xb VNB sky130_fd_pr__pfet_01v8_hvt m=2 w=1.0u l=0.15u mult=1 sa=0.265
+ sb=0.265 sd=0.28 area=0.063 perim=1.14
MMIP1 Sb S net59 VNB sky130_fd_pr__pfet_01v8_hvt m=1 w=1.0u l=0.15u mult=1 sa=0.265
+ sb=0.265 sd=0.28 area=0.063 perim=1.14
MMIP2 X xb net59 VNB sky130_fd_pr__pfet_01v8_hvt m=8 w=1.0u l=0.15u mult=1 sa=0.265
+ sb=0.265 sd=0.28 area=0.063 perim=1.14
.ENDS sky130_fd_sc_hd__mux2_8
* Copyright 2020 The SkyWater PDK Authors
*
* Licensed under the Apache License, Version 2.0 (the "License");
* you may not use this file except in compliance with the License.
* You may obtain a copy of the License at
*
*     https:  www.apache.org licenses LICENSE-2.0
*
* Unless required by applicable law or agreed to in writing, software
* distributed under the License is distributed on an "AS IS" BASIS,
* WITHOUT WARRANTIES OR CONDITIONS OF ANY KIND, either express or implied.
* See the License for the specific language governing permissions and
* limitations under the License.
*
* SPDX-License-Identifier: Apache-2.0

.SUBCKT sky130_fd_sc_hd__mux2i_1 A0 A1 S VGND VNB VNB net59 Y
*.PININFO A0:I A1:I S:I VGND:I VNB:I VNB:I net59:I Y:O
MMNA00 Y A0 smdNA0 VNB sky130_fd_pr__nfet_01v8 m=1 w=0.65u l=0.15u mult=1 sa=0.265
+ sb=0.265 sd=0.28 area=0.063 perim=1.14
MMNA01 smdNA0 Sb VGND VNB sky130_fd_pr__nfet_01v8 m=1 w=0.65u l=0.15u mult=1 sa=0.265
+ sb=0.265 sd=0.28 area=0.063 perim=1.14
MMNA10 Y A1 sndNA1 VNB sky130_fd_pr__nfet_01v8 m=1 w=0.65u l=0.15u mult=1 sa=0.265
+ sb=0.265 sd=0.28 area=0.063 perim=1.14
MMNA11 sndNA1 S VGND VNB sky130_fd_pr__nfet_01v8 m=1 w=0.65u l=0.15u mult=1 sa=0.265
+ sb=0.265 sd=0.28 area=0.063 perim=1.14
MMIN1 Sb S VGND VNB sky130_fd_pr__nfet_01v8 m=1 w=0.65u l=0.15u mult=1 sa=0.265
+ sb=0.265 sd=0.28 area=0.063 perim=1.14
MMPA00 net59 S sndPS VNB sky130_fd_pr__pfet_01v8_hvt m=1 w=1.0u l=0.15u mult=1 sa=0.265
+ sb=0.265 sd=0.28 area=0.063 perim=1.14
MMPA01 sndPS A0 Y VNB sky130_fd_pr__pfet_01v8_hvt m=1 w=1.0u l=0.15u mult=1 sa=0.265
+ sb=0.265 sd=0.28 area=0.063 perim=1.14
MMPA10 net59 Sb sndPSb VNB sky130_fd_pr__pfet_01v8_hvt m=1 w=1.0u l=0.15u mult=1
+ sa=0.265 sb=0.265 sd=0.28 area=0.063 perim=1.14
MMPA11 sndPSb A1 Y VNB sky130_fd_pr__pfet_01v8_hvt m=1 w=1.0u l=0.15u mult=1 sa=0.265
+ sb=0.265 sd=0.28 area=0.063 perim=1.14
MMIP1 Sb S net59 VNB sky130_fd_pr__pfet_01v8_hvt m=1 w=1.0u l=0.15u mult=1 sa=0.265
+ sb=0.265 sd=0.28 area=0.063 perim=1.14
.ENDS sky130_fd_sc_hd__mux2i_1
* Copyright 2020 The SkyWater PDK Authors
*
* Licensed under the Apache License, Version 2.0 (the "License");
* you may not use this file except in compliance with the License.
* You may obtain a copy of the License at
*
*     https:  www.apache.org licenses LICENSE-2.0
*
* Unless required by applicable law or agreed to in writing, software
* distributed under the License is distributed on an "AS IS" BASIS,
* WITHOUT WARRANTIES OR CONDITIONS OF ANY KIND, either express or implied.
* See the License for the specific language governing permissions and
* limitations under the License.
*
* SPDX-License-Identifier: Apache-2.0

.SUBCKT sky130_fd_sc_hd__mux2i_2 A0 A1 S VGND VNB VNB net59 Y
*.PININFO A0:I A1:I S:I VGND:I VNB:I VNB:I net59:I Y:O
MMNA00 Y A0 smdNA0 VNB sky130_fd_pr__nfet_01v8 m=2 w=0.65u l=0.15u mult=1 sa=0.265
+ sb=0.265 sd=0.28 area=0.063 perim=1.14
MMNA01 smdNA0 Sb VGND VNB sky130_fd_pr__nfet_01v8 m=2 w=0.65u l=0.15u mult=1 sa=0.265
+ sb=0.265 sd=0.28 area=0.063 perim=1.14
MMNA10 Y A1 sndNA1 VNB sky130_fd_pr__nfet_01v8 m=2 w=0.65u l=0.15u mult=1 sa=0.265
+ sb=0.265 sd=0.28 area=0.063 perim=1.14
MMNA11 sndNA1 S VGND VNB sky130_fd_pr__nfet_01v8 m=2 w=0.65u l=0.15u mult=1 sa=0.265
+ sb=0.265 sd=0.28 area=0.063 perim=1.14
MMIN1 Sb S VGND VNB sky130_fd_pr__nfet_01v8 m=1 w=0.65u l=0.15u mult=1 sa=0.265
+ sb=0.265 sd=0.28 area=0.063 perim=1.14
MMPA00 net59 S sndPS VNB sky130_fd_pr__pfet_01v8_hvt m=2 w=1.0u l=0.15u mult=1 sa=0.265
+ sb=0.265 sd=0.28 area=0.063 perim=1.14
MMPA01 sndPS A0 Y VNB sky130_fd_pr__pfet_01v8_hvt m=2 w=1.0u l=0.15u mult=1 sa=0.265
+ sb=0.265 sd=0.28 area=0.063 perim=1.14
MMPA10 net59 Sb sndPSb VNB sky130_fd_pr__pfet_01v8_hvt m=2 w=1.0u l=0.15u mult=1
+ sa=0.265 sb=0.265 sd=0.28 area=0.063 perim=1.14
MMPA11 sndPSb A1 Y VNB sky130_fd_pr__pfet_01v8_hvt m=2 w=1.0u l=0.15u mult=1 sa=0.265
+ sb=0.265 sd=0.28 area=0.063 perim=1.14
MMIP1 Sb S net59 VNB sky130_fd_pr__pfet_01v8_hvt m=1 w=1.0u l=0.15u mult=1 sa=0.265
+ sb=0.265 sd=0.28 area=0.063 perim=1.14
.ENDS sky130_fd_sc_hd__mux2i_2
* Copyright 2020 The SkyWater PDK Authors
*
* Licensed under the Apache License, Version 2.0 (the "License");
* you may not use this file except in compliance with the License.
* You may obtain a copy of the License at
*
*     https:  www.apache.org licenses LICENSE-2.0
*
* Unless required by applicable law or agreed to in writing, software
* distributed under the License is distributed on an "AS IS" BASIS,
* WITHOUT WARRANTIES OR CONDITIONS OF ANY KIND, either express or implied.
* See the License for the specific language governing permissions and
* limitations under the License.
*
* SPDX-License-Identifier: Apache-2.0

.SUBCKT sky130_fd_sc_hd__mux2i_4 A0 A1 S VGND VNB VNB net59 Y
*.PININFO A0:I A1:I S:I VGND:I VNB:I VNB:I net59:I Y:O
MMNA00 Y A0 smdNA0 VNB sky130_fd_pr__nfet_01v8 m=4 w=0.65u l=0.15u mult=1 sa=0.265
+ sb=0.265 sd=0.28 area=0.063 perim=1.14
MMNA01 smdNA0 Sb VGND VNB sky130_fd_pr__nfet_01v8 m=4 w=0.65u l=0.15u mult=1 sa=0.265
+ sb=0.265 sd=0.28 area=0.063 perim=1.14
MMNA10 Y A1 sndNA1 VNB sky130_fd_pr__nfet_01v8 m=4 w=0.65u l=0.15u mult=1 sa=0.265
+ sb=0.265 sd=0.28 area=0.063 perim=1.14
MMNA11 sndNA1 S VGND VNB sky130_fd_pr__nfet_01v8 m=4 w=0.65u l=0.15u mult=1 sa=0.265
+ sb=0.265 sd=0.28 area=0.063 perim=1.14
MMIN1 Sb S VGND VNB sky130_fd_pr__nfet_01v8 m=1 w=0.65u l=0.15u mult=1 sa=0.265
+ sb=0.265 sd=0.28 area=0.063 perim=1.14
MMPA00 net59 S sndPS VNB sky130_fd_pr__pfet_01v8_hvt m=4 w=1.0u l=0.15u mult=1 sa=0.265
+ sb=0.265 sd=0.28 area=0.063 perim=1.14
MMPA01 sndPS A0 Y VNB sky130_fd_pr__pfet_01v8_hvt m=4 w=1.0u l=0.15u mult=1 sa=0.265
+ sb=0.265 sd=0.28 area=0.063 perim=1.14
MMPA10 net59 Sb sndPSb VNB sky130_fd_pr__pfet_01v8_hvt m=4 w=1.0u l=0.15u mult=1
+ sa=0.265 sb=0.265 sd=0.28 area=0.063 perim=1.14
MMPA11 sndPSb A1 Y VNB sky130_fd_pr__pfet_01v8_hvt m=4 w=1.0u l=0.15u mult=1 sa=0.265
+ sb=0.265 sd=0.28 area=0.063 perim=1.14
MMIP1 Sb S net59 VNB sky130_fd_pr__pfet_01v8_hvt m=1 w=1.0u l=0.15u mult=1 sa=0.265
+ sb=0.265 sd=0.28 area=0.063 perim=1.14
.ENDS sky130_fd_sc_hd__mux2i_4
* Copyright 2020 The SkyWater PDK Authors
*
* Licensed under the Apache License, Version 2.0 (the "License");
* you may not use this file except in compliance with the License.
* You may obtain a copy of the License at
*
*     https:  www.apache.org licenses LICENSE-2.0
*
* Unless required by applicable law or agreed to in writing, software
* distributed under the License is distributed on an "AS IS" BASIS,
* WITHOUT WARRANTIES OR CONDITIONS OF ANY KIND, either express or implied.
* See the License for the specific language governing permissions and
* limitations under the License.
*
* SPDX-License-Identifier: Apache-2.0

.SUBCKT sky130_fd_sc_hd__mux4_1 A0 A1 A2 A3 S0 S1 VGND VNB VNB net59 X
*.PININFO A0:I A1:I A2:I A3:I S0:I S1:I VGND:I VNB:I VNB:I net59:I X:O
MMNA00 sndNS0ba0 S0b xlowb VNB sky130_fd_pr__nfet_01v8 m=1 w=0.42u l=0.15u mult=1
+ sa=0.265 sb=0.265 sd=0.28 area=0.028 perim=0.76
MMNA01 VGND A0 sndNS0ba0 VNB sky130_fd_pr__nfet_01v8 m=1 w=0.42u l=0.15u mult=1
+ sa=0.265 sb=0.265 sd=0.28 area=0.028 perim=0.76
MMNA10 sndNS0a1 S0 xlowb VNB sky130_fd_pr__nfet_01v8 m=1 w=0.42u l=0.15u mult=1
+ sa=0.265 sb=0.265 sd=0.28 area=0.028 perim=0.76
MMNA11 VGND A1 sndNS0a1 VNB sky130_fd_pr__nfet_01v8 m=1 w=0.42u l=0.15u mult=1
+ sa=0.265 sb=0.265 sd=0.28 area=0.028 perim=0.76
MMNA20 sndNS0ba2 S0b xhib VNB sky130_fd_pr__nfet_01v8 m=1 w=0.42u l=0.15u mult=1
+ sa=0.265 sb=0.265 sd=0.28 area=0.028 perim=0.76
MMNA21 VGND A2 sndNS0ba2 VNB sky130_fd_pr__nfet_01v8 m=1 w=0.42u l=0.15u mult=1
+ sa=0.265 sb=0.265 sd=0.28 area=0.028 perim=0.76
MMNA30 sndNS0a3 S0 xhib VNB sky130_fd_pr__nfet_01v8 m=1 w=0.42u l=0.15u mult=1
+ sa=0.265 sb=0.265 sd=0.28 area=0.028 perim=0.76
MMNA31 VGND A3 sndNS0a3 VNB sky130_fd_pr__nfet_01v8 m=1 w=0.42u l=0.15u mult=1
+ sa=0.265 sb=0.265 sd=0.28 area=0.028 perim=0.76
MMNs1o xb S1b xlowb VNB sky130_fd_pr__nfet_01v8 m=1 w=0.42u l=0.15u mult=1 sa=0.265
+ sb=0.265 sd=0.28 area=0.028 perim=0.76
MMNs2o xb S1 xhib VNB sky130_fd_pr__nfet_01v8 m=1 w=0.42u l=0.15u mult=1 sa=0.265
+ sb=0.265 sd=0.28 area=0.028 perim=0.76
MMIN1 VGND S1 S1b VNB sky130_fd_pr__nfet_01v8 m=1 w=0.42u l=0.15u mult=1 sa=0.265
+ sb=0.265 sd=0.28 area=0.028 perim=0.76
MMIN2 VGND S0 S0b VNB sky130_fd_pr__nfet_01v8 m=1 w=0.42u l=0.15u mult=1 sa=0.265
+ sb=0.265 sd=0.28 area=0.028 perim=0.76
MMIN4 VGND xb X VNB sky130_fd_pr__nfet_01v8 m=1 w=0.65u l=0.15u mult=1 sa=0.265
+ sb=0.265 sd=0.28 area=0.028 perim=0.76
MMPA00 sndPA0a0 A0 net59 VNB sky130_fd_pr__pfet_01v8_hvt m=1 w=0.42u l=0.15u mult=1
+ sa=0.265 sb=0.265 sd=0.28 area=0.028 perim=0.76
MMPA01 xlowb S0 sndPA0a0 VNB sky130_fd_pr__pfet_01v8_hvt m=1 w=0.42u l=0.15u mult=1
+ sa=0.265 sb=0.265 sd=0.28 area=0.028 perim=0.76
MMPA10 sndPA1a1 A1 net59 VNB sky130_fd_pr__pfet_01v8_hvt m=1 w=0.42u l=0.15u mult=1
+ sa=0.265 sb=0.265 sd=0.28 area=0.028 perim=0.76
MMPA11 xlowb S0b sndPA1a1 VNB sky130_fd_pr__pfet_01v8_hvt m=1 w=0.42u l=0.15u mult=1
+ sa=0.265 sb=0.265 sd=0.28 area=0.028 perim=0.76
MMPA20 sndPA2a2 A2 net59 VNB sky130_fd_pr__pfet_01v8_hvt m=1 w=0.42u l=0.15u mult=1
+ sa=0.265 sb=0.265 sd=0.28 area=0.028 perim=0.76
MMPA21 xhib S0 sndPA2a2 VNB sky130_fd_pr__pfet_01v8_hvt m=1 w=0.42u l=0.15u mult=1
+ sa=0.265 sb=0.265 sd=0.28 area=0.028 perim=0.76
MMPA30 sndPA3a3 A3 net59 VNB sky130_fd_pr__pfet_01v8_hvt m=1 w=0.42u l=0.15u mult=1
+ sa=0.265 sb=0.265 sd=0.28 area=0.028 perim=0.76
MMPA31 xhib S0b sndPA3a3 VNB sky130_fd_pr__pfet_01v8_hvt m=1 w=0.42u l=0.15u mult=1
+ sa=0.265 sb=0.265 sd=0.28 area=0.028 perim=0.76
MMPs1o xb S1 xlowb VNB sky130_fd_pr__pfet_01v8_hvt m=1 w=0.42u l=0.15u mult=1 sa=0.265
+ sb=0.265 sd=0.28 area=0.028 perim=0.76
MMPs2o xb S1b xhib VNB sky130_fd_pr__pfet_01v8_hvt m=1 w=0.42u l=0.15u mult=1 sa=0.265
+ sb=0.265 sd=0.28 area=0.028 perim=0.76
MMIP1 net59 S1 S1b VNB sky130_fd_pr__pfet_01v8_hvt m=1 w=0.42u l=0.15u mult=1 sa=0.265
+ sb=0.265 sd=0.28 area=0.028 perim=0.76
MMIP2 net59 S0 S0b VNB sky130_fd_pr__pfet_01v8_hvt m=1 w=0.42u l=0.15u mult=1 sa=0.265
+ sb=0.265 sd=0.28 area=0.028 perim=0.76
MMIP4 net59 xb X VNB sky130_fd_pr__pfet_01v8_hvt m=1 w=1.0u l=0.15u mult=1 sa=0.265
+ sb=0.265 sd=0.28 area=0.028 perim=0.76
.ENDS sky130_fd_sc_hd__mux4_1
* Copyright 2020 The SkyWater PDK Authors
*
* Licensed under the Apache License, Version 2.0 (the "License");
* you may not use this file except in compliance with the License.
* You may obtain a copy of the License at
*
*     https:  www.apache.org licenses LICENSE-2.0
*
* Unless required by applicable law or agreed to in writing, software
* distributed under the License is distributed on an "AS IS" BASIS,
* WITHOUT WARRANTIES OR CONDITIONS OF ANY KIND, either express or implied.
* See the License for the specific language governing permissions and
* limitations under the License.
*
* SPDX-License-Identifier: Apache-2.0

.SUBCKT sky130_fd_sc_hd__mux4_2 A0 A1 A2 A3 S0 S1 VGND VNB VNB net59 X
*.PININFO A0:I A1:I A2:I A3:I S0:I S1:I VGND:I VNB:I VNB:I net59:I X:O
MMNA00 sndNS0ba0 S0b xlowb VNB sky130_fd_pr__nfet_01v8 m=1 w=0.36u l=0.15u mult=1
+ sa=0.265 sb=0.265 sd=0.28 area=0.028 perim=0.76
MMNA01 VGND A0 sndNS0ba0 VNB sky130_fd_pr__nfet_01v8 m=1 w=0.42u l=0.15u mult=1
+ sa=0.265 sb=0.265 sd=0.28 area=0.028 perim=0.76
MMNA10 sndNS0a1 S0 xlowb VNB sky130_fd_pr__nfet_01v8 m=1 w=0.36u l=0.15u mult=1
+ sa=0.265 sb=0.265 sd=0.28 area=0.028 perim=0.76
MMNA11 VGND A1 sndNS0a1 VNB sky130_fd_pr__nfet_01v8 m=1 w=0.42u l=0.15u mult=1
+ sa=0.265 sb=0.265 sd=0.28 area=0.028 perim=0.76
MMNA20 sndNS0ba2 S0b xhib VNB sky130_fd_pr__nfet_01v8 m=1 w=0.36u l=0.15u mult=1
+ sa=0.265 sb=0.265 sd=0.28 area=0.028 perim=0.76
MMNA21 VGND A2 sndNS0ba2 VNB sky130_fd_pr__nfet_01v8 m=1 w=0.42u l=0.15u mult=1
+ sa=0.265 sb=0.265 sd=0.28 area=0.028 perim=0.76
MMNA30 sndNS0a3 S0 xhib VNB sky130_fd_pr__nfet_01v8 m=1 w=0.36u l=0.15u mult=1
+ sa=0.265 sb=0.265 sd=0.28 area=0.028 perim=0.76
MMNA31 VGND A3 sndNS0a3 VNB sky130_fd_pr__nfet_01v8 m=1 w=0.42u l=0.15u mult=1
+ sa=0.265 sb=0.265 sd=0.28 area=0.028 perim=0.76
MMNs1o xb S1b xlowb VNB sky130_fd_pr__nfet_01v8 m=1 w=0.42u l=0.15u mult=1 sa=0.265
+ sb=0.265 sd=0.28 area=0.028 perim=0.76
MMNs2o xb S1 xhib VNB sky130_fd_pr__nfet_01v8 m=1 w=0.42u l=0.15u mult=1 sa=0.265
+ sb=0.265 sd=0.28 area=0.028 perim=0.76
MMIN1 VGND S1 S1b VNB sky130_fd_pr__nfet_01v8 m=1 w=0.42u l=0.15u mult=1 sa=0.265
+ sb=0.265 sd=0.28 area=0.028 perim=0.76
MMIN2 VGND S0 S0b VNB sky130_fd_pr__nfet_01v8 m=1 w=0.42u l=0.15u mult=1 sa=0.265
+ sb=0.265 sd=0.28 area=0.028 perim=0.76
MMIN4 VGND xb X VNB sky130_fd_pr__nfet_01v8 m=2 w=0.65u l=0.15u mult=1 sa=0.265
+ sb=0.265 sd=0.28 area=0.028 perim=0.76
MMPA00 sndPA0a0 A0 net59 VNB sky130_fd_pr__pfet_01v8_hvt m=1 w=0.64u l=0.15u mult=1
+ sa=0.265 sb=0.265 sd=0.28 area=0.028 perim=0.76
MMPA01 xlowb S0 sndPA0a0 VNB sky130_fd_pr__pfet_01v8_hvt m=1 w=0.42u l=0.15u mult=1
+ sa=0.265 sb=0.265 sd=0.28 area=0.028 perim=0.76
MMPA10 sndPA1a1 A1 net59 VNB sky130_fd_pr__pfet_01v8_hvt m=1 w=0.64u l=0.15u mult=1
+ sa=0.265 sb=0.265 sd=0.28 area=0.028 perim=0.76
MMPA11 xlowb S0b sndPA1a1 VNB sky130_fd_pr__pfet_01v8_hvt m=1 w=0.42u l=0.15u mult=1
+ sa=0.265 sb=0.265 sd=0.28 area=0.028 perim=0.76
MMPA20 sndPA2a2 A2 net59 VNB sky130_fd_pr__pfet_01v8_hvt m=1 w=0.64u l=0.15u mult=1
+ sa=0.265 sb=0.265 sd=0.28 area=0.028 perim=0.76
MMPA21 xhib S0 sndPA2a2 VNB sky130_fd_pr__pfet_01v8_hvt m=1 w=0.42u l=0.15u mult=1
+ sa=0.265 sb=0.265 sd=0.28 area=0.028 perim=0.76
MMPA30 sndPA3a3 A3 net59 VNB sky130_fd_pr__pfet_01v8_hvt m=1 w=0.64u l=0.15u mult=1
+ sa=0.265 sb=0.265 sd=0.28 area=0.028 perim=0.76
MMPA31 xhib S0b sndPA3a3 VNB sky130_fd_pr__pfet_01v8_hvt m=1 w=0.42u l=0.15u mult=1
+ sa=0.265 sb=0.265 sd=0.28 area=0.028 perim=0.76
MMPs1o xb S1 xlowb VNB sky130_fd_pr__pfet_01v8_hvt m=1 w=0.54u l=0.15u mult=1 sa=0.265
+ sb=0.265 sd=0.28 area=0.028 perim=0.76
MMPs2o xb S1b xhib VNB sky130_fd_pr__pfet_01v8_hvt m=1 w=0.54u l=0.15u mult=1 sa=0.265
+ sb=0.265 sd=0.28 area=0.028 perim=0.76
MMIP1 net59 S1 S1b VNB sky130_fd_pr__pfet_01v8_hvt m=1 w=0.64u l=0.15u mult=1 sa=0.265
+ sb=0.265 sd=0.28 area=0.028 perim=0.76
MMIP2 net59 S0 S0b VNB sky130_fd_pr__pfet_01v8_hvt m=1 w=0.64u l=0.15u mult=1 sa=0.265
+ sb=0.265 sd=0.28 area=0.028 perim=0.76
MMIP4 net59 xb X VNB sky130_fd_pr__pfet_01v8_hvt m=2 w=1.0u l=0.15u mult=1 sa=0.265
+ sb=0.265 sd=0.28 area=0.028 perim=0.76
.ENDS sky130_fd_sc_hd__mux4_2
* Copyright 2020 The SkyWater PDK Authors
*
* Licensed under the Apache License, Version 2.0 (the "License");
* you may not use this file except in compliance with the License.
* You may obtain a copy of the License at
*
*     https:  www.apache.org licenses LICENSE-2.0
*
* Unless required by applicable law or agreed to in writing, software
* distributed under the License is distributed on an "AS IS" BASIS,
* WITHOUT WARRANTIES OR CONDITIONS OF ANY KIND, either express or implied.
* See the License for the specific language governing permissions and
* limitations under the License.
*
* SPDX-License-Identifier: Apache-2.0

.SUBCKT sky130_fd_sc_hd__mux4_4 A0 A1 A2 A3 S0 S1 VGND VNB VNB net59 X
*.PININFO A0:I A1:I A2:I A3:I S0:I S1:I VGND:I VNB:I VNB:I net59:I X:O
MMNA00 sndNS0ba0 S0b xlowb VNB sky130_fd_pr__nfet_01v8 m=1 w=0.36u l=0.15u mult=1
+ sa=0.265 sb=0.265 sd=0.28 area=0.028 perim=0.76
MMNA01 VGND A0 sndNS0ba0 VNB sky130_fd_pr__nfet_01v8 m=1 w=0.42u l=0.15u mult=1
+ sa=0.265 sb=0.265 sd=0.28 area=0.028 perim=0.76
MMNA10 sndNS0a1 S0 xlowb VNB sky130_fd_pr__nfet_01v8 m=1 w=0.36u l=0.15u mult=1
+ sa=0.265 sb=0.265 sd=0.28 area=0.028 perim=0.76
MMNA11 VGND A1 sndNS0a1 VNB sky130_fd_pr__nfet_01v8 m=1 w=0.42u l=0.15u mult=1
+ sa=0.265 sb=0.265 sd=0.28 area=0.028 perim=0.76
MMNA20 sndNS0ba2 S0b xhib VNB sky130_fd_pr__nfet_01v8 m=1 w=0.36u l=0.15u mult=1
+ sa=0.265 sb=0.265 sd=0.28 area=0.028 perim=0.76
MMNA21 VGND A2 sndNS0ba2 VNB sky130_fd_pr__nfet_01v8 m=1 w=0.42u l=0.15u mult=1
+ sa=0.265 sb=0.265 sd=0.28 area=0.028 perim=0.76
MMNA30 sndNS0a3 S0 xhib VNB sky130_fd_pr__nfet_01v8 m=1 w=0.36u l=0.15u mult=1
+ sa=0.265 sb=0.265 sd=0.28 area=0.028 perim=0.76
MMNA31 VGND A3 sndNS0a3 VNB sky130_fd_pr__nfet_01v8 m=1 w=0.42u l=0.15u mult=1
+ sa=0.265 sb=0.265 sd=0.28 area=0.028 perim=0.76
MMNs1o xb S1b xlowb VNB sky130_fd_pr__nfet_01v8 m=1 w=0.42u l=0.15u mult=1 sa=0.265
+ sb=0.265 sd=0.28 area=0.028 perim=0.76
MMNs2o xb S1 xhib VNB sky130_fd_pr__nfet_01v8 m=1 w=0.42u l=0.15u mult=1 sa=0.265
+ sb=0.265 sd=0.28 area=0.028 perim=0.76
MMIN1 VGND S1 S1b VNB sky130_fd_pr__nfet_01v8 m=1 w=0.42u l=0.15u mult=1 sa=0.265
+ sb=0.265 sd=0.28 area=0.028 perim=0.76
MMIN2 VGND S0 S0b VNB sky130_fd_pr__nfet_01v8 m=1 w=0.42u l=0.15u mult=1 sa=0.265
+ sb=0.265 sd=0.28 area=0.028 perim=0.76
MMIN4 VGND xb X VNB sky130_fd_pr__nfet_01v8 m=4 w=0.65u l=0.15u mult=1 sa=0.265
+ sb=0.265 sd=0.28 area=0.028 perim=0.76
MMPA00 sndPA0a0 A0 net59 VNB sky130_fd_pr__pfet_01v8_hvt m=1 w=0.64u l=0.15u mult=1
+ sa=0.265 sb=0.265 sd=0.28 area=0.028 perim=0.76
MMPA01 xlowb S0 sndPA0a0 VNB sky130_fd_pr__pfet_01v8_hvt m=1 w=0.42u l=0.15u mult=1
+ sa=0.265 sb=0.265 sd=0.28 area=0.028 perim=0.76
MMPA10 sndPA1a1 A1 net59 VNB sky130_fd_pr__pfet_01v8_hvt m=1 w=0.64u l=0.15u mult=1
+ sa=0.265 sb=0.265 sd=0.28 area=0.028 perim=0.76
MMPA11 xlowb S0b sndPA1a1 VNB sky130_fd_pr__pfet_01v8_hvt m=1 w=0.42u l=0.15u mult=1
+ sa=0.265 sb=0.265 sd=0.28 area=0.028 perim=0.76
MMPA20 sndPA2a2 A2 net59 VNB sky130_fd_pr__pfet_01v8_hvt m=1 w=0.64u l=0.15u mult=1
+ sa=0.265 sb=0.265 sd=0.28 area=0.028 perim=0.76
MMPA21 xhib S0 sndPA2a2 VNB sky130_fd_pr__pfet_01v8_hvt m=1 w=0.42u l=0.15u mult=1
+ sa=0.265 sb=0.265 sd=0.28 area=0.028 perim=0.76
MMPA30 sndPA3a3 A3 net59 VNB sky130_fd_pr__pfet_01v8_hvt m=1 w=0.64u l=0.15u mult=1
+ sa=0.265 sb=0.265 sd=0.28 area=0.028 perim=0.76
MMPA31 xhib S0b sndPA3a3 VNB sky130_fd_pr__pfet_01v8_hvt m=1 w=0.42u l=0.15u mult=1
+ sa=0.265 sb=0.265 sd=0.28 area=0.028 perim=0.76
MMPs1o xb S1 xlowb VNB sky130_fd_pr__pfet_01v8_hvt m=1 w=0.54u l=0.15u mult=1 sa=0.265
+ sb=0.265 sd=0.28 area=0.028 perim=0.76
MMPs2o xb S1b xhib VNB sky130_fd_pr__pfet_01v8_hvt m=1 w=0.54u l=0.15u mult=1 sa=0.265
+ sb=0.265 sd=0.28 area=0.028 perim=0.76
MMIP1 net59 S1 S1b VNB sky130_fd_pr__pfet_01v8_hvt m=1 w=0.64u l=0.15u mult=1 sa=0.265
+ sb=0.265 sd=0.28 area=0.028 perim=0.76
MMIP2 net59 S0 S0b VNB sky130_fd_pr__pfet_01v8_hvt m=1 w=0.64u l=0.15u mult=1 sa=0.265
+ sb=0.265 sd=0.28 area=0.028 perim=0.76
MMIP4 net59 xb X VNB sky130_fd_pr__pfet_01v8_hvt m=4 w=1.0u l=0.15u mult=1 sa=0.265
+ sb=0.265 sd=0.28 area=0.028 perim=0.76
.ENDS sky130_fd_sc_hd__mux4_4
* Copyright 2020 The SkyWater PDK Authors
*
* Licensed under the Apache License, Version 2.0 (the "License");
* you may not use this file except in compliance with the License.
* You may obtain a copy of the License at
*
*     https:  www.apache.org licenses LICENSE-2.0
*
* Unless required by applicable law or agreed to in writing, software
* distributed under the License is distributed on an "AS IS" BASIS,
* WITHOUT WARRANTIES OR CONDITIONS OF ANY KIND, either express or implied.
* See the License for the specific language governing permissions and
* limitations under the License.
*
* SPDX-License-Identifier: Apache-2.0

.SUBCKT sky130_fd_sc_hd__nand2_1 A B VGND VNB VNB net59 Y
*.PININFO A:I B:I VGND:I VNB:I VNB:I net59:I Y:O
MMP0 Y A net59 VNB sky130_fd_pr__pfet_01v8_hvt m=1 w=1.0u l=0.15u mult=1 sa=0.265
+ sb=0.265 sd=0.28 area=0.063 perim=1.14
MMP1 Y B net59 VNB sky130_fd_pr__pfet_01v8_hvt m=1 w=1.0u l=0.15u mult=1 sa=0.265
+ sb=0.265 sd=0.28 area=0.063 perim=1.14
MMN0 Y A sndA VNB sky130_fd_pr__nfet_01v8 m=1 w=0.65u l=0.15u mult=1 sa=0.265 sb=0.265
+ sd=0.28 area=0.063 perim=1.14
MMN1 sndA B VGND VNB sky130_fd_pr__nfet_01v8 m=1 w=0.65u l=0.15u mult=1 sa=0.265
+ sb=0.265 sd=0.28 area=0.063 perim=1.14
.ENDS sky130_fd_sc_hd__nand2_1
* Copyright 2020 The SkyWater PDK Authors
*
* Licensed under the Apache License, Version 2.0 (the "License");
* you may not use this file except in compliance with the License.
* You may obtain a copy of the License at
*
*     https:  www.apache.org licenses LICENSE-2.0
*
* Unless required by applicable law or agreed to in writing, software
* distributed under the License is distributed on an "AS IS" BASIS,
* WITHOUT WARRANTIES OR CONDITIONS OF ANY KIND, either express or implied.
* See the License for the specific language governing permissions and
* limitations under the License.
*
* SPDX-License-Identifier: Apache-2.0

.SUBCKT sky130_fd_sc_hd__nand2_2 A B VGND VNB VNB net59 Y
*.PININFO A:I B:I VGND:I VNB:I VNB:I net59:I Y:O
MMP0 Y A net59 VNB sky130_fd_pr__pfet_01v8_hvt m=2 w=1.0u l=0.15u mult=1 sa=0.265
+ sb=0.265 sd=0.28 area=0.063 perim=1.14
MMP1 Y B net59 VNB sky130_fd_pr__pfet_01v8_hvt m=2 w=1.0u l=0.15u mult=1 sa=0.265
+ sb=0.265 sd=0.28 area=0.063 perim=1.14
MMN0 Y A sndA VNB sky130_fd_pr__nfet_01v8 m=2 w=0.65u l=0.15u mult=1 sa=0.265 sb=0.265
+ sd=0.28 area=0.063 perim=1.14
MMN1 sndA B VGND VNB sky130_fd_pr__nfet_01v8 m=2 w=0.65u l=0.15u mult=1 sa=0.265
+ sb=0.265 sd=0.28 area=0.063 perim=1.14
.ENDS sky130_fd_sc_hd__nand2_2
* Copyright 2020 The SkyWater PDK Authors
*
* Licensed under the Apache License, Version 2.0 (the "License");
* you may not use this file except in compliance with the License.
* You may obtain a copy of the License at
*
*     https:  www.apache.org licenses LICENSE-2.0
*
* Unless required by applicable law or agreed to in writing, software
* distributed under the License is distributed on an "AS IS" BASIS,
* WITHOUT WARRANTIES OR CONDITIONS OF ANY KIND, either express or implied.
* See the License for the specific language governing permissions and
* limitations under the License.
*
* SPDX-License-Identifier: Apache-2.0

.SUBCKT sky130_fd_sc_hd__nand2_4 A B VGND VNB VNB net59 Y
*.PININFO A:I B:I VGND:I VNB:I VNB:I net59:I Y:O
MMP0 Y A net59 VNB sky130_fd_pr__pfet_01v8_hvt m=4 w=1.0u l=0.15u mult=1 sa=0.265
+ sb=0.265 sd=0.28 area=0.063 perim=1.14
MMP1 Y B net59 VNB sky130_fd_pr__pfet_01v8_hvt m=4 w=1.0u l=0.15u mult=1 sa=0.265
+ sb=0.265 sd=0.28 area=0.063 perim=1.14
MMN0 Y A sndA VNB sky130_fd_pr__nfet_01v8 m=4 w=0.65u l=0.15u mult=1 sa=0.265 sb=0.265
+ sd=0.28 area=0.063 perim=1.14
MMN1 sndA B VGND VNB sky130_fd_pr__nfet_01v8 m=4 w=0.65u l=0.15u mult=1 sa=0.265
+ sb=0.265 sd=0.28 area=0.063 perim=1.14
.ENDS sky130_fd_sc_hd__nand2_4
* Copyright 2020 The SkyWater PDK Authors
*
* Licensed under the Apache License, Version 2.0 (the "License");
* you may not use this file except in compliance with the License.
* You may obtain a copy of the License at
*
*     https:  www.apache.org licenses LICENSE-2.0
*
* Unless required by applicable law or agreed to in writing, software
* distributed under the License is distributed on an "AS IS" BASIS,
* WITHOUT WARRANTIES OR CONDITIONS OF ANY KIND, either express or implied.
* See the License for the specific language governing permissions and
* limitations under the License.
*
* SPDX-License-Identifier: Apache-2.0

.SUBCKT sky130_fd_sc_hd__nand2_8 A B VGND VNB VNB net59 Y
*.PININFO A:I B:I VGND:I VNB:I VNB:I net59:I Y:O
MMP0 Y A net59 VNB sky130_fd_pr__pfet_01v8_hvt m=8 w=1.0u l=0.15u mult=1 sa=0.265
+ sb=0.265 sd=0.28 area=0.063 perim=1.14
MMP1 Y B net59 VNB sky130_fd_pr__pfet_01v8_hvt m=8 w=1.0u l=0.15u mult=1 sa=0.265
+ sb=0.265 sd=0.28 area=0.063 perim=1.14
MMN0 Y A sndA VNB sky130_fd_pr__nfet_01v8 m=8 w=0.65u l=0.15u mult=1 sa=0.265 sb=0.265
+ sd=0.28 area=0.063 perim=1.14
MMN1 sndA B VGND VNB sky130_fd_pr__nfet_01v8 m=8 w=0.65u l=0.15u mult=1 sa=0.265
+ sb=0.265 sd=0.28 area=0.063 perim=1.14
.ENDS sky130_fd_sc_hd__nand2_8
* Copyright 2020 The SkyWater PDK Authors
*
* Licensed under the Apache License, Version 2.0 (the "License");
* you may not use this file except in compliance with the License.
* You may obtain a copy of the License at
*
*     https:  www.apache.org licenses LICENSE-2.0
*
* Unless required by applicable law or agreed to in writing, software
* distributed under the License is distributed on an "AS IS" BASIS,
* WITHOUT WARRANTIES OR CONDITIONS OF ANY KIND, either express or implied.
* See the License for the specific language governing permissions and
* limitations under the License.
*
* SPDX-License-Identifier: Apache-2.0

.SUBCKT sky130_fd_sc_hd__nand2b_1 A_N B VGND VNB VNB net59 Y
*.PININFO A_N:I B:I VGND:I VNB:I VNB:I net59:I Y:O
MMP0 Y A net59 VNB sky130_fd_pr__pfet_01v8_hvt m=1 w=1.0u l=0.15u mult=1 sa=0.265
+ sb=0.265 sd=0.28 area=0.063 perim=1.14
MMP1 Y B net59 VNB sky130_fd_pr__pfet_01v8_hvt m=1 w=1.0u l=0.15u mult=1 sa=0.265
+ sb=0.265 sd=0.28 area=0.063 perim=1.14
MMIP0 A A_N net59 VNB sky130_fd_pr__pfet_01v8_hvt m=1 w=0.42u l=0.15u mult=1 sa=0.265
+ sb=0.265 sd=0.28 area=0.063 perim=1.14
MMN0 Y A sndA VNB sky130_fd_pr__nfet_01v8 m=1 w=0.65u l=0.15u mult=1 sa=0.265 sb=0.265
+ sd=0.28 area=0.063 perim=1.14
MMN1 sndA B VGND VNB sky130_fd_pr__nfet_01v8 m=1 w=0.65u l=0.15u mult=1 sa=0.265
+ sb=0.265 sd=0.28 area=0.063 perim=1.14
MMIN0 A A_N VGND VNB sky130_fd_pr__nfet_01v8 m=1 w=0.42u l=0.15u mult=1 sa=0.265
+ sb=0.265 sd=0.28 area=0.063 perim=1.14
.ENDS sky130_fd_sc_hd__nand2b_1
* Copyright 2020 The SkyWater PDK Authors
*
* Licensed under the Apache License, Version 2.0 (the "License");
* you may not use this file except in compliance with the License.
* You may obtain a copy of the License at
*
*     https:  www.apache.org licenses LICENSE-2.0
*
* Unless required by applicable law or agreed to in writing, software
* distributed under the License is distributed on an "AS IS" BASIS,
* WITHOUT WARRANTIES OR CONDITIONS OF ANY KIND, either express or implied.
* See the License for the specific language governing permissions and
* limitations under the License.
*
* SPDX-License-Identifier: Apache-2.0

.SUBCKT sky130_fd_sc_hd__nand2b_2 A_N B VGND VNB VNB net59 Y
*.PININFO A_N:I B:I VGND:I VNB:I VNB:I net59:I Y:O
MMP0 Y A net59 VNB sky130_fd_pr__pfet_01v8_hvt m=2 w=1.0u l=0.15u mult=1 sa=0.265
+ sb=0.265 sd=0.28 area=0.063 perim=1.14
MMP1 Y B net59 VNB sky130_fd_pr__pfet_01v8_hvt m=2 w=1.0u l=0.15u mult=1 sa=0.265
+ sb=0.265 sd=0.28 area=0.063 perim=1.14
MMIP0 A A_N net59 VNB sky130_fd_pr__pfet_01v8_hvt m=1 w=0.42u l=0.15u mult=1 sa=0.265
+ sb=0.265 sd=0.28 area=0.063 perim=1.14
MMN0 Y A sndA VNB sky130_fd_pr__nfet_01v8 m=2 w=0.65u l=0.15u mult=1 sa=0.265 sb=0.265
+ sd=0.28 area=0.063 perim=1.14
MMN1 sndA B VGND VNB sky130_fd_pr__nfet_01v8 m=2 w=0.65u l=0.15u mult=1 sa=0.265
+ sb=0.265 sd=0.28 area=0.063 perim=1.14
MMIN0 A A_N VGND VNB sky130_fd_pr__nfet_01v8 m=1 w=0.42u l=0.15u mult=1 sa=0.265
+ sb=0.265 sd=0.28 area=0.063 perim=1.14
.ENDS sky130_fd_sc_hd__nand2b_2
* Copyright 2020 The SkyWater PDK Authors
*
* Licensed under the Apache License, Version 2.0 (the "License");
* you may not use this file except in compliance with the License.
* You may obtain a copy of the License at
*
*     https:  www.apache.org licenses LICENSE-2.0
*
* Unless required by applicable law or agreed to in writing, software
* distributed under the License is distributed on an "AS IS" BASIS,
* WITHOUT WARRANTIES OR CONDITIONS OF ANY KIND, either express or implied.
* See the License for the specific language governing permissions and
* limitations under the License.
*
* SPDX-License-Identifier: Apache-2.0

.SUBCKT sky130_fd_sc_hd__nand2b_4 A_N B VGND VNB VNB net59 Y
*.PININFO A_N:I B:I VGND:I VNB:I VNB:I net59:I Y:O
MMP0 Y A net59 VNB sky130_fd_pr__pfet_01v8_hvt m=4 w=1.0u l=0.15u mult=1 sa=0.265
+ sb=0.265 sd=0.28 area=0.063 perim=1.14
MMP1 Y B net59 VNB sky130_fd_pr__pfet_01v8_hvt m=4 w=1.0u l=0.15u mult=1 sa=0.265
+ sb=0.265 sd=0.28 area=0.063 perim=1.14
MMIP0 A A_N net59 VNB sky130_fd_pr__pfet_01v8_hvt m=1 w=1.0u l=0.15u mult=1 sa=0.265
+ sb=0.265 sd=0.28 area=0.063 perim=1.14
MMN0 Y A sndA VNB sky130_fd_pr__nfet_01v8 m=4 w=0.65u l=0.15u mult=1 sa=0.265 sb=0.265
+ sd=0.28 area=0.063 perim=1.14
MMN1 sndA B VGND VNB sky130_fd_pr__nfet_01v8 m=4 w=0.65u l=0.15u mult=1 sa=0.265
+ sb=0.265 sd=0.28 area=0.063 perim=1.14
MMIN0 A A_N VGND VNB sky130_fd_pr__nfet_01v8 m=1 w=0.65u l=0.15u mult=1 sa=0.265
+ sb=0.265 sd=0.28 area=0.063 perim=1.14
.ENDS sky130_fd_sc_hd__nand2b_4
* Copyright 2020 The SkyWater PDK Authors
*
* Licensed under the Apache License, Version 2.0 (the "License");
* you may not use this file except in compliance with the License.
* You may obtain a copy of the License at
*
*     https:  www.apache.org licenses LICENSE-2.0
*
* Unless required by applicable law or agreed to in writing, software
* distributed under the License is distributed on an "AS IS" BASIS,
* WITHOUT WARRANTIES OR CONDITIONS OF ANY KIND, either express or implied.
* See the License for the specific language governing permissions and
* limitations under the License.
*
* SPDX-License-Identifier: Apache-2.0

.SUBCKT sky130_fd_sc_hd__nand3_1 A B C VGND VNB VNB net59 Y
*.PININFO A:I B:I C:I VGND:I VNB:I VNB:I net59:I Y:O
MMP0 Y A net59 VNB sky130_fd_pr__pfet_01v8_hvt m=1 w=1.0u l=0.15u mult=1 sa=0.265
+ sb=0.265 sd=0.28 area=0.063 perim=1.14
MMP1 Y B net59 VNB sky130_fd_pr__pfet_01v8_hvt m=1 w=1.0u l=0.15u mult=1 sa=0.265
+ sb=0.265 sd=0.28 area=0.063 perim=1.14
MMP2 Y C net59 VNB sky130_fd_pr__pfet_01v8_hvt m=1 w=1.0u l=0.15u mult=1 sa=0.265
+ sb=0.265 sd=0.28 area=0.063 perim=1.14
MMN0 Y A sndA VNB sky130_fd_pr__nfet_01v8 m=1 w=0.65u l=0.15u mult=1 sa=0.265 sb=0.265
+ sd=0.28 area=0.063 perim=1.14
MMN1 sndA B sndB VNB sky130_fd_pr__nfet_01v8 m=1 w=0.65u l=0.15u mult=1 sa=0.265
+ sb=0.265 sd=0.28 area=0.063 perim=1.14
MMN2 sndB C VGND VNB sky130_fd_pr__nfet_01v8 m=1 w=0.65u l=0.15u mult=1 sa=0.265
+ sb=0.265 sd=0.28 area=0.063 perim=1.14
.ENDS sky130_fd_sc_hd__nand3_1
* Copyright 2020 The SkyWater PDK Authors
*
* Licensed under the Apache License, Version 2.0 (the "License");
* you may not use this file except in compliance with the License.
* You may obtain a copy of the License at
*
*     https:  www.apache.org licenses LICENSE-2.0
*
* Unless required by applicable law or agreed to in writing, software
* distributed under the License is distributed on an "AS IS" BASIS,
* WITHOUT WARRANTIES OR CONDITIONS OF ANY KIND, either express or implied.
* See the License for the specific language governing permissions and
* limitations under the License.
*
* SPDX-License-Identifier: Apache-2.0

.SUBCKT sky130_fd_sc_hd__nand3_2 A B C VGND VNB VNB net59 Y
*.PININFO A:I B:I C:I VGND:I VNB:I VNB:I net59:I Y:O
MMP0 Y A net59 VNB sky130_fd_pr__pfet_01v8_hvt m=2 w=1.0u l=0.15u mult=1 sa=0.265
+ sb=0.265 sd=0.28 area=0.063 perim=1.14
MMP1 Y B net59 VNB sky130_fd_pr__pfet_01v8_hvt m=2 w=1.0u l=0.15u mult=1 sa=0.265
+ sb=0.265 sd=0.28 area=0.063 perim=1.14
MMP2 Y C net59 VNB sky130_fd_pr__pfet_01v8_hvt m=2 w=1.0u l=0.15u mult=1 sa=0.265
+ sb=0.265 sd=0.28 area=0.063 perim=1.14
MMN0 Y A sndA VNB sky130_fd_pr__nfet_01v8 m=2 w=0.65u l=0.15u mult=1 sa=0.265 sb=0.265
+ sd=0.28 area=0.063 perim=1.14
MMN1 sndA B sndB VNB sky130_fd_pr__nfet_01v8 m=2 w=0.65u l=0.15u mult=1 sa=0.265
+ sb=0.265 sd=0.28 area=0.063 perim=1.14
MMN2 sndB C VGND VNB sky130_fd_pr__nfet_01v8 m=2 w=0.65u l=0.15u mult=1 sa=0.265
+ sb=0.265 sd=0.28 area=0.063 perim=1.14
.ENDS sky130_fd_sc_hd__nand3_2
* Copyright 2020 The SkyWater PDK Authors
*
* Licensed under the Apache License, Version 2.0 (the "License");
* you may not use this file except in compliance with the License.
* You may obtain a copy of the License at
*
*     https:  www.apache.org licenses LICENSE-2.0
*
* Unless required by applicable law or agreed to in writing, software
* distributed under the License is distributed on an "AS IS" BASIS,
* WITHOUT WARRANTIES OR CONDITIONS OF ANY KIND, either express or implied.
* See the License for the specific language governing permissions and
* limitations under the License.
*
* SPDX-License-Identifier: Apache-2.0

.SUBCKT sky130_fd_sc_hd__nand3_4 A B C VGND VNB VNB net59 Y
*.PININFO A:I B:I C:I VGND:I VNB:I VNB:I net59:I Y:O
MMP0 Y A net59 VNB sky130_fd_pr__pfet_01v8_hvt m=4 w=1.0u l=0.15u mult=1 sa=0.265
+ sb=0.265 sd=0.28 area=0.063 perim=1.14
MMP1 Y B net59 VNB sky130_fd_pr__pfet_01v8_hvt m=4 w=1.0u l=0.15u mult=1 sa=0.265
+ sb=0.265 sd=0.28 area=0.063 perim=1.14
MMP2 Y C net59 VNB sky130_fd_pr__pfet_01v8_hvt m=4 w=1.0u l=0.15u mult=1 sa=0.265
+ sb=0.265 sd=0.28 area=0.063 perim=1.14
MMN0 Y A sndA VNB sky130_fd_pr__nfet_01v8 m=4 w=0.65u l=0.15u mult=1 sa=0.265 sb=0.265
+ sd=0.28 area=0.063 perim=1.14
MMN1 sndA B sndB VNB sky130_fd_pr__nfet_01v8 m=4 w=0.65u l=0.15u mult=1 sa=0.265
+ sb=0.265 sd=0.28 area=0.063 perim=1.14
MMN2 sndB C VGND VNB sky130_fd_pr__nfet_01v8 m=4 w=0.65u l=0.15u mult=1 sa=0.265
+ sb=0.265 sd=0.28 area=0.063 perim=1.14
.ENDS sky130_fd_sc_hd__nand3_4
* Copyright 2020 The SkyWater PDK Authors
*
* Licensed under the Apache License, Version 2.0 (the "License");
* you may not use this file except in compliance with the License.
* You may obtain a copy of the License at
*
*     https:  www.apache.org licenses LICENSE-2.0
*
* Unless required by applicable law or agreed to in writing, software
* distributed under the License is distributed on an "AS IS" BASIS,
* WITHOUT WARRANTIES OR CONDITIONS OF ANY KIND, either express or implied.
* See the License for the specific language governing permissions and
* limitations under the License.
*
* SPDX-License-Identifier: Apache-2.0

.SUBCKT sky130_fd_sc_hd__nand3b_1 A_N B C VGND VNB VNB net59 Y
*.PININFO A_N:I B:I C:I VGND:I VNB:I VNB:I net59:I Y:O
MMP0 Y A net59 VNB sky130_fd_pr__pfet_01v8_hvt m=1 w=1.0u l=0.15u mult=1 sa=0.265
+ sb=0.265 sd=0.28 area=0.063 perim=1.14
MMP1 Y B net59 VNB sky130_fd_pr__pfet_01v8_hvt m=1 w=1.0u l=0.15u mult=1 sa=0.265
+ sb=0.265 sd=0.28 area=0.063 perim=1.14
MMP2 Y C net59 VNB sky130_fd_pr__pfet_01v8_hvt m=1 w=1.0u l=0.15u mult=1 sa=0.265
+ sb=0.265 sd=0.28 area=0.063 perim=1.14
MMIP0 A A_N net59 VNB sky130_fd_pr__pfet_01v8_hvt m=1 w=0.42u l=0.15u mult=1 sa=0.265
+ sb=0.265 sd=0.28 area=0.063 perim=1.14
MMN0 Y A sndA VNB sky130_fd_pr__nfet_01v8 m=1 w=0.65u l=0.15u mult=1 sa=0.265 sb=0.265
+ sd=0.28 area=0.063 perim=1.14
MMN1 sndA B sndB VNB sky130_fd_pr__nfet_01v8 m=1 w=0.65u l=0.15u mult=1 sa=0.265
+ sb=0.265 sd=0.28 area=0.063 perim=1.14
MMN2 sndB C VGND VNB sky130_fd_pr__nfet_01v8 m=1 w=0.65u l=0.15u mult=1 sa=0.265
+ sb=0.265 sd=0.28 area=0.063 perim=1.14
MMIN0 A A_N VGND VNB sky130_fd_pr__nfet_01v8 m=1 w=0.42u l=0.15u mult=1 sa=0.265
+ sb=0.265 sd=0.28 area=0.063 perim=1.14
.ENDS sky130_fd_sc_hd__nand3b_1
* Copyright 2020 The SkyWater PDK Authors
*
* Licensed under the Apache License, Version 2.0 (the "License");
* you may not use this file except in compliance with the License.
* You may obtain a copy of the License at
*
*     https:  www.apache.org licenses LICENSE-2.0
*
* Unless required by applicable law or agreed to in writing, software
* distributed under the License is distributed on an "AS IS" BASIS,
* WITHOUT WARRANTIES OR CONDITIONS OF ANY KIND, either express or implied.
* See the License for the specific language governing permissions and
* limitations under the License.
*
* SPDX-License-Identifier: Apache-2.0

.SUBCKT sky130_fd_sc_hd__nand3b_2 A_N B C VGND VNB VNB net59 Y
*.PININFO A_N:I B:I C:I VGND:I VNB:I VNB:I net59:I Y:O
MMP0 Y A net59 VNB sky130_fd_pr__pfet_01v8_hvt m=2 w=1.0u l=0.15u mult=1 sa=0.265
+ sb=0.265 sd=0.28 area=0.063 perim=1.14
MMP1 Y B net59 VNB sky130_fd_pr__pfet_01v8_hvt m=2 w=1.0u l=0.15u mult=1 sa=0.265
+ sb=0.265 sd=0.28 area=0.063 perim=1.14
MMP2 Y C net59 VNB sky130_fd_pr__pfet_01v8_hvt m=2 w=1.0u l=0.15u mult=1 sa=0.265
+ sb=0.265 sd=0.28 area=0.063 perim=1.14
MMIP0 A A_N net59 VNB sky130_fd_pr__pfet_01v8_hvt m=1 w=0.42u l=0.15u mult=1 sa=0.265
+ sb=0.265 sd=0.28 area=0.063 perim=1.14
MMN0 Y A sndA VNB sky130_fd_pr__nfet_01v8 m=2 w=0.65u l=0.15u mult=1 sa=0.265 sb=0.265
+ sd=0.28 area=0.063 perim=1.14
MMN1 sndA B sndB VNB sky130_fd_pr__nfet_01v8 m=2 w=0.65u l=0.15u mult=1 sa=0.265
+ sb=0.265 sd=0.28 area=0.063 perim=1.14
MMN2 sndB C VGND VNB sky130_fd_pr__nfet_01v8 m=2 w=0.65u l=0.15u mult=1 sa=0.265
+ sb=0.265 sd=0.28 area=0.063 perim=1.14
MMIN0 A A_N VGND VNB sky130_fd_pr__nfet_01v8 m=1 w=0.42u l=0.15u mult=1 sa=0.265
+ sb=0.265 sd=0.28 area=0.063 perim=1.14
.ENDS sky130_fd_sc_hd__nand3b_2
* Copyright 2020 The SkyWater PDK Authors
*
* Licensed under the Apache License, Version 2.0 (the "License");
* you may not use this file except in compliance with the License.
* You may obtain a copy of the License at
*
*     https:  www.apache.org licenses LICENSE-2.0
*
* Unless required by applicable law or agreed to in writing, software
* distributed under the License is distributed on an "AS IS" BASIS,
* WITHOUT WARRANTIES OR CONDITIONS OF ANY KIND, either express or implied.
* See the License for the specific language governing permissions and
* limitations under the License.
*
* SPDX-License-Identifier: Apache-2.0

.SUBCKT sky130_fd_sc_hd__nand3b_4 A_N B C VGND VNB VNB net59 Y
*.PININFO A_N:I B:I C:I VGND:I VNB:I VNB:I net59:I Y:O
MMP0 Y A net59 VNB sky130_fd_pr__pfet_01v8_hvt m=4 w=1.0u l=0.15u mult=1 sa=0.265
+ sb=0.265 sd=0.28 area=0.063 perim=1.14
MMP1 Y B net59 VNB sky130_fd_pr__pfet_01v8_hvt m=4 w=1.0u l=0.15u mult=1 sa=0.265
+ sb=0.265 sd=0.28 area=0.063 perim=1.14
MMP2 Y C net59 VNB sky130_fd_pr__pfet_01v8_hvt m=4 w=1.0u l=0.15u mult=1 sa=0.265
+ sb=0.265 sd=0.28 area=0.063 perim=1.14
MMIP0 A A_N net59 VNB sky130_fd_pr__pfet_01v8_hvt m=1 w=1.0u l=0.15u mult=1 sa=0.265
+ sb=0.265 sd=0.28 area=0.063 perim=1.14
MMN0 Y A sndA VNB sky130_fd_pr__nfet_01v8 m=4 w=0.65u l=0.15u mult=1 sa=0.265 sb=0.265
+ sd=0.28 area=0.063 perim=1.14
MMN1 sndA B sndB VNB sky130_fd_pr__nfet_01v8 m=4 w=0.65u l=0.15u mult=1 sa=0.265
+ sb=0.265 sd=0.28 area=0.063 perim=1.14
MMN2 sndB C VGND VNB sky130_fd_pr__nfet_01v8 m=4 w=0.65u l=0.15u mult=1 sa=0.265
+ sb=0.265 sd=0.28 area=0.063 perim=1.14
MMIN0 A A_N VGND VNB sky130_fd_pr__nfet_01v8 m=1 w=0.65u l=0.15u mult=1 sa=0.265
+ sb=0.265 sd=0.28 area=0.063 perim=1.14
.ENDS sky130_fd_sc_hd__nand3b_4
* Copyright 2020 The SkyWater PDK Authors
*
* Licensed under the Apache License, Version 2.0 (the "License");
* you may not use this file except in compliance with the License.
* You may obtain a copy of the License at
*
*     https:  www.apache.org licenses LICENSE-2.0
*
* Unless required by applicable law or agreed to in writing, software
* distributed under the License is distributed on an "AS IS" BASIS,
* WITHOUT WARRANTIES OR CONDITIONS OF ANY KIND, either express or implied.
* See the License for the specific language governing permissions and
* limitations under the License.
*
* SPDX-License-Identifier: Apache-2.0

.SUBCKT sky130_fd_sc_hd__nand4_1 A B C D VGND VNB VNB net59 Y
*.PININFO A:I B:I C:I D:I VGND:I VNB:I VNB:I net59:I Y:O
MMP0 Y A net59 VNB sky130_fd_pr__pfet_01v8_hvt m=1 w=1.0u l=0.15u mult=1 sa=0.265
+ sb=0.265 sd=0.28 area=0.063 perim=1.14
MMP1 Y B net59 VNB sky130_fd_pr__pfet_01v8_hvt m=1 w=1.0u l=0.15u mult=1 sa=0.265
+ sb=0.265 sd=0.28 area=0.063 perim=1.14
MMP3 Y D net59 VNB sky130_fd_pr__pfet_01v8_hvt m=1 w=1.0u l=0.15u mult=1 sa=0.265
+ sb=0.265 sd=0.28 area=0.063 perim=1.14
MMP2 Y C net59 VNB sky130_fd_pr__pfet_01v8_hvt m=1 w=1.0u l=0.15u mult=1 sa=0.265
+ sb=0.265 sd=0.28 area=0.063 perim=1.14
MMN0 Y A sndA VNB sky130_fd_pr__nfet_01v8 m=1 w=0.65u l=0.15u mult=1 sa=0.265 sb=0.265
+ sd=0.28 area=0.063 perim=1.14
MMN1 sndA B sndB VNB sky130_fd_pr__nfet_01v8 m=1 w=0.65u l=0.15u mult=1 sa=0.265
+ sb=0.265 sd=0.28 area=0.063 perim=1.14
MMN2 sndB C sndC VNB sky130_fd_pr__nfet_01v8 m=1 w=0.65u l=0.15u mult=1 sa=0.265
+ sb=0.265 sd=0.28 area=0.063 perim=1.14
MMN3 sndC D VGND VNB sky130_fd_pr__nfet_01v8 m=1 w=0.65u l=0.15u mult=1 sa=0.265
+ sb=0.265 sd=0.28 area=0.063 perim=1.14
.ENDS sky130_fd_sc_hd__nand4_1
* Copyright 2020 The SkyWater PDK Authors
*
* Licensed under the Apache License, Version 2.0 (the "License");
* you may not use this file except in compliance with the License.
* You may obtain a copy of the License at
*
*     https:  www.apache.org licenses LICENSE-2.0
*
* Unless required by applicable law or agreed to in writing, software
* distributed under the License is distributed on an "AS IS" BASIS,
* WITHOUT WARRANTIES OR CONDITIONS OF ANY KIND, either express or implied.
* See the License for the specific language governing permissions and
* limitations under the License.
*
* SPDX-License-Identifier: Apache-2.0

.SUBCKT sky130_fd_sc_hd__nand4_2 A B C D VGND VNB VNB net59 Y
*.PININFO A:I B:I C:I D:I VGND:I VNB:I VNB:I net59:I Y:O
MMP0 Y A net59 VNB sky130_fd_pr__pfet_01v8_hvt m=2 w=1.0u l=0.15u mult=1 sa=0.265
+ sb=0.265 sd=0.28 area=0.063 perim=1.14
MMP1 Y B net59 VNB sky130_fd_pr__pfet_01v8_hvt m=2 w=1.0u l=0.15u mult=1 sa=0.265
+ sb=0.265 sd=0.28 area=0.063 perim=1.14
MMP3 Y D net59 VNB sky130_fd_pr__pfet_01v8_hvt m=2 w=1.0u l=0.15u mult=1 sa=0.265
+ sb=0.265 sd=0.28 area=0.063 perim=1.14
MMP2 Y C net59 VNB sky130_fd_pr__pfet_01v8_hvt m=2 w=1.0u l=0.15u mult=1 sa=0.265
+ sb=0.265 sd=0.28 area=0.063 perim=1.14
MMN0 Y A sndA VNB sky130_fd_pr__nfet_01v8 m=2 w=0.65u l=0.15u mult=1 sa=0.265 sb=0.265
+ sd=0.28 area=0.063 perim=1.14
MMN1 sndA B sndB VNB sky130_fd_pr__nfet_01v8 m=2 w=0.65u l=0.15u mult=1 sa=0.265
+ sb=0.265 sd=0.28 area=0.063 perim=1.14
MMN2 sndB C sndC VNB sky130_fd_pr__nfet_01v8 m=2 w=0.65u l=0.15u mult=1 sa=0.265
+ sb=0.265 sd=0.28 area=0.063 perim=1.14
MMN3 sndC D VGND VNB sky130_fd_pr__nfet_01v8 m=2 w=0.65u l=0.15u mult=1 sa=0.265
+ sb=0.265 sd=0.28 area=0.063 perim=1.14
.ENDS sky130_fd_sc_hd__nand4_2
* Copyright 2020 The SkyWater PDK Authors
*
* Licensed under the Apache License, Version 2.0 (the "License");
* you may not use this file except in compliance with the License.
* You may obtain a copy of the License at
*
*     https:  www.apache.org licenses LICENSE-2.0
*
* Unless required by applicable law or agreed to in writing, software
* distributed under the License is distributed on an "AS IS" BASIS,
* WITHOUT WARRANTIES OR CONDITIONS OF ANY KIND, either express or implied.
* See the License for the specific language governing permissions and
* limitations under the License.
*
* SPDX-License-Identifier: Apache-2.0

.SUBCKT sky130_fd_sc_hd__nand4_4 A B C D VGND VNB VNB net59 Y
*.PININFO A:I B:I C:I D:I VGND:I VNB:I VNB:I net59:I Y:O
MMP0 Y A net59 VNB sky130_fd_pr__pfet_01v8_hvt m=4 w=1.0u l=0.15u mult=1 sa=0.265
+ sb=0.265 sd=0.28 area=0.063 perim=1.14
MMP1 Y B net59 VNB sky130_fd_pr__pfet_01v8_hvt m=4 w=1.0u l=0.15u mult=1 sa=0.265
+ sb=0.265 sd=0.28 area=0.063 perim=1.14
MMP3 Y D net59 VNB sky130_fd_pr__pfet_01v8_hvt m=4 w=1.0u l=0.15u mult=1 sa=0.265
+ sb=0.265 sd=0.28 area=0.063 perim=1.14
MMP2 Y C net59 VNB sky130_fd_pr__pfet_01v8_hvt m=4 w=1.0u l=0.15u mult=1 sa=0.265
+ sb=0.265 sd=0.28 area=0.063 perim=1.14
MMN0 Y A sndA VNB sky130_fd_pr__nfet_01v8 m=4 w=0.65u l=0.15u mult=1 sa=0.265 sb=0.265
+ sd=0.28 area=0.063 perim=1.14
MMN1 sndA B sndB VNB sky130_fd_pr__nfet_01v8 m=4 w=0.65u l=0.15u mult=1 sa=0.265
+ sb=0.265 sd=0.28 area=0.063 perim=1.14
MMN2 sndB C sndC VNB sky130_fd_pr__nfet_01v8 m=4 w=0.65u l=0.15u mult=1 sa=0.265
+ sb=0.265 sd=0.28 area=0.063 perim=1.14
MMN3 sndC D VGND VNB sky130_fd_pr__nfet_01v8 m=4 w=0.65u l=0.15u mult=1 sa=0.265
+ sb=0.265 sd=0.28 area=0.063 perim=1.14
.ENDS sky130_fd_sc_hd__nand4_4
* Copyright 2020 The SkyWater PDK Authors
*
* Licensed under the Apache License, Version 2.0 (the "License");
* you may not use this file except in compliance with the License.
* You may obtain a copy of the License at
*
*     https:  www.apache.org licenses LICENSE-2.0
*
* Unless required by applicable law or agreed to in writing, software
* distributed under the License is distributed on an "AS IS" BASIS,
* WITHOUT WARRANTIES OR CONDITIONS OF ANY KIND, either express or implied.
* See the License for the specific language governing permissions and
* limitations under the License.
*
* SPDX-License-Identifier: Apache-2.0

.SUBCKT sky130_fd_sc_hd__nand4b_1 A_N B C D VGND VNB VNB net59 Y
*.PININFO A_N:I B:I C:I D:I VGND:I VNB:I VNB:I net59:I Y:O
MMP0 Y A net59 VNB sky130_fd_pr__pfet_01v8_hvt m=1 w=1.0u l=0.15u mult=1 sa=0.265
+ sb=0.265 sd=0.28 area=0.063 perim=1.14
MMP1 Y B net59 VNB sky130_fd_pr__pfet_01v8_hvt m=1 w=1.0u l=0.15u mult=1 sa=0.265
+ sb=0.265 sd=0.28 area=0.063 perim=1.14
MMP2 Y C net59 VNB sky130_fd_pr__pfet_01v8_hvt m=1 w=1.0u l=0.15u mult=1 sa=0.265
+ sb=0.265 sd=0.28 area=0.063 perim=1.14
MMP3 Y D net59 VNB sky130_fd_pr__pfet_01v8_hvt m=1 w=1.0u l=0.15u mult=1 sa=0.265
+ sb=0.265 sd=0.28 area=0.063 perim=1.14
MMIP0 A A_N net59 VNB sky130_fd_pr__pfet_01v8_hvt m=1 w=0.42u l=0.15u mult=1 sa=0.265
+ sb=0.265 sd=0.28 area=0.063 perim=1.14
MMN0 Y A sndA VNB sky130_fd_pr__nfet_01v8 m=1 w=0.65u l=0.15u mult=1 sa=0.265 sb=0.265
+ sd=0.28 area=0.063 perim=1.14
MMN1 sndA B sndB VNB sky130_fd_pr__nfet_01v8 m=1 w=0.65u l=0.15u mult=1 sa=0.265
+ sb=0.265 sd=0.28 area=0.063 perim=1.14
MMN2 sndB C sndC VNB sky130_fd_pr__nfet_01v8 m=1 w=0.65u l=0.15u mult=1 sa=0.265
+ sb=0.265 sd=0.28 area=0.063 perim=1.14
MMN3 sndC D VGND VNB sky130_fd_pr__nfet_01v8 m=1 w=0.65u l=0.15u mult=1 sa=0.265
+ sb=0.265 sd=0.28 area=0.063 perim=1.14
MMIN0 A A_N VGND VNB sky130_fd_pr__nfet_01v8 m=1 w=0.42u l=0.15u mult=1 sa=0.265
+ sb=0.265 sd=0.28 area=0.063 perim=1.14
.ENDS sky130_fd_sc_hd__nand4b_1
* Copyright 2020 The SkyWater PDK Authors
*
* Licensed under the Apache License, Version 2.0 (the "License");
* you may not use this file except in compliance with the License.
* You may obtain a copy of the License at
*
*     https:  www.apache.org licenses LICENSE-2.0
*
* Unless required by applicable law or agreed to in writing, software
* distributed under the License is distributed on an "AS IS" BASIS,
* WITHOUT WARRANTIES OR CONDITIONS OF ANY KIND, either express or implied.
* See the License for the specific language governing permissions and
* limitations under the License.
*
* SPDX-License-Identifier: Apache-2.0

.SUBCKT sky130_fd_sc_hd__nand4b_2 A_N B C D VGND VNB VNB net59 Y
*.PININFO A_N:I B:I C:I D:I VGND:I VNB:I VNB:I net59:I Y:O
MMP0 Y A net59 VNB sky130_fd_pr__pfet_01v8_hvt m=2 w=1.0u l=0.15u mult=1 sa=0.265
+ sb=0.265 sd=0.28 area=0.063 perim=1.14
MMP1 Y B net59 VNB sky130_fd_pr__pfet_01v8_hvt m=2 w=1.0u l=0.15u mult=1 sa=0.265
+ sb=0.265 sd=0.28 area=0.063 perim=1.14
MMP2 Y C net59 VNB sky130_fd_pr__pfet_01v8_hvt m=2 w=1.0u l=0.15u mult=1 sa=0.265
+ sb=0.265 sd=0.28 area=0.063 perim=1.14
MMP3 Y D net59 VNB sky130_fd_pr__pfet_01v8_hvt m=2 w=1.0u l=0.15u mult=1 sa=0.265
+ sb=0.265 sd=0.28 area=0.063 perim=1.14
MMIP0 A A_N net59 VNB sky130_fd_pr__pfet_01v8_hvt m=1 w=0.42u l=0.15u mult=1 sa=0.265
+ sb=0.265 sd=0.28 area=0.063 perim=1.14
MMN0 Y A sndA VNB sky130_fd_pr__nfet_01v8 m=2 w=0.65u l=0.15u mult=1 sa=0.265 sb=0.265
+ sd=0.28 area=0.063 perim=1.14
MMN1 sndA B sndB VNB sky130_fd_pr__nfet_01v8 m=2 w=0.65u l=0.15u mult=1 sa=0.265
+ sb=0.265 sd=0.28 area=0.063 perim=1.14
MMN2 sndB C sndC VNB sky130_fd_pr__nfet_01v8 m=2 w=0.65u l=0.15u mult=1 sa=0.265
+ sb=0.265 sd=0.28 area=0.063 perim=1.14
MMN3 sndC D VGND VNB sky130_fd_pr__nfet_01v8 m=2 w=0.65u l=0.15u mult=1 sa=0.265
+ sb=0.265 sd=0.28 area=0.063 perim=1.14
MMIN0 A A_N VGND VNB sky130_fd_pr__nfet_01v8 m=1 w=0.42u l=0.15u mult=1 sa=0.265
+ sb=0.265 sd=0.28 area=0.063 perim=1.14
.ENDS sky130_fd_sc_hd__nand4b_2
* Copyright 2020 The SkyWater PDK Authors
*
* Licensed under the Apache License, Version 2.0 (the "License");
* you may not use this file except in compliance with the License.
* You may obtain a copy of the License at
*
*     https:  www.apache.org licenses LICENSE-2.0
*
* Unless required by applicable law or agreed to in writing, software
* distributed under the License is distributed on an "AS IS" BASIS,
* WITHOUT WARRANTIES OR CONDITIONS OF ANY KIND, either express or implied.
* See the License for the specific language governing permissions and
* limitations under the License.
*
* SPDX-License-Identifier: Apache-2.0

.SUBCKT sky130_fd_sc_hd__nand4b_4 A_N B C D VGND VNB VNB net59 Y
*.PININFO A_N:I B:I C:I D:I VGND:I VNB:I VNB:I net59:I Y:O
MMP0 Y A net59 VNB sky130_fd_pr__pfet_01v8_hvt m=4 w=1.0u l=0.15u mult=1 sa=0.265
+ sb=0.265 sd=0.28 area=0.063 perim=1.14
MMP1 Y B net59 VNB sky130_fd_pr__pfet_01v8_hvt m=4 w=1.0u l=0.15u mult=1 sa=0.265
+ sb=0.265 sd=0.28 area=0.063 perim=1.14
MMP2 Y C net59 VNB sky130_fd_pr__pfet_01v8_hvt m=4 w=1.0u l=0.15u mult=1 sa=0.265
+ sb=0.265 sd=0.28 area=0.063 perim=1.14
MMP3 Y D net59 VNB sky130_fd_pr__pfet_01v8_hvt m=4 w=1.0u l=0.15u mult=1 sa=0.265
+ sb=0.265 sd=0.28 area=0.063 perim=1.14
MMIP0 A A_N net59 VNB sky130_fd_pr__pfet_01v8_hvt m=1 w=1.0u l=0.15u mult=1 sa=0.265
+ sb=0.265 sd=0.28 area=0.063 perim=1.14
MMN0 Y A sndA VNB sky130_fd_pr__nfet_01v8 m=4 w=0.65u l=0.15u mult=1 sa=0.265 sb=0.265
+ sd=0.28 area=0.063 perim=1.14
MMN1 sndA B sndB VNB sky130_fd_pr__nfet_01v8 m=4 w=0.65u l=0.15u mult=1 sa=0.265
+ sb=0.265 sd=0.28 area=0.063 perim=1.14
MMN2 sndB C sndC VNB sky130_fd_pr__nfet_01v8 m=4 w=0.65u l=0.15u mult=1 sa=0.265
+ sb=0.265 sd=0.28 area=0.063 perim=1.14
MMN3 sndC D VGND VNB sky130_fd_pr__nfet_01v8 m=4 w=0.65u l=0.15u mult=1 sa=0.265
+ sb=0.265 sd=0.28 area=0.063 perim=1.14
MMIN0 A A_N VGND VNB sky130_fd_pr__nfet_01v8 m=1 w=0.65u l=0.15u mult=1 sa=0.265
+ sb=0.265 sd=0.28 area=0.063 perim=1.14
.ENDS sky130_fd_sc_hd__nand4b_4
* Copyright 2020 The SkyWater PDK Authors
*
* Licensed under the Apache License, Version 2.0 (the "License");
* you may not use this file except in compliance with the License.
* You may obtain a copy of the License at
*
*     https:  www.apache.org licenses LICENSE-2.0
*
* Unless required by applicable law or agreed to in writing, software
* distributed under the License is distributed on an "AS IS" BASIS,
* WITHOUT WARRANTIES OR CONDITIONS OF ANY KIND, either express or implied.
* See the License for the specific language governing permissions and
* limitations under the License.
*
* SPDX-License-Identifier: Apache-2.0

.SUBCKT sky130_fd_sc_hd__nand4bb_1 A_N B_N C D VGND VNB VNB net59 Y
*.PININFO A_N:I B_N:I C:I D:I VGND:I VNB:I VNB:I net59:I Y:O
MMP0 Y A net59 VNB sky130_fd_pr__pfet_01v8_hvt m=1 w=1.0u l=0.15u mult=1 sa=0.265
+ sb=0.265 sd=0.28 area=0.063 perim=1.14
MMP1 Y B net59 VNB sky130_fd_pr__pfet_01v8_hvt m=1 w=1.0u l=0.15u mult=1 sa=0.265
+ sb=0.265 sd=0.28 area=0.063 perim=1.14
MMP2 Y C net59 VNB sky130_fd_pr__pfet_01v8_hvt m=1 w=1.0u l=0.15u mult=1 sa=0.265
+ sb=0.265 sd=0.28 area=0.063 perim=1.14
MMP3 Y D net59 VNB sky130_fd_pr__pfet_01v8_hvt m=1 w=1.0u l=0.15u mult=1 sa=0.265
+ sb=0.265 sd=0.28 area=0.063 perim=1.14
MMIP0 A A_N net59 VNB sky130_fd_pr__pfet_01v8_hvt m=1 w=0.42u l=0.15u mult=1 sa=0.265
+ sb=0.265 sd=0.28 area=0.063 perim=1.14
MMIP1 B B_N net59 VNB sky130_fd_pr__pfet_01v8_hvt m=1 w=0.42u l=0.15u mult=1 sa=0.265
+ sb=0.265 sd=0.28 area=0.063 perim=1.14
MMN0 Y A sndA VNB sky130_fd_pr__nfet_01v8 m=1 w=0.65u l=0.15u mult=1 sa=0.265 sb=0.265
+ sd=0.28 area=0.063 perim=1.14
MMN1 sndA B sndB VNB sky130_fd_pr__nfet_01v8 m=1 w=0.65u l=0.15u mult=1 sa=0.265
+ sb=0.265 sd=0.28 area=0.063 perim=1.14
MMN2 sndB C sndC VNB sky130_fd_pr__nfet_01v8 m=1 w=0.65u l=0.15u mult=1 sa=0.265
+ sb=0.265 sd=0.28 area=0.063 perim=1.14
MMN3 sndC D VGND VNB sky130_fd_pr__nfet_01v8 m=1 w=0.65u l=0.15u mult=1 sa=0.265
+ sb=0.265 sd=0.28 area=0.063 perim=1.14
MMIN0 A A_N VGND VNB sky130_fd_pr__nfet_01v8 m=1 w=0.42u l=0.15u mult=1 sa=0.265
+ sb=0.265 sd=0.28 area=0.063 perim=1.14
MMIN1 B B_N VGND VNB sky130_fd_pr__nfet_01v8 m=1 w=0.42u l=0.15u mult=1 sa=0.265
+ sb=0.265 sd=0.28 area=0.063 perim=1.14
.ENDS sky130_fd_sc_hd__nand4bb_1
* Copyright 2020 The SkyWater PDK Authors
*
* Licensed under the Apache License, Version 2.0 (the "License");
* you may not use this file except in compliance with the License.
* You may obtain a copy of the License at
*
*     https:  www.apache.org licenses LICENSE-2.0
*
* Unless required by applicable law or agreed to in writing, software
* distributed under the License is distributed on an "AS IS" BASIS,
* WITHOUT WARRANTIES OR CONDITIONS OF ANY KIND, either express or implied.
* See the License for the specific language governing permissions and
* limitations under the License.
*
* SPDX-License-Identifier: Apache-2.0

.SUBCKT sky130_fd_sc_hd__nand4bb_2 A_N B_N C D VGND VNB VNB net59 Y
*.PININFO A_N:I B_N:I C:I D:I VGND:I VNB:I VNB:I net59:I Y:O
MMP0 Y A net59 VNB sky130_fd_pr__pfet_01v8_hvt m=2 w=1.0u l=0.15u mult=1 sa=0.265
+ sb=0.265 sd=0.28 area=0.063 perim=1.14
MMP1 Y B net59 VNB sky130_fd_pr__pfet_01v8_hvt m=2 w=1.0u l=0.15u mult=1 sa=0.265
+ sb=0.265 sd=0.28 area=0.063 perim=1.14
MMP2 Y C net59 VNB sky130_fd_pr__pfet_01v8_hvt m=2 w=1.0u l=0.15u mult=1 sa=0.265
+ sb=0.265 sd=0.28 area=0.063 perim=1.14
MMP3 Y D net59 VNB sky130_fd_pr__pfet_01v8_hvt m=2 w=1.0u l=0.15u mult=1 sa=0.265
+ sb=0.265 sd=0.28 area=0.063 perim=1.14
MMIP0 A A_N net59 VNB sky130_fd_pr__pfet_01v8_hvt m=1 w=0.42u l=0.15u mult=1 sa=0.265
+ sb=0.265 sd=0.28 area=0.063 perim=1.14
MMIP1 B B_N net59 VNB sky130_fd_pr__pfet_01v8_hvt m=1 w=0.42u l=0.15u mult=1 sa=0.265
+ sb=0.265 sd=0.28 area=0.063 perim=1.14
MMN0 Y A sndA VNB sky130_fd_pr__nfet_01v8 m=2 w=0.65u l=0.15u mult=1 sa=0.265 sb=0.265
+ sd=0.28 area=0.063 perim=1.14
MMN1 sndA B sndB VNB sky130_fd_pr__nfet_01v8 m=2 w=0.65u l=0.15u mult=1 sa=0.265
+ sb=0.265 sd=0.28 area=0.063 perim=1.14
MMN2 sndB C sndC VNB sky130_fd_pr__nfet_01v8 m=2 w=0.65u l=0.15u mult=1 sa=0.265
+ sb=0.265 sd=0.28 area=0.063 perim=1.14
MMN3 sndC D VGND VNB sky130_fd_pr__nfet_01v8 m=2 w=0.65u l=0.15u mult=1 sa=0.265
+ sb=0.265 sd=0.28 area=0.063 perim=1.14
MMIN0 A A_N VGND VNB sky130_fd_pr__nfet_01v8 m=1 w=0.42u l=0.15u mult=1 sa=0.265
+ sb=0.265 sd=0.28 area=0.063 perim=1.14
MMIN1 B B_N VGND VNB sky130_fd_pr__nfet_01v8 m=1 w=0.42u l=0.15u mult=1 sa=0.265
+ sb=0.265 sd=0.28 area=0.063 perim=1.14
.ENDS sky130_fd_sc_hd__nand4bb_2
* Copyright 2020 The SkyWater PDK Authors
*
* Licensed under the Apache License, Version 2.0 (the "License");
* you may not use this file except in compliance with the License.
* You may obtain a copy of the License at
*
*     https:  www.apache.org licenses LICENSE-2.0
*
* Unless required by applicable law or agreed to in writing, software
* distributed under the License is distributed on an "AS IS" BASIS,
* WITHOUT WARRANTIES OR CONDITIONS OF ANY KIND, either express or implied.
* See the License for the specific language governing permissions and
* limitations under the License.
*
* SPDX-License-Identifier: Apache-2.0

.SUBCKT sky130_fd_sc_hd__nand4bb_4 A_N B_N C D VGND VNB VNB net59 Y
*.PININFO A_N:I B_N:I C:I D:I VGND:I VNB:I VNB:I net59:I Y:O
MMP0 Y A net59 VNB sky130_fd_pr__pfet_01v8_hvt m=4 w=1.0u l=0.15u mult=1 sa=0.265
+ sb=0.265 sd=0.28 area=0.063 perim=1.14
MMP1 Y B net59 VNB sky130_fd_pr__pfet_01v8_hvt m=4 w=1.0u l=0.15u mult=1 sa=0.265
+ sb=0.265 sd=0.28 area=0.063 perim=1.14
MMP2 Y C net59 VNB sky130_fd_pr__pfet_01v8_hvt m=4 w=1.0u l=0.15u mult=1 sa=0.265
+ sb=0.265 sd=0.28 area=0.063 perim=1.14
MMP3 Y D net59 VNB sky130_fd_pr__pfet_01v8_hvt m=4 w=1.0u l=0.15u mult=1 sa=0.265
+ sb=0.265 sd=0.28 area=0.063 perim=1.14
MMIP0 A A_N net59 VNB sky130_fd_pr__pfet_01v8_hvt m=1 w=1.0u l=0.15u mult=1 sa=0.265
+ sb=0.265 sd=0.28 area=0.063 perim=1.14
MMIP1 B B_N net59 VNB sky130_fd_pr__pfet_01v8_hvt m=1 w=1.0u l=0.15u mult=1 sa=0.265
+ sb=0.265 sd=0.28 area=0.063 perim=1.14
MMN0 Y A sndA VNB sky130_fd_pr__nfet_01v8 m=4 w=0.65u l=0.15u mult=1 sa=0.265 sb=0.265
+ sd=0.28 area=0.063 perim=1.14
MMN1 sndA B sndB VNB sky130_fd_pr__nfet_01v8 m=4 w=0.65u l=0.15u mult=1 sa=0.265
+ sb=0.265 sd=0.28 area=0.063 perim=1.14
MMN2 sndB C sndC VNB sky130_fd_pr__nfet_01v8 m=4 w=0.65u l=0.15u mult=1 sa=0.265
+ sb=0.265 sd=0.28 area=0.063 perim=1.14
MMN3 sndC D VGND VNB sky130_fd_pr__nfet_01v8 m=4 w=0.65u l=0.15u mult=1 sa=0.265
+ sb=0.265 sd=0.28 area=0.063 perim=1.14
MMIN0 A A_N VGND VNB sky130_fd_pr__nfet_01v8 m=1 w=0.65u l=0.15u mult=1 sa=0.265
+ sb=0.265 sd=0.28 area=0.063 perim=1.14
MMIN1 B B_N VGND VNB sky130_fd_pr__nfet_01v8 m=1 w=0.65u l=0.15u mult=1 sa=0.265
+ sb=0.265 sd=0.28 area=0.063 perim=1.14
.ENDS sky130_fd_sc_hd__nand4bb_4
* Copyright 2020 The SkyWater PDK Authors
*
* Licensed under the Apache License, Version 2.0 (the "License");
* you may not use this file except in compliance with the License.
* You may obtain a copy of the License at
*
*     https:  www.apache.org licenses LICENSE-2.0
*
* Unless required by applicable law or agreed to in writing, software
* distributed under the License is distributed on an "AS IS" BASIS,
* WITHOUT WARRANTIES OR CONDITIONS OF ANY KIND, either express or implied.
* See the License for the specific language governing permissions and
* limitations under the License.
*
* SPDX-License-Identifier: Apache-2.0

.SUBCKT sky130_fd_sc_hd__nor2_1 A B VGND VNB VNB net59 Y
*.PININFO A:I B:I VGND:I VNB:I VNB:I net59:I Y:O
MMP0 net59 A sndPA VNB sky130_fd_pr__pfet_01v8_hvt m=1 w=1.0u l=0.15u mult=1 sa=0.265
+ sb=0.265 sd=0.28 area=0.063 perim=1.14
MMP1 sndPA B Y VNB sky130_fd_pr__pfet_01v8_hvt m=1 w=1.0u l=0.15u mult=1 sa=0.265
+ sb=0.265 sd=0.28 area=0.063 perim=1.14
MMN0 Y A VGND VNB sky130_fd_pr__nfet_01v8 m=1 w=0.65u l=0.15u mult=1 sa=0.265 sb=0.265
+ sd=0.28 area=0.063 perim=1.14
MMN1 Y B VGND VNB sky130_fd_pr__nfet_01v8 m=1 w=0.65u l=0.15u mult=1 sa=0.265 sb=0.265
+ sd=0.28 area=0.063 perim=1.14
.ENDS sky130_fd_sc_hd__nor2_1
* Copyright 2020 The SkyWater PDK Authors
*
* Licensed under the Apache License, Version 2.0 (the "License");
* you may not use this file except in compliance with the License.
* You may obtain a copy of the License at
*
*     https:  www.apache.org licenses LICENSE-2.0
*
* Unless required by applicable law or agreed to in writing, software
* distributed under the License is distributed on an "AS IS" BASIS,
* WITHOUT WARRANTIES OR CONDITIONS OF ANY KIND, either express or implied.
* See the License for the specific language governing permissions and
* limitations under the License.
*
* SPDX-License-Identifier: Apache-2.0

.SUBCKT sky130_fd_sc_hd__nor2_2 A B VGND VNB VNB net59 Y
*.PININFO A:I B:I VGND:I VNB:I VNB:I net59:I Y:O
MMP0 net59 A sndPA VNB sky130_fd_pr__pfet_01v8_hvt m=2 w=1.0u l=0.15u mult=1 sa=0.265
+ sb=0.265 sd=0.28 area=0.063 perim=1.14
MMP1 sndPA B Y VNB sky130_fd_pr__pfet_01v8_hvt m=2 w=1.0u l=0.15u mult=1 sa=0.265
+ sb=0.265 sd=0.28 area=0.063 perim=1.14
MMN0 Y A VGND VNB sky130_fd_pr__nfet_01v8 m=2 w=0.65u l=0.15u mult=1 sa=0.265 sb=0.265
+ sd=0.28 area=0.063 perim=1.14
MMN1 Y B VGND VNB sky130_fd_pr__nfet_01v8 m=2 w=0.65u l=0.15u mult=1 sa=0.265 sb=0.265
+ sd=0.28 area=0.063 perim=1.14
.ENDS sky130_fd_sc_hd__nor2_2
* Copyright 2020 The SkyWater PDK Authors
*
* Licensed under the Apache License, Version 2.0 (the "License");
* you may not use this file except in compliance with the License.
* You may obtain a copy of the License at
*
*     https:  www.apache.org licenses LICENSE-2.0
*
* Unless required by applicable law or agreed to in writing, software
* distributed under the License is distributed on an "AS IS" BASIS,
* WITHOUT WARRANTIES OR CONDITIONS OF ANY KIND, either express or implied.
* See the License for the specific language governing permissions and
* limitations under the License.
*
* SPDX-License-Identifier: Apache-2.0

.SUBCKT sky130_fd_sc_hd__nor2_4 A B VGND VNB VNB net59 Y
*.PININFO A:I B:I VGND:I VNB:I VNB:I net59:I Y:O
MMP0 net59 A sndPA VNB sky130_fd_pr__pfet_01v8_hvt m=4 w=1.0u l=0.15u mult=1 sa=0.265
+ sb=0.265 sd=0.28 area=0.063 perim=1.14
MMP1 sndPA B Y VNB sky130_fd_pr__pfet_01v8_hvt m=4 w=1.0u l=0.15u mult=1 sa=0.265
+ sb=0.265 sd=0.28 area=0.063 perim=1.14
MMN0 Y A VGND VNB sky130_fd_pr__nfet_01v8 m=4 w=0.65u l=0.15u mult=1 sa=0.265 sb=0.265
+ sd=0.28 area=0.063 perim=1.14
MMN1 Y B VGND VNB sky130_fd_pr__nfet_01v8 m=4 w=0.65u l=0.15u mult=1 sa=0.265 sb=0.265
+ sd=0.28 area=0.063 perim=1.14
.ENDS sky130_fd_sc_hd__nor2_4
* Copyright 2020 The SkyWater PDK Authors
*
* Licensed under the Apache License, Version 2.0 (the "License");
* you may not use this file except in compliance with the License.
* You may obtain a copy of the License at
*
*     https:  www.apache.org licenses LICENSE-2.0
*
* Unless required by applicable law or agreed to in writing, software
* distributed under the License is distributed on an "AS IS" BASIS,
* WITHOUT WARRANTIES OR CONDITIONS OF ANY KIND, either express or implied.
* See the License for the specific language governing permissions and
* limitations under the License.
*
* SPDX-License-Identifier: Apache-2.0

.SUBCKT sky130_fd_sc_hd__nor2_8 A B VGND VNB VNB net59 Y
*.PININFO A:I B:I VGND:I VNB:I VNB:I net59:I Y:O
MMP0 net59 A sndPA VNB sky130_fd_pr__pfet_01v8_hvt m=8 w=1.0u l=0.15u mult=1 sa=0.265
+ sb=0.265 sd=0.28 area=0.063 perim=1.14
MMP1 sndPA B Y VNB sky130_fd_pr__pfet_01v8_hvt m=8 w=1.0u l=0.15u mult=1 sa=0.265
+ sb=0.265 sd=0.28 area=0.063 perim=1.14
MMN0 Y A VGND VNB sky130_fd_pr__nfet_01v8 m=8 w=0.65u l=0.15u mult=1 sa=0.265 sb=0.265
+ sd=0.28 area=0.063 perim=1.14
MMN1 Y B VGND VNB sky130_fd_pr__nfet_01v8 m=8 w=0.65u l=0.15u mult=1 sa=0.265 sb=0.265
+ sd=0.28 area=0.063 perim=1.14
.ENDS sky130_fd_sc_hd__nor2_8
* Copyright 2020 The SkyWater PDK Authors
*
* Licensed under the Apache License, Version 2.0 (the "License");
* you may not use this file except in compliance with the License.
* You may obtain a copy of the License at
*
*     https:  www.apache.org licenses LICENSE-2.0
*
* Unless required by applicable law or agreed to in writing, software
* distributed under the License is distributed on an "AS IS" BASIS,
* WITHOUT WARRANTIES OR CONDITIONS OF ANY KIND, either express or implied.
* See the License for the specific language governing permissions and
* limitations under the License.
*
* SPDX-License-Identifier: Apache-2.0

.SUBCKT sky130_fd_sc_hd__nor2b_1 A B_N VGND VNB VNB net59 Y
*.PININFO A:I B_N:I VGND:I VNB:I VNB:I net59:I Y:O
MMP0 net59 A sndPA VNB sky130_fd_pr__pfet_01v8_hvt m=1 w=1.0u l=0.15u mult=1 sa=0.265
+ sb=0.265 sd=0.28 area=0.063 perim=1.14
MMP1 sndPA B Y VNB sky130_fd_pr__pfet_01v8_hvt m=1 w=1.0u l=0.15u mult=1 sa=0.265
+ sb=0.265 sd=0.28 area=0.063 perim=1.14
MMIP1 B B_N net59 VNB sky130_fd_pr__pfet_01v8_hvt m=1 w=0.42u l=0.15u mult=1 sa=0.265
+ sb=0.265 sd=0.28 area=0.063 perim=1.14
MMN0 Y A VGND VNB sky130_fd_pr__nfet_01v8 m=1 w=0.65u l=0.15u mult=1 sa=0.265 sb=0.265
+ sd=0.28 area=0.063 perim=1.14
MMN1 Y B VGND VNB sky130_fd_pr__nfet_01v8 m=1 w=0.65u l=0.15u mult=1 sa=0.265 sb=0.265
+ sd=0.28 area=0.063 perim=1.14
MMIN1 B B_N VGND VNB sky130_fd_pr__nfet_01v8 m=1 w=0.42u l=0.15u mult=1 sa=0.265
+ sb=0.265 sd=0.28 area=0.063 perim=1.14
.ENDS sky130_fd_sc_hd__nor2b_1
* Copyright 2020 The SkyWater PDK Authors
*
* Licensed under the Apache License, Version 2.0 (the "License");
* you may not use this file except in compliance with the License.
* You may obtain a copy of the License at
*
*     https:  www.apache.org licenses LICENSE-2.0
*
* Unless required by applicable law or agreed to in writing, software
* distributed under the License is distributed on an "AS IS" BASIS,
* WITHOUT WARRANTIES OR CONDITIONS OF ANY KIND, either express or implied.
* See the License for the specific language governing permissions and
* limitations under the License.
*
* SPDX-License-Identifier: Apache-2.0

.SUBCKT sky130_fd_sc_hd__nor2b_2 A B_N VGND VNB VNB net59 Y
*.PININFO A:I B_N:I VGND:I VNB:I VNB:I net59:I Y:O
MMP0 net59 A sndPA VNB sky130_fd_pr__pfet_01v8_hvt m=2 w=1.0u l=0.15u mult=1 sa=0.265
+ sb=0.265 sd=0.28 area=0.063 perim=1.14
MMP1 sndPA B Y VNB sky130_fd_pr__pfet_01v8_hvt m=2 w=1.0u l=0.15u mult=1 sa=0.265
+ sb=0.265 sd=0.28 area=0.063 perim=1.14
MMIP1 B B_N net59 VNB sky130_fd_pr__pfet_01v8_hvt m=1 w=0.42u l=0.15u mult=1 sa=0.265
+ sb=0.265 sd=0.28 area=0.063 perim=1.14
MMN0 Y A VGND VNB sky130_fd_pr__nfet_01v8 m=2 w=0.65u l=0.15u mult=1 sa=0.265 sb=0.265
+ sd=0.28 area=0.063 perim=1.14
MMN1 Y B VGND VNB sky130_fd_pr__nfet_01v8 m=2 w=0.65u l=0.15u mult=1 sa=0.265 sb=0.265
+ sd=0.28 area=0.063 perim=1.14
MMIN1 B B_N VGND VNB sky130_fd_pr__nfet_01v8 m=1 w=0.42u l=0.15u mult=1 sa=0.265
+ sb=0.265 sd=0.28 area=0.063 perim=1.14
.ENDS sky130_fd_sc_hd__nor2b_2
* Copyright 2020 The SkyWater PDK Authors
*
* Licensed under the Apache License, Version 2.0 (the "License");
* you may not use this file except in compliance with the License.
* You may obtain a copy of the License at
*
*     https:  www.apache.org licenses LICENSE-2.0
*
* Unless required by applicable law or agreed to in writing, software
* distributed under the License is distributed on an "AS IS" BASIS,
* WITHOUT WARRANTIES OR CONDITIONS OF ANY KIND, either express or implied.
* See the License for the specific language governing permissions and
* limitations under the License.
*
* SPDX-License-Identifier: Apache-2.0

.SUBCKT sky130_fd_sc_hd__nor2b_4 A B_N VGND VNB VNB net59 Y
*.PININFO A:I B_N:I VGND:I VNB:I VNB:I net59:I Y:O
MMP0 net59 A sndPA VNB sky130_fd_pr__pfet_01v8_hvt m=4 w=1.0u l=0.15u mult=1 sa=0.265
+ sb=0.265 sd=0.28 area=0.063 perim=1.14
MMP1 sndPA B Y VNB sky130_fd_pr__pfet_01v8_hvt m=4 w=1.0u l=0.15u mult=1 sa=0.265
+ sb=0.265 sd=0.28 area=0.063 perim=1.14
MMIP1 B B_N net59 VNB sky130_fd_pr__pfet_01v8_hvt m=1 w=1.0u l=0.15u mult=1 sa=0.265
+ sb=0.265 sd=0.28 area=0.063 perim=1.14
MMN0 Y A VGND VNB sky130_fd_pr__nfet_01v8 m=4 w=0.65u l=0.15u mult=1 sa=0.265 sb=0.265
+ sd=0.28 area=0.063 perim=1.14
MMN1 Y B VGND VNB sky130_fd_pr__nfet_01v8 m=4 w=0.65u l=0.15u mult=1 sa=0.265 sb=0.265
+ sd=0.28 area=0.063 perim=1.14
MMIN1 B B_N VGND VNB sky130_fd_pr__nfet_01v8 m=1 w=0.65u l=0.15u mult=1 sa=0.265
+ sb=0.265 sd=0.28 area=0.063 perim=1.14
.ENDS sky130_fd_sc_hd__nor2b_4
* Copyright 2020 The SkyWater PDK Authors
*
* Licensed under the Apache License, Version 2.0 (the "License");
* you may not use this file except in compliance with the License.
* You may obtain a copy of the License at
*
*     https:  www.apache.org licenses LICENSE-2.0
*
* Unless required by applicable law or agreed to in writing, software
* distributed under the License is distributed on an "AS IS" BASIS,
* WITHOUT WARRANTIES OR CONDITIONS OF ANY KIND, either express or implied.
* See the License for the specific language governing permissions and
* limitations under the License.
*
* SPDX-License-Identifier: Apache-2.0

.SUBCKT sky130_fd_sc_hd__nor3_1 A B C VGND VNB VNB net59 Y
*.PININFO A:I B:I C:I VGND:I VNB:I VNB:I net59:I Y:O
MMP0 net59 A sndPA VNB sky130_fd_pr__pfet_01v8_hvt m=1 w=1.0u l=0.15u mult=1 sa=0.265
+ sb=0.265 sd=0.28 area=0.063 perim=1.14
MMP1 sndPA B sndPB VNB sky130_fd_pr__pfet_01v8_hvt m=1 w=1.0u l=0.15u mult=1 sa=0.265
+ sb=0.265 sd=0.28 area=0.063 perim=1.14
MMP2 sndPB C Y VNB sky130_fd_pr__pfet_01v8_hvt m=1 w=1.0u l=0.15u mult=1 sa=0.265
+ sb=0.265 sd=0.28 area=0.063 perim=1.14
MMN0 Y A VGND VNB sky130_fd_pr__nfet_01v8 m=1 w=0.65u l=0.15u mult=1 sa=0.265 sb=0.265
+ sd=0.28 area=0.063 perim=1.14
MMN1 Y B VGND VNB sky130_fd_pr__nfet_01v8 m=1 w=0.65u l=0.15u mult=1 sa=0.265 sb=0.265
+ sd=0.28 area=0.063 perim=1.14
MMN2 Y C VGND VNB sky130_fd_pr__nfet_01v8 m=1 w=0.65u l=0.15u mult=1 sa=0.265 sb=0.265
+ sd=0.28 area=0.063 perim=1.14
.ENDS sky130_fd_sc_hd__nor3_1
* Copyright 2020 The SkyWater PDK Authors
*
* Licensed under the Apache License, Version 2.0 (the "License");
* you may not use this file except in compliance with the License.
* You may obtain a copy of the License at
*
*     https:  www.apache.org licenses LICENSE-2.0
*
* Unless required by applicable law or agreed to in writing, software
* distributed under the License is distributed on an "AS IS" BASIS,
* WITHOUT WARRANTIES OR CONDITIONS OF ANY KIND, either express or implied.
* See the License for the specific language governing permissions and
* limitations under the License.
*
* SPDX-License-Identifier: Apache-2.0

.SUBCKT sky130_fd_sc_hd__nor3_2 A B C VGND VNB VNB net59 Y
*.PININFO A:I B:I C:I VGND:I VNB:I VNB:I net59:I Y:O
MMP0 net59 A sndPA VNB sky130_fd_pr__pfet_01v8_hvt m=2 w=1.0u l=0.15u mult=1 sa=0.265
+ sb=0.265 sd=0.28 area=0.063 perim=1.14
MMP1 sndPA B sndPB VNB sky130_fd_pr__pfet_01v8_hvt m=2 w=1.0u l=0.15u mult=1 sa=0.265
+ sb=0.265 sd=0.28 area=0.063 perim=1.14
MMP2 sndPB C Y VNB sky130_fd_pr__pfet_01v8_hvt m=2 w=1.0u l=0.15u mult=1 sa=0.265
+ sb=0.265 sd=0.28 area=0.063 perim=1.14
MMN0 Y A VGND VNB sky130_fd_pr__nfet_01v8 m=2 w=0.65u l=0.15u mult=1 sa=0.265 sb=0.265
+ sd=0.28 area=0.063 perim=1.14
MMN1 Y B VGND VNB sky130_fd_pr__nfet_01v8 m=2 w=0.65u l=0.15u mult=1 sa=0.265 sb=0.265
+ sd=0.28 area=0.063 perim=1.14
MMN2 Y C VGND VNB sky130_fd_pr__nfet_01v8 m=2 w=0.65u l=0.15u mult=1 sa=0.265 sb=0.265
+ sd=0.28 area=0.063 perim=1.14
.ENDS sky130_fd_sc_hd__nor3_2
* Copyright 2020 The SkyWater PDK Authors
*
* Licensed under the Apache License, Version 2.0 (the "License");
* you may not use this file except in compliance with the License.
* You may obtain a copy of the License at
*
*     https:  www.apache.org licenses LICENSE-2.0
*
* Unless required by applicable law or agreed to in writing, software
* distributed under the License is distributed on an "AS IS" BASIS,
* WITHOUT WARRANTIES OR CONDITIONS OF ANY KIND, either express or implied.
* See the License for the specific language governing permissions and
* limitations under the License.
*
* SPDX-License-Identifier: Apache-2.0

.SUBCKT sky130_fd_sc_hd__nor3_4 A B C VGND VNB VNB net59 Y
*.PININFO A:I B:I C:I VGND:I VNB:I VNB:I net59:I Y:O
MMP0 net59 A sndPA VNB sky130_fd_pr__pfet_01v8_hvt m=4 w=1.0u l=0.15u mult=1 sa=0.265
+ sb=0.265 sd=0.28 area=0.063 perim=1.14
MMP1 sndPA B sndPB VNB sky130_fd_pr__pfet_01v8_hvt m=4 w=1.0u l=0.15u mult=1 sa=0.265
+ sb=0.265 sd=0.28 area=0.063 perim=1.14
MMP2 sndPB C Y VNB sky130_fd_pr__pfet_01v8_hvt m=4 w=1.0u l=0.15u mult=1 sa=0.265
+ sb=0.265 sd=0.28 area=0.063 perim=1.14
MMN0 Y A VGND VNB sky130_fd_pr__nfet_01v8 m=4 w=0.65u l=0.15u mult=1 sa=0.265 sb=0.265
+ sd=0.28 area=0.063 perim=1.14
MMN1 Y B VGND VNB sky130_fd_pr__nfet_01v8 m=4 w=0.65u l=0.15u mult=1 sa=0.265 sb=0.265
+ sd=0.28 area=0.063 perim=1.14
MMN2 Y C VGND VNB sky130_fd_pr__nfet_01v8 m=4 w=0.65u l=0.15u mult=1 sa=0.265 sb=0.265
+ sd=0.28 area=0.063 perim=1.14
.ENDS sky130_fd_sc_hd__nor3_4
* Copyright 2020 The SkyWater PDK Authors
*
* Licensed under the Apache License, Version 2.0 (the "License");
* you may not use this file except in compliance with the License.
* You may obtain a copy of the License at
*
*     https:  www.apache.org licenses LICENSE-2.0
*
* Unless required by applicable law or agreed to in writing, software
* distributed under the License is distributed on an "AS IS" BASIS,
* WITHOUT WARRANTIES OR CONDITIONS OF ANY KIND, either express or implied.
* See the License for the specific language governing permissions and
* limitations under the License.
*
* SPDX-License-Identifier: Apache-2.0

.SUBCKT sky130_fd_sc_hd__nor3b_1 A B C_N VGND VNB VNB net59 Y
*.PININFO A:I B:I C_N:I VGND:I VNB:I VNB:I net59:I Y:O
MMP0 net59 A sndPA VNB sky130_fd_pr__pfet_01v8_hvt m=1 w=1.0u l=0.15u mult=1 sa=0.265
+ sb=0.265 sd=0.28 area=0.063 perim=1.14
MMP1 sndPA B sndPB VNB sky130_fd_pr__pfet_01v8_hvt m=1 w=1.0u l=0.15u mult=1 sa=0.265
+ sb=0.265 sd=0.28 area=0.063 perim=1.14
MMP2 sndPB C Y VNB sky130_fd_pr__pfet_01v8_hvt m=1 w=1.0u l=0.15u mult=1 sa=0.265
+ sb=0.265 sd=0.28 area=0.063 perim=1.14
MMIP2 C C_N net59 VNB sky130_fd_pr__pfet_01v8_hvt m=1 w=0.42u l=0.15u mult=1 sa=0.265
+ sb=0.265 sd=0.28 area=0.063 perim=1.14
MMN0 Y A VGND VNB sky130_fd_pr__nfet_01v8 m=1 w=0.65u l=0.15u mult=1 sa=0.265 sb=0.265
+ sd=0.28 area=0.063 perim=1.14
MMN1 Y B VGND VNB sky130_fd_pr__nfet_01v8 m=1 w=0.65u l=0.15u mult=1 sa=0.265 sb=0.265
+ sd=0.28 area=0.063 perim=1.14
MMN2 Y C VGND VNB sky130_fd_pr__nfet_01v8 m=1 w=0.65u l=0.15u mult=1 sa=0.265 sb=0.265
+ sd=0.28 area=0.063 perim=1.14
MMIN2 C C_N VGND VNB sky130_fd_pr__nfet_01v8 m=1 w=0.42u l=0.15u mult=1 sa=0.265
+ sb=0.265 sd=0.28 area=0.063 perim=1.14
.ENDS sky130_fd_sc_hd__nor3b_1
* Copyright 2020 The SkyWater PDK Authors
*
* Licensed under the Apache License, Version 2.0 (the "License");
* you may not use this file except in compliance with the License.
* You may obtain a copy of the License at
*
*     https:  www.apache.org licenses LICENSE-2.0
*
* Unless required by applicable law or agreed to in writing, software
* distributed under the License is distributed on an "AS IS" BASIS,
* WITHOUT WARRANTIES OR CONDITIONS OF ANY KIND, either express or implied.
* See the License for the specific language governing permissions and
* limitations under the License.
*
* SPDX-License-Identifier: Apache-2.0

.SUBCKT sky130_fd_sc_hd__nor3b_2 A B C_N VGND VNB VNB net59 Y
*.PININFO A:I B:I C_N:I VGND:I VNB:I VNB:I net59:I Y:O
MMP0 net59 A sndPA VNB sky130_fd_pr__pfet_01v8_hvt m=2 w=1.0u l=0.15u mult=1 sa=0.265
+ sb=0.265 sd=0.28 area=0.063 perim=1.14
MMP1 sndPA B sndPB VNB sky130_fd_pr__pfet_01v8_hvt m=2 w=1.0u l=0.15u mult=1 sa=0.265
+ sb=0.265 sd=0.28 area=0.063 perim=1.14
MMP2 sndPB C Y VNB sky130_fd_pr__pfet_01v8_hvt m=2 w=1.0u l=0.15u mult=1 sa=0.265
+ sb=0.265 sd=0.28 area=0.063 perim=1.14
MMIP2 C C_N net59 VNB sky130_fd_pr__pfet_01v8_hvt m=1 w=0.42u l=0.15u mult=1 sa=0.265
+ sb=0.265 sd=0.28 area=0.063 perim=1.14
MMN0 Y A VGND VNB sky130_fd_pr__nfet_01v8 m=2 w=0.65u l=0.15u mult=1 sa=0.265 sb=0.265
+ sd=0.28 area=0.063 perim=1.14
MMN1 Y B VGND VNB sky130_fd_pr__nfet_01v8 m=2 w=0.65u l=0.15u mult=1 sa=0.265 sb=0.265
+ sd=0.28 area=0.063 perim=1.14
MMN2 Y C VGND VNB sky130_fd_pr__nfet_01v8 m=2 w=0.65u l=0.15u mult=1 sa=0.265 sb=0.265
+ sd=0.28 area=0.063 perim=1.14
MMIN2 C C_N VGND VNB sky130_fd_pr__nfet_01v8 m=1 w=0.42u l=0.15u mult=1 sa=0.265
+ sb=0.265 sd=0.28 area=0.063 perim=1.14
.ENDS sky130_fd_sc_hd__nor3b_2
* Copyright 2020 The SkyWater PDK Authors
*
* Licensed under the Apache License, Version 2.0 (the "License");
* you may not use this file except in compliance with the License.
* You may obtain a copy of the License at
*
*     https:  www.apache.org licenses LICENSE-2.0
*
* Unless required by applicable law or agreed to in writing, software
* distributed under the License is distributed on an "AS IS" BASIS,
* WITHOUT WARRANTIES OR CONDITIONS OF ANY KIND, either express or implied.
* See the License for the specific language governing permissions and
* limitations under the License.
*
* SPDX-License-Identifier: Apache-2.0

.SUBCKT sky130_fd_sc_hd__nor3b_4 A B C_N VGND VNB VNB net59 Y
*.PININFO A:I B:I C_N:I VGND:I VNB:I VNB:I net59:I Y:O
MMP0 net59 A sndPA VNB sky130_fd_pr__pfet_01v8_hvt m=4 w=1.0u l=0.15u mult=1 sa=0.265
+ sb=0.265 sd=0.28 area=0.063 perim=1.14
MMP1 sndPA B sndPB VNB sky130_fd_pr__pfet_01v8_hvt m=4 w=1.0u l=0.15u mult=1 sa=0.265
+ sb=0.265 sd=0.28 area=0.063 perim=1.14
MMP2 sndPB C Y VNB sky130_fd_pr__pfet_01v8_hvt m=4 w=1.0u l=0.15u mult=1 sa=0.265
+ sb=0.265 sd=0.28 area=0.063 perim=1.14
MMIP2 C C_N net59 VNB sky130_fd_pr__pfet_01v8_hvt m=1 w=1.0u l=0.15u mult=1 sa=0.265
+ sb=0.265 sd=0.28 area=0.063 perim=1.14
MMN0 Y A VGND VNB sky130_fd_pr__nfet_01v8 m=4 w=0.65u l=0.15u mult=1 sa=0.265 sb=0.265
+ sd=0.28 area=0.063 perim=1.14
MMN1 Y B VGND VNB sky130_fd_pr__nfet_01v8 m=4 w=0.65u l=0.15u mult=1 sa=0.265 sb=0.265
+ sd=0.28 area=0.063 perim=1.14
MMN2 Y C VGND VNB sky130_fd_pr__nfet_01v8 m=4 w=0.65u l=0.15u mult=1 sa=0.265 sb=0.265
+ sd=0.28 area=0.063 perim=1.14
MMIN2 C C_N VGND VNB sky130_fd_pr__nfet_01v8 m=1 w=0.65u l=0.15u mult=1 sa=0.265
+ sb=0.265 sd=0.28 area=0.063 perim=1.14
.ENDS sky130_fd_sc_hd__nor3b_4
* Copyright 2020 The SkyWater PDK Authors
*
* Licensed under the Apache License, Version 2.0 (the "License");
* you may not use this file except in compliance with the License.
* You may obtain a copy of the License at
*
*     https:  www.apache.org licenses LICENSE-2.0
*
* Unless required by applicable law or agreed to in writing, software
* distributed under the License is distributed on an "AS IS" BASIS,
* WITHOUT WARRANTIES OR CONDITIONS OF ANY KIND, either express or implied.
* See the License for the specific language governing permissions and
* limitations under the License.
*
* SPDX-License-Identifier: Apache-2.0

.SUBCKT sky130_fd_sc_hd__nor4_1 A B C D VGND VNB VNB net59 Y
*.PININFO A:I B:I C:I D:I VGND:I VNB:I VNB:I net59:I Y:O
MMP0 net59 A sndPA VNB sky130_fd_pr__pfet_01v8_hvt m=1 w=1.0u l=0.15u mult=1 sa=0.265
+ sb=0.265 sd=0.28 area=0.028 perim=0.76
MMP1 sndPA B sndPB VNB sky130_fd_pr__pfet_01v8_hvt m=1 w=1.0u l=0.15u mult=1 sa=0.265
+ sb=0.265 sd=0.28 area=0.028 perim=0.76
MMP2 sndPB C sndPC VNB sky130_fd_pr__pfet_01v8_hvt m=1 w=1.0u l=0.15u mult=1 sa=0.265
+ sb=0.265 sd=0.28 area=0.028 perim=0.76
MMP3 sndPC D Y VNB sky130_fd_pr__pfet_01v8_hvt m=1 w=1.0u l=0.15u mult=1 sa=0.265
+ sb=0.265 sd=0.28 area=0.028 perim=0.76
MMN0 Y A VGND VNB sky130_fd_pr__nfet_01v8 m=1 w=0.65u l=0.15u mult=1 sa=0.265 sb=0.265
+ sd=0.28 area=0.028 perim=0.76
MMN1 Y B VGND VNB sky130_fd_pr__nfet_01v8 m=1 w=0.65u l=0.15u mult=1 sa=0.265 sb=0.265
+ sd=0.28 area=0.028 perim=0.76
MMN2 Y C VGND VNB sky130_fd_pr__nfet_01v8 m=1 w=0.65u l=0.15u mult=1 sa=0.265 sb=0.265
+ sd=0.28 area=0.028 perim=0.76
MMN3 Y D VGND VNB sky130_fd_pr__nfet_01v8 m=1 w=0.65u l=0.15u mult=1 sa=0.265 sb=0.265
+ sd=0.28 area=0.028 perim=0.76
.ENDS sky130_fd_sc_hd__nor4_1
* Copyright 2020 The SkyWater PDK Authors
*
* Licensed under the Apache License, Version 2.0 (the "License");
* you may not use this file except in compliance with the License.
* You may obtain a copy of the License at
*
*     https:  www.apache.org licenses LICENSE-2.0
*
* Unless required by applicable law or agreed to in writing, software
* distributed under the License is distributed on an "AS IS" BASIS,
* WITHOUT WARRANTIES OR CONDITIONS OF ANY KIND, either express or implied.
* See the License for the specific language governing permissions and
* limitations under the License.
*
* SPDX-License-Identifier: Apache-2.0

.SUBCKT sky130_fd_sc_hd__nor4_2 A B C D VGND VNB VNB net59 Y
*.PININFO A:I B:I C:I D:I VGND:I VNB:I VNB:I net59:I Y:O
MMP0 net59 A sndPA VNB sky130_fd_pr__pfet_01v8_hvt m=2 w=1.0u l=0.15u mult=1 sa=0.265
+ sb=0.265 sd=0.28 area=0.028 perim=0.76
MMP1 sndPA B sndPB VNB sky130_fd_pr__pfet_01v8_hvt m=2 w=1.0u l=0.15u mult=1 sa=0.265
+ sb=0.265 sd=0.28 area=0.028 perim=0.76
MMP2 sndPB C sndPC VNB sky130_fd_pr__pfet_01v8_hvt m=2 w=1.0u l=0.15u mult=1 sa=0.265
+ sb=0.265 sd=0.28 area=0.028 perim=0.76
MMP3 sndPC D Y VNB sky130_fd_pr__pfet_01v8_hvt m=2 w=1.0u l=0.15u mult=1 sa=0.265
+ sb=0.265 sd=0.28 area=0.028 perim=0.76
MMN0 Y A VGND VNB sky130_fd_pr__nfet_01v8 m=2 w=0.65u l=0.15u mult=1 sa=0.265 sb=0.265
+ sd=0.28 area=0.028 perim=0.76
MMN1 Y B VGND VNB sky130_fd_pr__nfet_01v8 m=2 w=0.65u l=0.15u mult=1 sa=0.265 sb=0.265
+ sd=0.28 area=0.028 perim=0.76
MMN2 Y C VGND VNB sky130_fd_pr__nfet_01v8 m=2 w=0.65u l=0.15u mult=1 sa=0.265 sb=0.265
+ sd=0.28 area=0.028 perim=0.76
MMN3 Y D VGND VNB sky130_fd_pr__nfet_01v8 m=2 w=0.65u l=0.15u mult=1 sa=0.265 sb=0.265
+ sd=0.28 area=0.028 perim=0.76
.ENDS sky130_fd_sc_hd__nor4_2
* Copyright 2020 The SkyWater PDK Authors
*
* Licensed under the Apache License, Version 2.0 (the "License");
* you may not use this file except in compliance with the License.
* You may obtain a copy of the License at
*
*     https:  www.apache.org licenses LICENSE-2.0
*
* Unless required by applicable law or agreed to in writing, software
* distributed under the License is distributed on an "AS IS" BASIS,
* WITHOUT WARRANTIES OR CONDITIONS OF ANY KIND, either express or implied.
* See the License for the specific language governing permissions and
* limitations under the License.
*
* SPDX-License-Identifier: Apache-2.0

.SUBCKT sky130_fd_sc_hd__nor4_4 A B C D VGND VNB VNB net59 Y
*.PININFO A:I B:I C:I D:I VGND:I VNB:I VNB:I net59:I Y:O
MMP0 net59 A sndPA VNB sky130_fd_pr__pfet_01v8_hvt m=4 w=1.0u l=0.15u mult=1 sa=0.265
+ sb=0.265 sd=0.28 area=0.028 perim=0.76
MMP1 sndPA B sndPB VNB sky130_fd_pr__pfet_01v8_hvt m=4 w=1.0u l=0.15u mult=1 sa=0.265
+ sb=0.265 sd=0.28 area=0.028 perim=0.76
MMP2 sndPB C sndPC VNB sky130_fd_pr__pfet_01v8_hvt m=4 w=1.0u l=0.15u mult=1 sa=0.265
+ sb=0.265 sd=0.28 area=0.028 perim=0.76
MMP3 sndPC D Y VNB sky130_fd_pr__pfet_01v8_hvt m=4 w=1.0u l=0.15u mult=1 sa=0.265
+ sb=0.265 sd=0.28 area=0.028 perim=0.76
MMN0 Y A VGND VNB sky130_fd_pr__nfet_01v8 m=4 w=0.65u l=0.15u mult=1 sa=0.265 sb=0.265
+ sd=0.28 area=0.028 perim=0.76
MMN1 Y B VGND VNB sky130_fd_pr__nfet_01v8 m=4 w=0.65u l=0.15u mult=1 sa=0.265 sb=0.265
+ sd=0.28 area=0.028 perim=0.76
MMN2 Y C VGND VNB sky130_fd_pr__nfet_01v8 m=4 w=0.65u l=0.15u mult=1 sa=0.265 sb=0.265
+ sd=0.28 area=0.028 perim=0.76
MMN3 Y D VGND VNB sky130_fd_pr__nfet_01v8 m=4 w=0.65u l=0.15u mult=1 sa=0.265 sb=0.265
+ sd=0.28 area=0.028 perim=0.76
.ENDS sky130_fd_sc_hd__nor4_4
* Copyright 2020 The SkyWater PDK Authors
*
* Licensed under the Apache License, Version 2.0 (the "License");
* you may not use this file except in compliance with the License.
* You may obtain a copy of the License at
*
*     https:  www.apache.org licenses LICENSE-2.0
*
* Unless required by applicable law or agreed to in writing, software
* distributed under the License is distributed on an "AS IS" BASIS,
* WITHOUT WARRANTIES OR CONDITIONS OF ANY KIND, either express or implied.
* See the License for the specific language governing permissions and
* limitations under the License.
*
* SPDX-License-Identifier: Apache-2.0

.SUBCKT sky130_fd_sc_hd__nor4b_1 A B C D_N VGND VNB VNB net59 Y
*.PININFO A:I B:I C:I D_N:I VGND:I VNB:I VNB:I net59:I Y:O
MMP0 net59 A sndPA VNB sky130_fd_pr__pfet_01v8_hvt m=1 w=1.0u l=0.15u mult=1 sa=0.265
+ sb=0.265 sd=0.28 area=0.063 perim=1.14
MMP1 sndPA B sndPB VNB sky130_fd_pr__pfet_01v8_hvt m=1 w=1.0u l=0.15u mult=1 sa=0.265
+ sb=0.265 sd=0.28 area=0.063 perim=1.14
MMP2 sndPB C sndPC VNB sky130_fd_pr__pfet_01v8_hvt m=1 w=1.0u l=0.15u mult=1 sa=0.265
+ sb=0.265 sd=0.28 area=0.063 perim=1.14
MMP3 sndPC D Y VNB sky130_fd_pr__pfet_01v8_hvt m=1 w=1.0u l=0.15u mult=1 sa=0.265
+ sb=0.265 sd=0.28 area=0.063 perim=1.14
MMIP3 D D_N net59 VNB sky130_fd_pr__pfet_01v8_hvt m=1 w=0.42u l=0.15u mult=1 sa=0.265
+ sb=0.265 sd=0.28 area=0.063 perim=1.14
MMN0 Y A VGND VNB sky130_fd_pr__nfet_01v8 m=1 w=0.65u l=0.15u mult=1 sa=0.265 sb=0.265
+ sd=0.28 area=0.063 perim=1.14
MMN1 Y B VGND VNB sky130_fd_pr__nfet_01v8 m=1 w=0.65u l=0.15u mult=1 sa=0.265 sb=0.265
+ sd=0.28 area=0.063 perim=1.14
MMN2 Y C VGND VNB sky130_fd_pr__nfet_01v8 m=1 w=0.65u l=0.15u mult=1 sa=0.265 sb=0.265
+ sd=0.28 area=0.063 perim=1.14
MMN3 Y D VGND VNB sky130_fd_pr__nfet_01v8 m=1 w=0.65u l=0.15u mult=1 sa=0.265 sb=0.265
+ sd=0.28 area=0.063 perim=1.14
MMIN3 D D_N VGND VNB sky130_fd_pr__nfet_01v8 m=1 w=0.42u l=0.15u mult=1 sa=0.265
+ sb=0.265 sd=0.28 area=0.063 perim=1.14
.ENDS sky130_fd_sc_hd__nor4b_1
* Copyright 2020 The SkyWater PDK Authors
*
* Licensed under the Apache License, Version 2.0 (the "License");
* you may not use this file except in compliance with the License.
* You may obtain a copy of the License at
*
*     https:  www.apache.org licenses LICENSE-2.0
*
* Unless required by applicable law or agreed to in writing, software
* distributed under the License is distributed on an "AS IS" BASIS,
* WITHOUT WARRANTIES OR CONDITIONS OF ANY KIND, either express or implied.
* See the License for the specific language governing permissions and
* limitations under the License.
*
* SPDX-License-Identifier: Apache-2.0

.SUBCKT sky130_fd_sc_hd__nor4b_2 A B C D_N VGND VNB VNB net59 Y
*.PININFO A:I B:I C:I D_N:I VGND:I VNB:I VNB:I net59:I Y:O
MMP0 net59 A sndPA VNB sky130_fd_pr__pfet_01v8_hvt m=2 w=1.0u l=0.15u mult=1 sa=0.265
+ sb=0.265 sd=0.28 area=0.063 perim=1.14
MMP1 sndPA B sndPB VNB sky130_fd_pr__pfet_01v8_hvt m=2 w=1.0u l=0.15u mult=1 sa=0.265
+ sb=0.265 sd=0.28 area=0.063 perim=1.14
MMP2 sndPB C sndPC VNB sky130_fd_pr__pfet_01v8_hvt m=2 w=1.0u l=0.15u mult=1 sa=0.265
+ sb=0.265 sd=0.28 area=0.063 perim=1.14
MMP3 sndPC D Y VNB sky130_fd_pr__pfet_01v8_hvt m=2 w=1.0u l=0.15u mult=1 sa=0.265
+ sb=0.265 sd=0.28 area=0.063 perim=1.14
MMIP3 D D_N net59 VNB sky130_fd_pr__pfet_01v8_hvt m=1 w=0.42u l=0.15u mult=1 sa=0.265
+ sb=0.265 sd=0.28 area=0.063 perim=1.14
MMN0 Y A VGND VNB sky130_fd_pr__nfet_01v8 m=2 w=0.65u l=0.15u mult=1 sa=0.265 sb=0.265
+ sd=0.28 area=0.063 perim=1.14
MMN1 Y B VGND VNB sky130_fd_pr__nfet_01v8 m=2 w=0.65u l=0.15u mult=1 sa=0.265 sb=0.265
+ sd=0.28 area=0.063 perim=1.14
MMN2 Y C VGND VNB sky130_fd_pr__nfet_01v8 m=2 w=0.65u l=0.15u mult=1 sa=0.265 sb=0.265
+ sd=0.28 area=0.063 perim=1.14
MMN3 Y D VGND VNB sky130_fd_pr__nfet_01v8 m=2 w=0.65u l=0.15u mult=1 sa=0.265 sb=0.265
+ sd=0.28 area=0.063 perim=1.14
MMIN3 D D_N VGND VNB sky130_fd_pr__nfet_01v8 m=1 w=0.42u l=0.15u mult=1 sa=0.265
+ sb=0.265 sd=0.28 area=0.063 perim=1.14
.ENDS sky130_fd_sc_hd__nor4b_2
* Copyright 2020 The SkyWater PDK Authors
*
* Licensed under the Apache License, Version 2.0 (the "License");
* you may not use this file except in compliance with the License.
* You may obtain a copy of the License at
*
*     https:  www.apache.org licenses LICENSE-2.0
*
* Unless required by applicable law or agreed to in writing, software
* distributed under the License is distributed on an "AS IS" BASIS,
* WITHOUT WARRANTIES OR CONDITIONS OF ANY KIND, either express or implied.
* See the License for the specific language governing permissions and
* limitations under the License.
*
* SPDX-License-Identifier: Apache-2.0

.SUBCKT sky130_fd_sc_hd__nor4b_4 A B C D_N VGND VNB VNB net59 Y
*.PININFO A:I B:I C:I D_N:I VGND:I VNB:I VNB:I net59:I Y:O
MMP0 net59 A sndPA VNB sky130_fd_pr__pfet_01v8_hvt m=4 w=1.0u l=0.15u mult=1 sa=0.265
+ sb=0.265 sd=0.28 area=0.063 perim=1.14
MMP1 sndPA B sndPB VNB sky130_fd_pr__pfet_01v8_hvt m=4 w=1.0u l=0.15u mult=1 sa=0.265
+ sb=0.265 sd=0.28 area=0.063 perim=1.14
MMP2 sndPB C sndPC VNB sky130_fd_pr__pfet_01v8_hvt m=4 w=1.0u l=0.15u mult=1 sa=0.265
+ sb=0.265 sd=0.28 area=0.063 perim=1.14
MMP3 sndPC D Y VNB sky130_fd_pr__pfet_01v8_hvt m=4 w=1.0u l=0.15u mult=1 sa=0.265
+ sb=0.265 sd=0.28 area=0.063 perim=1.14
MMIP3 D D_N net59 VNB sky130_fd_pr__pfet_01v8_hvt m=1 w=1.0u l=0.15u mult=1 sa=0.265
+ sb=0.265 sd=0.28 area=0.063 perim=1.14
MMN0 Y A VGND VNB sky130_fd_pr__nfet_01v8 m=4 w=0.65u l=0.15u mult=1 sa=0.265 sb=0.265
+ sd=0.28 area=0.063 perim=1.14
MMN1 Y B VGND VNB sky130_fd_pr__nfet_01v8 m=4 w=0.65u l=0.15u mult=1 sa=0.265 sb=0.265
+ sd=0.28 area=0.063 perim=1.14
MMN2 Y C VGND VNB sky130_fd_pr__nfet_01v8 m=4 w=0.65u l=0.15u mult=1 sa=0.265 sb=0.265
+ sd=0.28 area=0.063 perim=1.14
MMN3 Y D VGND VNB sky130_fd_pr__nfet_01v8 m=4 w=0.65u l=0.15u mult=1 sa=0.265 sb=0.265
+ sd=0.28 area=0.063 perim=1.14
MMIN3 D D_N VGND VNB sky130_fd_pr__nfet_01v8 m=1 w=0.65u l=0.15u mult=1 sa=0.265
+ sb=0.265 sd=0.28 area=0.063 perim=1.14
.ENDS sky130_fd_sc_hd__nor4b_4
* Copyright 2020 The SkyWater PDK Authors
*
* Licensed under the Apache License, Version 2.0 (the "License");
* you may not use this file except in compliance with the License.
* You may obtain a copy of the License at
*
*     https:  www.apache.org licenses LICENSE-2.0
*
* Unless required by applicable law or agreed to in writing, software
* distributed under the License is distributed on an "AS IS" BASIS,
* WITHOUT WARRANTIES OR CONDITIONS OF ANY KIND, either express or implied.
* See the License for the specific language governing permissions and
* limitations under the License.
*
* SPDX-License-Identifier: Apache-2.0

.SUBCKT sky130_fd_sc_hd__nor4bb_1 A B C_N D_N VGND VNB VNB net59 Y
*.PININFO A:I B:I C_N:I D_N:I VGND:I VNB:I VNB:I net59:I Y:O
MMP0 net59 A sndPA VNB sky130_fd_pr__pfet_01v8_hvt m=1 w=1.0u l=0.15u mult=1 sa=0.265
+ sb=0.265 sd=0.28 area=0.063 perim=1.14
MMP1 sndPA B sndPB VNB sky130_fd_pr__pfet_01v8_hvt m=1 w=1.0u l=0.15u mult=1 sa=0.265
+ sb=0.265 sd=0.28 area=0.063 perim=1.14
MMP2 sndPB C sndPC VNB sky130_fd_pr__pfet_01v8_hvt m=1 w=1.0u l=0.15u mult=1 sa=0.265
+ sb=0.265 sd=0.28 area=0.063 perim=1.14
MMP3 sndPC D Y VNB sky130_fd_pr__pfet_01v8_hvt m=1 w=1.0u l=0.15u mult=1 sa=0.265
+ sb=0.265 sd=0.28 area=0.063 perim=1.14
MMIP2 C C_N net59 VNB sky130_fd_pr__pfet_01v8_hvt m=1 w=0.42u l=0.15u mult=1 sa=0.265
+ sb=0.265 sd=0.28 area=0.063 perim=1.14
MMIP3 D D_N net59 VNB sky130_fd_pr__pfet_01v8_hvt m=1 w=0.42u l=0.15u mult=1 sa=0.265
+ sb=0.265 sd=0.28 area=0.063 perim=1.14
MMN0 Y A VGND VNB sky130_fd_pr__nfet_01v8 m=1 w=0.65u l=0.15u mult=1 sa=0.265 sb=0.265
+ sd=0.28 area=0.063 perim=1.14
MMN1 Y B VGND VNB sky130_fd_pr__nfet_01v8 m=1 w=0.65u l=0.15u mult=1 sa=0.265 sb=0.265
+ sd=0.28 area=0.063 perim=1.14
MMN2 Y C VGND VNB sky130_fd_pr__nfet_01v8 m=1 w=0.65u l=0.15u mult=1 sa=0.265 sb=0.265
+ sd=0.28 area=0.063 perim=1.14
MMN3 Y D VGND VNB sky130_fd_pr__nfet_01v8 m=1 w=0.65u l=0.15u mult=1 sa=0.265 sb=0.265
+ sd=0.28 area=0.063 perim=1.14
MMIN2 C C_N VGND VNB sky130_fd_pr__nfet_01v8 m=1 w=0.42u l=0.15u mult=1 sa=0.265
+ sb=0.265 sd=0.28 area=0.063 perim=1.14
MMIN3 D D_N VGND VNB sky130_fd_pr__nfet_01v8 m=1 w=0.42u l=0.15u mult=1 sa=0.265
+ sb=0.265 sd=0.28 area=0.063 perim=1.14
.ENDS sky130_fd_sc_hd__nor4bb_1
* Copyright 2020 The SkyWater PDK Authors
*
* Licensed under the Apache License, Version 2.0 (the "License");
* you may not use this file except in compliance with the License.
* You may obtain a copy of the License at
*
*     https:  www.apache.org licenses LICENSE-2.0
*
* Unless required by applicable law or agreed to in writing, software
* distributed under the License is distributed on an "AS IS" BASIS,
* WITHOUT WARRANTIES OR CONDITIONS OF ANY KIND, either express or implied.
* See the License for the specific language governing permissions and
* limitations under the License.
*
* SPDX-License-Identifier: Apache-2.0

.SUBCKT sky130_fd_sc_hd__nor4bb_2 A B C_N D_N VGND VNB VNB net59 Y
*.PININFO A:I B:I C_N:I D_N:I VGND:I VNB:I VNB:I net59:I Y:O
MMP0 net59 A sndPA VNB sky130_fd_pr__pfet_01v8_hvt m=2 w=1.0u l=0.15u mult=1 sa=0.265
+ sb=0.265 sd=0.28 area=0.063 perim=1.14
MMP1 sndPA B sndPB VNB sky130_fd_pr__pfet_01v8_hvt m=2 w=1.0u l=0.15u mult=1 sa=0.265
+ sb=0.265 sd=0.28 area=0.063 perim=1.14
MMP2 sndPB C sndPC VNB sky130_fd_pr__pfet_01v8_hvt m=2 w=1.0u l=0.15u mult=1 sa=0.265
+ sb=0.265 sd=0.28 area=0.063 perim=1.14
MMP3 sndPC D Y VNB sky130_fd_pr__pfet_01v8_hvt m=2 w=1.0u l=0.15u mult=1 sa=0.265
+ sb=0.265 sd=0.28 area=0.063 perim=1.14
MMIP2 C C_N net59 VNB sky130_fd_pr__pfet_01v8_hvt m=1 w=0.42u l=0.15u mult=1 sa=0.265
+ sb=0.265 sd=0.28 area=0.063 perim=1.14
MMIP3 D D_N net59 VNB sky130_fd_pr__pfet_01v8_hvt m=1 w=0.42u l=0.15u mult=1 sa=0.265
+ sb=0.265 sd=0.28 area=0.063 perim=1.14
MMN0 Y A VGND VNB sky130_fd_pr__nfet_01v8 m=2 w=0.65u l=0.15u mult=1 sa=0.265 sb=0.265
+ sd=0.28 area=0.063 perim=1.14
MMN1 Y B VGND VNB sky130_fd_pr__nfet_01v8 m=2 w=0.65u l=0.15u mult=1 sa=0.265 sb=0.265
+ sd=0.28 area=0.063 perim=1.14
MMN2 Y C VGND VNB sky130_fd_pr__nfet_01v8 m=2 w=0.65u l=0.15u mult=1 sa=0.265 sb=0.265
+ sd=0.28 area=0.063 perim=1.14
MMN3 Y D VGND VNB sky130_fd_pr__nfet_01v8 m=2 w=0.65u l=0.15u mult=1 sa=0.265 sb=0.265
+ sd=0.28 area=0.063 perim=1.14
MMIN2 C C_N VGND VNB sky130_fd_pr__nfet_01v8 m=1 w=0.42u l=0.15u mult=1 sa=0.265
+ sb=0.265 sd=0.28 area=0.063 perim=1.14
MMIN3 D D_N VGND VNB sky130_fd_pr__nfet_01v8 m=1 w=0.42u l=0.15u mult=1 sa=0.265
+ sb=0.265 sd=0.28 area=0.063 perim=1.14
.ENDS sky130_fd_sc_hd__nor4bb_2
* Copyright 2020 The SkyWater PDK Authors
*
* Licensed under the Apache License, Version 2.0 (the "License");
* you may not use this file except in compliance with the License.
* You may obtain a copy of the License at
*
*     https:  www.apache.org licenses LICENSE-2.0
*
* Unless required by applicable law or agreed to in writing, software
* distributed under the License is distributed on an "AS IS" BASIS,
* WITHOUT WARRANTIES OR CONDITIONS OF ANY KIND, either express or implied.
* See the License for the specific language governing permissions and
* limitations under the License.
*
* SPDX-License-Identifier: Apache-2.0

.SUBCKT sky130_fd_sc_hd__nor4bb_4 A B C_N D_N VGND VNB VNB net59 Y
*.PININFO A:I B:I C_N:I D_N:I VGND:I VNB:I VNB:I net59:I Y:O
MMP0 net59 A sndPA VNB sky130_fd_pr__pfet_01v8_hvt m=4 w=1.0u l=0.15u mult=1 sa=0.265
+ sb=0.265 sd=0.28 area=0.063 perim=1.14
MMP1 sndPA B sndPB VNB sky130_fd_pr__pfet_01v8_hvt m=4 w=1.0u l=0.15u mult=1 sa=0.265
+ sb=0.265 sd=0.28 area=0.063 perim=1.14
MMP2 sndPB C sndPC VNB sky130_fd_pr__pfet_01v8_hvt m=4 w=1.0u l=0.15u mult=1 sa=0.265
+ sb=0.265 sd=0.28 area=0.063 perim=1.14
MMP3 sndPC D Y VNB sky130_fd_pr__pfet_01v8_hvt m=4 w=1.0u l=0.15u mult=1 sa=0.265
+ sb=0.265 sd=0.28 area=0.063 perim=1.14
MMIP2 C C_N net59 VNB sky130_fd_pr__pfet_01v8_hvt m=1 w=1.0u l=0.15u mult=1 sa=0.265
+ sb=0.265 sd=0.28 area=0.063 perim=1.14
MMIP3 D D_N net59 VNB sky130_fd_pr__pfet_01v8_hvt m=1 w=1.0u l=0.15u mult=1 sa=0.265
+ sb=0.265 sd=0.28 area=0.063 perim=1.14
MMN0 Y A VGND VNB sky130_fd_pr__nfet_01v8 m=4 w=0.65u l=0.15u mult=1 sa=0.265 sb=0.265
+ sd=0.28 area=0.063 perim=1.14
MMN1 Y B VGND VNB sky130_fd_pr__nfet_01v8 m=4 w=0.65u l=0.15u mult=1 sa=0.265 sb=0.265
+ sd=0.28 area=0.063 perim=1.14
MMN2 Y C VGND VNB sky130_fd_pr__nfet_01v8 m=4 w=0.65u l=0.15u mult=1 sa=0.265 sb=0.265
+ sd=0.28 area=0.063 perim=1.14
MMN3 Y D VGND VNB sky130_fd_pr__nfet_01v8 m=4 w=0.65u l=0.15u mult=1 sa=0.265 sb=0.265
+ sd=0.28 area=0.063 perim=1.14
MMIN2 C C_N VGND VNB sky130_fd_pr__nfet_01v8 m=1 w=0.65u l=0.15u mult=1 sa=0.265
+ sb=0.265 sd=0.28 area=0.063 perim=1.14
MMIN3 D D_N VGND VNB sky130_fd_pr__nfet_01v8 m=1 w=0.65u l=0.15u mult=1 sa=0.265
+ sb=0.265 sd=0.28 area=0.063 perim=1.14
.ENDS sky130_fd_sc_hd__nor4bb_4
* Copyright 2020 The SkyWater PDK Authors
*
* Licensed under the Apache License, Version 2.0 (the "License");
* you may not use this file except in compliance with the License.
* You may obtain a copy of the License at
*
*     https:  www.apache.org licenses LICENSE-2.0
*
* Unless required by applicable law or agreed to in writing, software
* distributed under the License is distributed on an "AS IS" BASIS,
* WITHOUT WARRANTIES OR CONDITIONS OF ANY KIND, either express or implied.
* See the License for the specific language governing permissions and
* limitations under the License.
*
* SPDX-License-Identifier: Apache-2.0

.SUBCKT sky130_fd_sc_hd__o2111a_1 A1 A2 B1 C1 D1 VGND VNB VNB net59 X
*.PININFO A1:I A2:I B1:I C1:I D1:I VGND:I VNB:I VNB:I net59:I X:O
MMPA0 net59 A1 sndA1 VNB sky130_fd_pr__pfet_01v8_hvt m=1 w=1.0u l=0.15u mult=1 sa=0.265
+ sb=0.265 sd=0.28 area=0.063 perim=1.14
MMPA1 sndA1 A2 y VNB sky130_fd_pr__pfet_01v8_hvt m=1 w=1.0u l=0.15u mult=1 sa=0.265
+ sb=0.265 sd=0.28 area=0.063 perim=1.14
MMPB0 net59 B1 y VNB sky130_fd_pr__pfet_01v8_hvt m=1 w=1.0u l=0.15u mult=1 sa=0.265
+ sb=0.265 sd=0.28 area=0.063 perim=1.14
MMPC0 net59 C1 y VNB sky130_fd_pr__pfet_01v8_hvt m=1 w=1.0u l=0.15u mult=1 sa=0.265
+ sb=0.265 sd=0.28 area=0.063 perim=1.14
MMPD0 net59 D1 y VNB sky130_fd_pr__pfet_01v8_hvt m=1 w=1.0u l=0.15u mult=1 sa=0.265
+ sb=0.265 sd=0.28 area=0.063 perim=1.14
MMIPX X y net59 VNB sky130_fd_pr__pfet_01v8_hvt m=1 w=1.0u l=0.15u mult=1 sa=0.265
+ sb=0.265 sd=0.28 area=0.063 perim=1.14
MMNA0 pndA A1 VGND VNB sky130_fd_pr__nfet_01v8 m=1 w=0.65u l=0.15u mult=1 sa=0.265
+ sb=0.265 sd=0.28 area=0.063 perim=1.14
MMNA1 pndA A2 VGND VNB sky130_fd_pr__nfet_01v8 m=1 w=0.65u l=0.15u mult=1 sa=0.265
+ sb=0.265 sd=0.28 area=0.063 perim=1.14
MMNB0 pndB B1 pndA VNB sky130_fd_pr__nfet_01v8 m=1 w=0.65u l=0.15u mult=1 sa=0.265
+ sb=0.265 sd=0.28 area=0.063 perim=1.14
MMNC0 pndC C1 pndB VNB sky130_fd_pr__nfet_01v8 m=1 w=0.65u l=0.15u mult=1 sa=0.265
+ sb=0.265 sd=0.28 area=0.063 perim=1.14
MMND0 y D1 pndC VNB sky130_fd_pr__nfet_01v8 m=1 w=0.65u l=0.15u mult=1 sa=0.265
+ sb=0.265 sd=0.28 area=0.063 perim=1.14
MMINX X y VGND VNB sky130_fd_pr__nfet_01v8 m=1 w=0.65u l=0.15u mult=1 sa=0.265
+ sb=0.265 sd=0.28 area=0.063 perim=1.14
.ENDS sky130_fd_sc_hd__o2111a_1
* Copyright 2020 The SkyWater PDK Authors
*
* Licensed under the Apache License, Version 2.0 (the "License");
* you may not use this file except in compliance with the License.
* You may obtain a copy of the License at
*
*     https:  www.apache.org licenses LICENSE-2.0
*
* Unless required by applicable law or agreed to in writing, software
* distributed under the License is distributed on an "AS IS" BASIS,
* WITHOUT WARRANTIES OR CONDITIONS OF ANY KIND, either express or implied.
* See the License for the specific language governing permissions and
* limitations under the License.
*
* SPDX-License-Identifier: Apache-2.0

.SUBCKT sky130_fd_sc_hd__o2111a_2 A1 A2 B1 C1 D1 VGND VNB VNB net59 X
*.PININFO A1:I A2:I B1:I C1:I D1:I VGND:I VNB:I VNB:I net59:I X:O
MMPA0 net59 A1 sndA1 VNB sky130_fd_pr__pfet_01v8_hvt m=1 w=1.0u l=0.15u mult=1 sa=0.265
+ sb=0.265 sd=0.28 area=0.063 perim=1.14
MMPA1 sndA1 A2 y VNB sky130_fd_pr__pfet_01v8_hvt m=1 w=1.0u l=0.15u mult=1 sa=0.265
+ sb=0.265 sd=0.28 area=0.063 perim=1.14
MMPB0 net59 B1 y VNB sky130_fd_pr__pfet_01v8_hvt m=1 w=1.0u l=0.15u mult=1 sa=0.265
+ sb=0.265 sd=0.28 area=0.063 perim=1.14
MMPC0 net59 C1 y VNB sky130_fd_pr__pfet_01v8_hvt m=1 w=1.0u l=0.15u mult=1 sa=0.265
+ sb=0.265 sd=0.28 area=0.063 perim=1.14
MMPD0 net59 D1 y VNB sky130_fd_pr__pfet_01v8_hvt m=1 w=1.0u l=0.15u mult=1 sa=0.265
+ sb=0.265 sd=0.28 area=0.063 perim=1.14
MMIPX X y net59 VNB sky130_fd_pr__pfet_01v8_hvt m=2 w=1.0u l=0.15u mult=1 sa=0.265
+ sb=0.265 sd=0.28 area=0.063 perim=1.14
MMNA0 pndA A1 VGND VNB sky130_fd_pr__nfet_01v8 m=1 w=0.65u l=0.15u mult=1 sa=0.265
+ sb=0.265 sd=0.28 area=0.063 perim=1.14
MMNA1 pndA A2 VGND VNB sky130_fd_pr__nfet_01v8 m=1 w=0.65u l=0.15u mult=1 sa=0.265
+ sb=0.265 sd=0.28 area=0.063 perim=1.14
MMNB0 pndB B1 pndA VNB sky130_fd_pr__nfet_01v8 m=1 w=0.65u l=0.15u mult=1 sa=0.265
+ sb=0.265 sd=0.28 area=0.063 perim=1.14
MMNC0 pndC C1 pndB VNB sky130_fd_pr__nfet_01v8 m=1 w=0.65u l=0.15u mult=1 sa=0.265
+ sb=0.265 sd=0.28 area=0.063 perim=1.14
MMND0 y D1 pndC VNB sky130_fd_pr__nfet_01v8 m=1 w=0.65u l=0.15u mult=1 sa=0.265
+ sb=0.265 sd=0.28 area=0.063 perim=1.14
MMINX X y VGND VNB sky130_fd_pr__nfet_01v8 m=2 w=0.65u l=0.15u mult=1 sa=0.265
+ sb=0.265 sd=0.28 area=0.063 perim=1.14
.ENDS sky130_fd_sc_hd__o2111a_2
* Copyright 2020 The SkyWater PDK Authors
*
* Licensed under the Apache License, Version 2.0 (the "License");
* you may not use this file except in compliance with the License.
* You may obtain a copy of the License at
*
*     https:  www.apache.org licenses LICENSE-2.0
*
* Unless required by applicable law or agreed to in writing, software
* distributed under the License is distributed on an "AS IS" BASIS,
* WITHOUT WARRANTIES OR CONDITIONS OF ANY KIND, either express or implied.
* See the License for the specific language governing permissions and
* limitations under the License.
*
* SPDX-License-Identifier: Apache-2.0

.SUBCKT sky130_fd_sc_hd__o2111a_4 A1 A2 B1 C1 D1 VGND VNB VNB net59 X
*.PININFO A1:I A2:I B1:I C1:I D1:I VGND:I VNB:I VNB:I net59:I X:O
MMPA0 net59 A1 sndA1 VNB sky130_fd_pr__pfet_01v8_hvt m=2 w=1.0u l=0.15u mult=1 sa=0.265
+ sb=0.265 sd=0.28 area=0.063 perim=1.14
MMPA1 sndA1 A2 y VNB sky130_fd_pr__pfet_01v8_hvt m=2 w=1.0u l=0.15u mult=1 sa=0.265
+ sb=0.265 sd=0.28 area=0.063 perim=1.14
MMPB0 net59 B1 y VNB sky130_fd_pr__pfet_01v8_hvt m=2 w=1.0u l=0.15u mult=1 sa=0.265
+ sb=0.265 sd=0.28 area=0.063 perim=1.14
MMPC0 net59 C1 y VNB sky130_fd_pr__pfet_01v8_hvt m=2 w=1.0u l=0.15u mult=1 sa=0.265
+ sb=0.265 sd=0.28 area=0.063 perim=1.14
MMPD0 net59 D1 y VNB sky130_fd_pr__pfet_01v8_hvt m=2 w=1.0u l=0.15u mult=1 sa=0.265
+ sb=0.265 sd=0.28 area=0.063 perim=1.14
MMIPX X y net59 VNB sky130_fd_pr__pfet_01v8_hvt m=4 w=1.0u l=0.15u mult=1 sa=0.265
+ sb=0.265 sd=0.28 area=0.063 perim=1.14
MMNA0 pndA A1 VGND VNB sky130_fd_pr__nfet_01v8 m=2 w=0.65u l=0.15u mult=1 sa=0.265
+ sb=0.265 sd=0.28 area=0.063 perim=1.14
MMNA1 pndA A2 VGND VNB sky130_fd_pr__nfet_01v8 m=2 w=0.65u l=0.15u mult=1 sa=0.265
+ sb=0.265 sd=0.28 area=0.063 perim=1.14
MMNB0 pndB B1 pndA VNB sky130_fd_pr__nfet_01v8 m=2 w=0.65u l=0.15u mult=1 sa=0.265
+ sb=0.265 sd=0.28 area=0.063 perim=1.14
MMNC0 pndC C1 pndB VNB sky130_fd_pr__nfet_01v8 m=2 w=0.65u l=0.15u mult=1 sa=0.265
+ sb=0.265 sd=0.28 area=0.063 perim=1.14
MMND0 y D1 pndC VNB sky130_fd_pr__nfet_01v8 m=2 w=0.65u l=0.15u mult=1 sa=0.265
+ sb=0.265 sd=0.28 area=0.063 perim=1.14
MMINX X y VGND VNB sky130_fd_pr__nfet_01v8 m=4 w=0.65u l=0.15u mult=1 sa=0.265
+ sb=0.265 sd=0.28 area=0.063 perim=1.14
.ENDS sky130_fd_sc_hd__o2111a_4
* Copyright 2020 The SkyWater PDK Authors
*
* Licensed under the Apache License, Version 2.0 (the "License");
* you may not use this file except in compliance with the License.
* You may obtain a copy of the License at
*
*     https:  www.apache.org licenses LICENSE-2.0
*
* Unless required by applicable law or agreed to in writing, software
* distributed under the License is distributed on an "AS IS" BASIS,
* WITHOUT WARRANTIES OR CONDITIONS OF ANY KIND, either express or implied.
* See the License for the specific language governing permissions and
* limitations under the License.
*
* SPDX-License-Identifier: Apache-2.0

.SUBCKT sky130_fd_sc_hd__o2111ai_1 A1 A2 B1 C1 D1 VGND VNB VNB net59 Y
*.PININFO A1:I A2:I B1:I C1:I D1:I VGND:I VNB:I VNB:I net59:I Y:O
MMPA0 net59 A1 sndA1 VNB sky130_fd_pr__pfet_01v8_hvt m=1 w=1.0u l=0.15u mult=1 sa=0.265
+ sb=0.265 sd=0.28 area=0.063 perim=1.14
MMPA1 sndA1 A2 Y VNB sky130_fd_pr__pfet_01v8_hvt m=1 w=1.0u l=0.15u mult=1 sa=0.265
+ sb=0.265 sd=0.28 area=0.063 perim=1.14
MMPB0 net59 B1 Y VNB sky130_fd_pr__pfet_01v8_hvt m=1 w=1.0u l=0.15u mult=1 sa=0.265
+ sb=0.265 sd=0.28 area=0.063 perim=1.14
MMPC0 net59 C1 Y VNB sky130_fd_pr__pfet_01v8_hvt m=1 w=1.0u l=0.15u mult=1 sa=0.265
+ sb=0.265 sd=0.28 area=0.063 perim=1.14
MMPD0 net59 D1 Y VNB sky130_fd_pr__pfet_01v8_hvt m=1 w=1.0u l=0.15u mult=1 sa=0.265
+ sb=0.265 sd=0.28 area=0.063 perim=1.14
MMNA0 pndA A1 VGND VNB sky130_fd_pr__nfet_01v8 m=1 w=0.65u l=0.15u mult=1 sa=0.265
+ sb=0.265 sd=0.28 area=0.063 perim=1.14
MMNA1 pndA A2 VGND VNB sky130_fd_pr__nfet_01v8 m=1 w=0.65u l=0.15u mult=1 sa=0.265
+ sb=0.265 sd=0.28 area=0.063 perim=1.14
MMNB0 pndB B1 pndA VNB sky130_fd_pr__nfet_01v8 m=1 w=0.65u l=0.15u mult=1 sa=0.265
+ sb=0.265 sd=0.28 area=0.063 perim=1.14
MMNC0 pndC C1 pndB VNB sky130_fd_pr__nfet_01v8 m=1 w=0.65u l=0.15u mult=1 sa=0.265
+ sb=0.265 sd=0.28 area=0.063 perim=1.14
MMND0 Y D1 pndC VNB sky130_fd_pr__nfet_01v8 m=1 w=0.65u l=0.15u mult=1 sa=0.265
+ sb=0.265 sd=0.28 area=0.063 perim=1.14
.ENDS sky130_fd_sc_hd__o2111ai_1
* Copyright 2020 The SkyWater PDK Authors
*
* Licensed under the Apache License, Version 2.0 (the "License");
* you may not use this file except in compliance with the License.
* You may obtain a copy of the License at
*
*     https:  www.apache.org licenses LICENSE-2.0
*
* Unless required by applicable law or agreed to in writing, software
* distributed under the License is distributed on an "AS IS" BASIS,
* WITHOUT WARRANTIES OR CONDITIONS OF ANY KIND, either express or implied.
* See the License for the specific language governing permissions and
* limitations under the License.
*
* SPDX-License-Identifier: Apache-2.0

.SUBCKT sky130_fd_sc_hd__o2111ai_2 A1 A2 B1 C1 D1 VGND VNB VNB net59 Y
*.PININFO A1:I A2:I B1:I C1:I D1:I VGND:I VNB:I VNB:I net59:I Y:O
MMPA0 net59 A1 sndA1 VNB sky130_fd_pr__pfet_01v8_hvt m=2 w=1.0u l=0.15u mult=1 sa=0.265
+ sb=0.265 sd=0.28 area=0.063 perim=1.14
MMPA1 sndA1 A2 Y VNB sky130_fd_pr__pfet_01v8_hvt m=2 w=1.0u l=0.15u mult=1 sa=0.265
+ sb=0.265 sd=0.28 area=0.063 perim=1.14
MMPB0 net59 B1 Y VNB sky130_fd_pr__pfet_01v8_hvt m=2 w=1.0u l=0.15u mult=1 sa=0.265
+ sb=0.265 sd=0.28 area=0.063 perim=1.14
MMPC0 net59 C1 Y VNB sky130_fd_pr__pfet_01v8_hvt m=2 w=1.0u l=0.15u mult=1 sa=0.265
+ sb=0.265 sd=0.28 area=0.063 perim=1.14
MMPD0 net59 D1 Y VNB sky130_fd_pr__pfet_01v8_hvt m=2 w=1.0u l=0.15u mult=1 sa=0.265
+ sb=0.265 sd=0.28 area=0.063 perim=1.14
MMNA0 pndA A1 VGND VNB sky130_fd_pr__nfet_01v8 m=2 w=0.65u l=0.15u mult=1 sa=0.265
+ sb=0.265 sd=0.28 area=0.063 perim=1.14
MMNA1 pndA A2 VGND VNB sky130_fd_pr__nfet_01v8 m=2 w=0.65u l=0.15u mult=1 sa=0.265
+ sb=0.265 sd=0.28 area=0.063 perim=1.14
MMNB0 pndB B1 pndA VNB sky130_fd_pr__nfet_01v8 m=2 w=0.65u l=0.15u mult=1 sa=0.265
+ sb=0.265 sd=0.28 area=0.063 perim=1.14
MMNC0 pndC C1 pndB VNB sky130_fd_pr__nfet_01v8 m=2 w=0.65u l=0.15u mult=1 sa=0.265
+ sb=0.265 sd=0.28 area=0.063 perim=1.14
MMND0 Y D1 pndC VNB sky130_fd_pr__nfet_01v8 m=2 w=0.65u l=0.15u mult=1 sa=0.265
+ sb=0.265 sd=0.28 area=0.063 perim=1.14
.ENDS sky130_fd_sc_hd__o2111ai_2
* Copyright 2020 The SkyWater PDK Authors
*
* Licensed under the Apache License, Version 2.0 (the "License");
* you may not use this file except in compliance with the License.
* You may obtain a copy of the License at
*
*     https:  www.apache.org licenses LICENSE-2.0
*
* Unless required by applicable law or agreed to in writing, software
* distributed under the License is distributed on an "AS IS" BASIS,
* WITHOUT WARRANTIES OR CONDITIONS OF ANY KIND, either express or implied.
* See the License for the specific language governing permissions and
* limitations under the License.
*
* SPDX-License-Identifier: Apache-2.0

.SUBCKT sky130_fd_sc_hd__o2111ai_4 A1 A2 B1 C1 D1 VGND VNB VNB net59 Y
*.PININFO A1:I A2:I B1:I C1:I D1:I VGND:I VNB:I VNB:I net59:I Y:O
MMPA0 net59 A1 sndA1 VNB sky130_fd_pr__pfet_01v8_hvt m=4 w=1.0u l=0.15u mult=1 sa=0.265
+ sb=0.265 sd=0.28 area=0.063 perim=1.14
MMPA1 sndA1 A2 Y VNB sky130_fd_pr__pfet_01v8_hvt m=4 w=1.0u l=0.15u mult=1 sa=0.265
+ sb=0.265 sd=0.28 area=0.063 perim=1.14
MMPB0 net59 B1 Y VNB sky130_fd_pr__pfet_01v8_hvt m=4 w=1.0u l=0.15u mult=1 sa=0.265
+ sb=0.265 sd=0.28 area=0.063 perim=1.14
MMPC0 net59 C1 Y VNB sky130_fd_pr__pfet_01v8_hvt m=4 w=1.0u l=0.15u mult=1 sa=0.265
+ sb=0.265 sd=0.28 area=0.063 perim=1.14
MMPD0 net59 D1 Y VNB sky130_fd_pr__pfet_01v8_hvt m=4 w=1.0u l=0.15u mult=1 sa=0.265
+ sb=0.265 sd=0.28 area=0.063 perim=1.14
MMNA0 pndA A1 VGND VNB sky130_fd_pr__nfet_01v8 m=4 w=0.65u l=0.15u mult=1 sa=0.265
+ sb=0.265 sd=0.28 area=0.063 perim=1.14
MMNA1 pndA A2 VGND VNB sky130_fd_pr__nfet_01v8 m=4 w=0.65u l=0.15u mult=1 sa=0.265
+ sb=0.265 sd=0.28 area=0.063 perim=1.14
MMNB0 pndB B1 pndA VNB sky130_fd_pr__nfet_01v8 m=4 w=0.65u l=0.15u mult=1 sa=0.265
+ sb=0.265 sd=0.28 area=0.063 perim=1.14
MMNC0 pndC C1 pndB VNB sky130_fd_pr__nfet_01v8 m=4 w=0.65u l=0.15u mult=1 sa=0.265
+ sb=0.265 sd=0.28 area=0.063 perim=1.14
MMND0 Y D1 pndC VNB sky130_fd_pr__nfet_01v8 m=4 w=0.65u l=0.15u mult=1 sa=0.265
+ sb=0.265 sd=0.28 area=0.063 perim=1.14
.ENDS sky130_fd_sc_hd__o2111ai_4
* Copyright 2020 The SkyWater PDK Authors
*
* Licensed under the Apache License, Version 2.0 (the "License");
* you may not use this file except in compliance with the License.
* You may obtain a copy of the License at
*
*     https:  www.apache.org licenses LICENSE-2.0
*
* Unless required by applicable law or agreed to in writing, software
* distributed under the License is distributed on an "AS IS" BASIS,
* WITHOUT WARRANTIES OR CONDITIONS OF ANY KIND, either express or implied.
* See the License for the specific language governing permissions and
* limitations under the License.
*
* SPDX-License-Identifier: Apache-2.0

.SUBCKT sky130_fd_sc_hd__o211a_1 A1 A2 B1 C1 VGND VNB VNB net59 X
*.PININFO A1:I A2:I B1:I C1:I VGND:I VNB:I VNB:I net59:I X:O
MMPA0 net59 A1 sndA1 VNB sky130_fd_pr__pfet_01v8_hvt m=1 w=1.0u l=0.15u mult=1 sa=0.265
+ sb=0.265 sd=0.28 area=0.063 perim=1.14
MMPA1 sndA1 A2 y VNB sky130_fd_pr__pfet_01v8_hvt m=1 w=1.0u l=0.15u mult=1 sa=0.265
+ sb=0.265 sd=0.28 area=0.063 perim=1.14
MMPB0 net59 B1 y VNB sky130_fd_pr__pfet_01v8_hvt m=1 w=1.0u l=0.15u mult=1 sa=0.265
+ sb=0.265 sd=0.28 area=0.063 perim=1.14
MMPC0 net59 C1 y VNB sky130_fd_pr__pfet_01v8_hvt m=1 w=1.0u l=0.15u mult=1 sa=0.265
+ sb=0.265 sd=0.28 area=0.063 perim=1.14
MMIPX X y net59 VNB sky130_fd_pr__pfet_01v8_hvt m=1 w=1.0u l=0.15u mult=1 sa=0.265
+ sb=0.265 sd=0.28 area=0.063 perim=1.14
MMNA0 pndA A1 VGND VNB sky130_fd_pr__nfet_01v8 m=1 w=0.65u l=0.15u mult=1 sa=0.265
+ sb=0.265 sd=0.28 area=0.063 perim=1.14
MMNA1 pndA A2 VGND VNB sky130_fd_pr__nfet_01v8 m=1 w=0.65u l=0.15u mult=1 sa=0.265
+ sb=0.265 sd=0.28 area=0.063 perim=1.14
MMNB0 pndB B1 pndA VNB sky130_fd_pr__nfet_01v8 m=1 w=0.65u l=0.15u mult=1 sa=0.265
+ sb=0.265 sd=0.28 area=0.063 perim=1.14
MMNC0 y C1 pndB VNB sky130_fd_pr__nfet_01v8 m=1 w=0.65u l=0.15u mult=1 sa=0.265
+ sb=0.265 sd=0.28 area=0.063 perim=1.14
MMINX X y VGND VNB sky130_fd_pr__nfet_01v8 m=1 w=0.65u l=0.15u mult=1 sa=0.265
+ sb=0.265 sd=0.28 area=0.063 perim=1.14
.ENDS sky130_fd_sc_hd__o211a_1
* Copyright 2020 The SkyWater PDK Authors
*
* Licensed under the Apache License, Version 2.0 (the "License");
* you may not use this file except in compliance with the License.
* You may obtain a copy of the License at
*
*     https:  www.apache.org licenses LICENSE-2.0
*
* Unless required by applicable law or agreed to in writing, software
* distributed under the License is distributed on an "AS IS" BASIS,
* WITHOUT WARRANTIES OR CONDITIONS OF ANY KIND, either express or implied.
* See the License for the specific language governing permissions and
* limitations under the License.
*
* SPDX-License-Identifier: Apache-2.0

.SUBCKT sky130_fd_sc_hd__o211a_2 A1 A2 B1 C1 VGND VNB VNB net59 X
*.PININFO A1:I A2:I B1:I C1:I VGND:I VNB:I VNB:I net59:I X:O
MMPA0 net59 A1 sndA1 VNB sky130_fd_pr__pfet_01v8_hvt m=1 w=1.0u l=0.15u mult=1 sa=0.265
+ sb=0.265 sd=0.28 area=0.063 perim=1.14
MMPA1 sndA1 A2 y VNB sky130_fd_pr__pfet_01v8_hvt m=1 w=1.0u l=0.15u mult=1 sa=0.265
+ sb=0.265 sd=0.28 area=0.063 perim=1.14
MMPB0 net59 B1 y VNB sky130_fd_pr__pfet_01v8_hvt m=1 w=1.0u l=0.15u mult=1 sa=0.265
+ sb=0.265 sd=0.28 area=0.063 perim=1.14
MMPC0 net59 C1 y VNB sky130_fd_pr__pfet_01v8_hvt m=1 w=1.0u l=0.15u mult=1 sa=0.265
+ sb=0.265 sd=0.28 area=0.063 perim=1.14
MMIPX X y net59 VNB sky130_fd_pr__pfet_01v8_hvt m=2 w=1.0u l=0.15u mult=1 sa=0.265
+ sb=0.265 sd=0.28 area=0.063 perim=1.14
MMNA0 pndA A1 VGND VNB sky130_fd_pr__nfet_01v8 m=1 w=0.65u l=0.15u mult=1 sa=0.265
+ sb=0.265 sd=0.28 area=0.063 perim=1.14
MMNA1 pndA A2 VGND VNB sky130_fd_pr__nfet_01v8 m=1 w=0.65u l=0.15u mult=1 sa=0.265
+ sb=0.265 sd=0.28 area=0.063 perim=1.14
MMNB0 pndB B1 pndA VNB sky130_fd_pr__nfet_01v8 m=1 w=0.65u l=0.15u mult=1 sa=0.265
+ sb=0.265 sd=0.28 area=0.063 perim=1.14
MMNC0 y C1 pndB VNB sky130_fd_pr__nfet_01v8 m=1 w=0.65u l=0.15u mult=1 sa=0.265
+ sb=0.265 sd=0.28 area=0.063 perim=1.14
MMINX X y VGND VNB sky130_fd_pr__nfet_01v8 m=2 w=0.65u l=0.15u mult=1 sa=0.265
+ sb=0.265 sd=0.28 area=0.063 perim=1.14
.ENDS sky130_fd_sc_hd__o211a_2
* Copyright 2020 The SkyWater PDK Authors
*
* Licensed under the Apache License, Version 2.0 (the "License");
* you may not use this file except in compliance with the License.
* You may obtain a copy of the License at
*
*     https:  www.apache.org licenses LICENSE-2.0
*
* Unless required by applicable law or agreed to in writing, software
* distributed under the License is distributed on an "AS IS" BASIS,
* WITHOUT WARRANTIES OR CONDITIONS OF ANY KIND, either express or implied.
* See the License for the specific language governing permissions and
* limitations under the License.
*
* SPDX-License-Identifier: Apache-2.0

.SUBCKT sky130_fd_sc_hd__o211a_4 A1 A2 B1 C1 VGND VNB VNB net59 X
*.PININFO A1:I A2:I B1:I C1:I VGND:I VNB:I VNB:I net59:I X:O
MMPA0 net59 A1 sndA1 VNB sky130_fd_pr__pfet_01v8_hvt m=2 w=1.0u l=0.15u mult=1 sa=0.265
+ sb=0.265 sd=0.28 area=0.063 perim=1.14
MMPA1 sndA1 A2 y VNB sky130_fd_pr__pfet_01v8_hvt m=2 w=1.0u l=0.15u mult=1 sa=0.265
+ sb=0.265 sd=0.28 area=0.063 perim=1.14
MMPB0 net59 B1 y VNB sky130_fd_pr__pfet_01v8_hvt m=2 w=1.0u l=0.15u mult=1 sa=0.265
+ sb=0.265 sd=0.28 area=0.063 perim=1.14
MMPC0 net59 C1 y VNB sky130_fd_pr__pfet_01v8_hvt m=2 w=1.0u l=0.15u mult=1 sa=0.265
+ sb=0.265 sd=0.28 area=0.063 perim=1.14
MMIPX X y net59 VNB sky130_fd_pr__pfet_01v8_hvt m=4 w=1.0u l=0.15u mult=1 sa=0.265
+ sb=0.265 sd=0.28 area=0.063 perim=1.14
MMNA0 pndA A1 VGND VNB sky130_fd_pr__nfet_01v8 m=2 w=0.65u l=0.15u mult=1 sa=0.265
+ sb=0.265 sd=0.28 area=0.063 perim=1.14
MMNA1 pndA A2 VGND VNB sky130_fd_pr__nfet_01v8 m=2 w=0.65u l=0.15u mult=1 sa=0.265
+ sb=0.265 sd=0.28 area=0.063 perim=1.14
MMNB0 pndB B1 pndA VNB sky130_fd_pr__nfet_01v8 m=2 w=0.65u l=0.15u mult=1 sa=0.265
+ sb=0.265 sd=0.28 area=0.063 perim=1.14
MMNC0 y C1 pndB VNB sky130_fd_pr__nfet_01v8 m=2 w=0.65u l=0.15u mult=1 sa=0.265
+ sb=0.265 sd=0.28 area=0.063 perim=1.14
MMINX X y VGND VNB sky130_fd_pr__nfet_01v8 m=4 w=0.65u l=0.15u mult=1 sa=0.265
+ sb=0.265 sd=0.28 area=0.063 perim=1.14
.ENDS sky130_fd_sc_hd__o211a_4
* Copyright 2020 The SkyWater PDK Authors
*
* Licensed under the Apache License, Version 2.0 (the "License");
* you may not use this file except in compliance with the License.
* You may obtain a copy of the License at
*
*     https:  www.apache.org licenses LICENSE-2.0
*
* Unless required by applicable law or agreed to in writing, software
* distributed under the License is distributed on an "AS IS" BASIS,
* WITHOUT WARRANTIES OR CONDITIONS OF ANY KIND, either express or implied.
* See the License for the specific language governing permissions and
* limitations under the License.
*
* SPDX-License-Identifier: Apache-2.0

.SUBCKT sky130_fd_sc_hd__o211ai_1 A1 A2 B1 C1 VGND VNB VNB net59 Y
*.PININFO A1:I A2:I B1:I C1:I VGND:I VNB:I VNB:I net59:I Y:O
MMPA0 net59 A1 sndA1 VNB sky130_fd_pr__pfet_01v8_hvt m=1 w=1.0u l=0.15u mult=1 sa=0.265
+ sb=0.265 sd=0.28 area=0.063 perim=1.14
MMPA1 sndA1 A2 Y VNB sky130_fd_pr__pfet_01v8_hvt m=1 w=1.0u l=0.15u mult=1 sa=0.265
+ sb=0.265 sd=0.28 area=0.063 perim=1.14
MMPB0 net59 B1 Y VNB sky130_fd_pr__pfet_01v8_hvt m=1 w=1.0u l=0.15u mult=1 sa=0.265
+ sb=0.265 sd=0.28 area=0.063 perim=1.14
MMPC0 net59 C1 Y VNB sky130_fd_pr__pfet_01v8_hvt m=1 w=1.0u l=0.15u mult=1 sa=0.265
+ sb=0.265 sd=0.28 area=0.063 perim=1.14
MMNA0 pndA A1 VGND VNB sky130_fd_pr__nfet_01v8 m=1 w=0.65u l=0.15u mult=1 sa=0.265
+ sb=0.265 sd=0.28 area=0.063 perim=1.14
MMNA1 pndA A2 VGND VNB sky130_fd_pr__nfet_01v8 m=1 w=0.65u l=0.15u mult=1 sa=0.265
+ sb=0.265 sd=0.28 area=0.063 perim=1.14
MMNB0 pndB B1 pndA VNB sky130_fd_pr__nfet_01v8 m=1 w=0.65u l=0.15u mult=1 sa=0.265
+ sb=0.265 sd=0.28 area=0.063 perim=1.14
MMNC0 Y C1 pndB VNB sky130_fd_pr__nfet_01v8 m=1 w=0.65u l=0.15u mult=1 sa=0.265
+ sb=0.265 sd=0.28 area=0.063 perim=1.14
.ENDS sky130_fd_sc_hd__o211ai_1
* Copyright 2020 The SkyWater PDK Authors
*
* Licensed under the Apache License, Version 2.0 (the "License");
* you may not use this file except in compliance with the License.
* You may obtain a copy of the License at
*
*     https:  www.apache.org licenses LICENSE-2.0
*
* Unless required by applicable law or agreed to in writing, software
* distributed under the License is distributed on an "AS IS" BASIS,
* WITHOUT WARRANTIES OR CONDITIONS OF ANY KIND, either express or implied.
* See the License for the specific language governing permissions and
* limitations under the License.
*
* SPDX-License-Identifier: Apache-2.0

.SUBCKT sky130_fd_sc_hd__o211ai_2 A1 A2 B1 C1 VGND VNB VNB net59 Y
*.PININFO A1:I A2:I B1:I C1:I VGND:I VNB:I VNB:I net59:I Y:O
MMPA0 net59 A1 sndA1 VNB sky130_fd_pr__pfet_01v8_hvt m=2 w=1.0u l=0.15u mult=1 sa=0.265
+ sb=0.265 sd=0.28 area=0.063 perim=1.14
MMPA1 sndA1 A2 Y VNB sky130_fd_pr__pfet_01v8_hvt m=2 w=1.0u l=0.15u mult=1 sa=0.265
+ sb=0.265 sd=0.28 area=0.063 perim=1.14
MMPB0 net59 B1 Y VNB sky130_fd_pr__pfet_01v8_hvt m=2 w=1.0u l=0.15u mult=1 sa=0.265
+ sb=0.265 sd=0.28 area=0.063 perim=1.14
MMPC0 net59 C1 Y VNB sky130_fd_pr__pfet_01v8_hvt m=2 w=1.0u l=0.15u mult=1 sa=0.265
+ sb=0.265 sd=0.28 area=0.063 perim=1.14
MMNA0 pndA A1 VGND VNB sky130_fd_pr__nfet_01v8 m=2 w=0.65u l=0.15u mult=1 sa=0.265
+ sb=0.265 sd=0.28 area=0.063 perim=1.14
MMNA1 pndA A2 VGND VNB sky130_fd_pr__nfet_01v8 m=2 w=0.65u l=0.15u mult=1 sa=0.265
+ sb=0.265 sd=0.28 area=0.063 perim=1.14
MMNB0 pndB B1 pndA VNB sky130_fd_pr__nfet_01v8 m=2 w=0.65u l=0.15u mult=1 sa=0.265
+ sb=0.265 sd=0.28 area=0.063 perim=1.14
MMNC0 Y C1 pndB VNB sky130_fd_pr__nfet_01v8 m=2 w=0.65u l=0.15u mult=1 sa=0.265
+ sb=0.265 sd=0.28 area=0.063 perim=1.14
.ENDS sky130_fd_sc_hd__o211ai_2
* Copyright 2020 The SkyWater PDK Authors
*
* Licensed under the Apache License, Version 2.0 (the "License");
* you may not use this file except in compliance with the License.
* You may obtain a copy of the License at
*
*     https:  www.apache.org licenses LICENSE-2.0
*
* Unless required by applicable law or agreed to in writing, software
* distributed under the License is distributed on an "AS IS" BASIS,
* WITHOUT WARRANTIES OR CONDITIONS OF ANY KIND, either express or implied.
* See the License for the specific language governing permissions and
* limitations under the License.
*
* SPDX-License-Identifier: Apache-2.0

.SUBCKT sky130_fd_sc_hd__o211ai_4 A1 A2 B1 C1 VGND VNB VNB net59 Y
*.PININFO A1:I A2:I B1:I C1:I VGND:I VNB:I VNB:I net59:I Y:O
MMPA0 net59 A1 sndA1 VNB sky130_fd_pr__pfet_01v8_hvt m=4 w=1.0u l=0.15u mult=1 sa=0.265
+ sb=0.265 sd=0.28 area=0.063 perim=1.14
MMPA1 sndA1 A2 Y VNB sky130_fd_pr__pfet_01v8_hvt m=4 w=1.0u l=0.15u mult=1 sa=0.265
+ sb=0.265 sd=0.28 area=0.063 perim=1.14
MMPB0 net59 B1 Y VNB sky130_fd_pr__pfet_01v8_hvt m=4 w=1.0u l=0.15u mult=1 sa=0.265
+ sb=0.265 sd=0.28 area=0.063 perim=1.14
MMPC0 net59 C1 Y VNB sky130_fd_pr__pfet_01v8_hvt m=4 w=1.0u l=0.15u mult=1 sa=0.265
+ sb=0.265 sd=0.28 area=0.063 perim=1.14
MMNA0 pndA A1 VGND VNB sky130_fd_pr__nfet_01v8 m=4 w=0.65u l=0.15u mult=1 sa=0.265
+ sb=0.265 sd=0.28 area=0.063 perim=1.14
MMNA1 pndA A2 VGND VNB sky130_fd_pr__nfet_01v8 m=4 w=0.65u l=0.15u mult=1 sa=0.265
+ sb=0.265 sd=0.28 area=0.063 perim=1.14
MMNB0 pndB B1 pndA VNB sky130_fd_pr__nfet_01v8 m=4 w=0.65u l=0.15u mult=1 sa=0.265
+ sb=0.265 sd=0.28 area=0.063 perim=1.14
MMNC0 Y C1 pndB VNB sky130_fd_pr__nfet_01v8 m=4 w=0.65u l=0.15u mult=1 sa=0.265
+ sb=0.265 sd=0.28 area=0.063 perim=1.14
.ENDS sky130_fd_sc_hd__o211ai_4
* Copyright 2020 The SkyWater PDK Authors
*
* Licensed under the Apache License, Version 2.0 (the "License");
* you may not use this file except in compliance with the License.
* You may obtain a copy of the License at
*
*     https:  www.apache.org licenses LICENSE-2.0
*
* Unless required by applicable law or agreed to in writing, software
* distributed under the License is distributed on an "AS IS" BASIS,
* WITHOUT WARRANTIES OR CONDITIONS OF ANY KIND, either express or implied.
* See the License for the specific language governing permissions and
* limitations under the License.
*
* SPDX-License-Identifier: Apache-2.0

.SUBCKT sky130_fd_sc_hd__o21a_1 A1 A2 B1 VGND VNB VNB net59 X
*.PININFO A1:I A2:I B1:I VGND:I VNB:I VNB:I net59:I X:O
MMPA0 net59 A1 sndA1 VNB sky130_fd_pr__pfet_01v8_hvt m=1 w=1.0u l=0.15u mult=1 sa=0.265
+ sb=0.265 sd=0.28 area=0.063 perim=1.14
MMPA1 sndA1 A2 y VNB sky130_fd_pr__pfet_01v8_hvt m=1 w=1.0u l=0.15u mult=1 sa=0.265
+ sb=0.265 sd=0.28 area=0.063 perim=1.14
MMPB0 net59 B1 y VNB sky130_fd_pr__pfet_01v8_hvt m=1 w=1.0u l=0.15u mult=1 sa=0.265
+ sb=0.265 sd=0.28 area=0.063 perim=1.14
MMIPX X y net59 VNB sky130_fd_pr__pfet_01v8_hvt m=1 w=1.0u l=0.15u mult=1 sa=0.265
+ sb=0.265 sd=0.28 area=0.063 perim=1.14
MMNA0 pndA A1 VGND VNB sky130_fd_pr__nfet_01v8 m=1 w=0.65u l=0.15u mult=1 sa=0.265
+ sb=0.265 sd=0.28 area=0.063 perim=1.14
MMNA1 pndA A2 VGND VNB sky130_fd_pr__nfet_01v8 m=1 w=0.65u l=0.15u mult=1 sa=0.265
+ sb=0.265 sd=0.28 area=0.063 perim=1.14
MMNB0 y B1 pndA VNB sky130_fd_pr__nfet_01v8 m=1 w=0.65u l=0.15u mult=1 sa=0.265
+ sb=0.265 sd=0.28 area=0.063 perim=1.14
MMINX X y VGND VNB sky130_fd_pr__nfet_01v8 m=1 w=0.65u l=0.15u mult=1 sa=0.265
+ sb=0.265 sd=0.28 area=0.063 perim=1.14
.ENDS sky130_fd_sc_hd__o21a_1
* Copyright 2020 The SkyWater PDK Authors
*
* Licensed under the Apache License, Version 2.0 (the "License");
* you may not use this file except in compliance with the License.
* You may obtain a copy of the License at
*
*     https:  www.apache.org licenses LICENSE-2.0
*
* Unless required by applicable law or agreed to in writing, software
* distributed under the License is distributed on an "AS IS" BASIS,
* WITHOUT WARRANTIES OR CONDITIONS OF ANY KIND, either express or implied.
* See the License for the specific language governing permissions and
* limitations under the License.
*
* SPDX-License-Identifier: Apache-2.0

.SUBCKT sky130_fd_sc_hd__o21a_2 A1 A2 B1 VGND VNB VNB net59 X
*.PININFO A1:I A2:I B1:I VGND:I VNB:I VNB:I net59:I X:O
MMPA0 net59 A1 sndA1 VNB sky130_fd_pr__pfet_01v8_hvt m=1 w=1.0u l=0.15u mult=1 sa=0.265
+ sb=0.265 sd=0.28 area=0.063 perim=1.14
MMPA1 sndA1 A2 y VNB sky130_fd_pr__pfet_01v8_hvt m=1 w=1.0u l=0.15u mult=1 sa=0.265
+ sb=0.265 sd=0.28 area=0.063 perim=1.14
MMPB0 net59 B1 y VNB sky130_fd_pr__pfet_01v8_hvt m=1 w=1.0u l=0.15u mult=1 sa=0.265
+ sb=0.265 sd=0.28 area=0.063 perim=1.14
MMIPX X y net59 VNB sky130_fd_pr__pfet_01v8_hvt m=2 w=1.0u l=0.15u mult=1 sa=0.265
+ sb=0.265 sd=0.28 area=0.063 perim=1.14
MMNA0 pndA A1 VGND VNB sky130_fd_pr__nfet_01v8 m=1 w=0.65u l=0.15u mult=1 sa=0.265
+ sb=0.265 sd=0.28 area=0.063 perim=1.14
MMNA1 pndA A2 VGND VNB sky130_fd_pr__nfet_01v8 m=1 w=0.65u l=0.15u mult=1 sa=0.265
+ sb=0.265 sd=0.28 area=0.063 perim=1.14
MMNB0 y B1 pndA VNB sky130_fd_pr__nfet_01v8 m=1 w=0.65u l=0.15u mult=1 sa=0.265
+ sb=0.265 sd=0.28 area=0.063 perim=1.14
MMINX X y VGND VNB sky130_fd_pr__nfet_01v8 m=2 w=0.65u l=0.15u mult=1 sa=0.265
+ sb=0.265 sd=0.28 area=0.063 perim=1.14
.ENDS sky130_fd_sc_hd__o21a_2
* Copyright 2020 The SkyWater PDK Authors
*
* Licensed under the Apache License, Version 2.0 (the "License");
* you may not use this file except in compliance with the License.
* You may obtain a copy of the License at
*
*     https:  www.apache.org licenses LICENSE-2.0
*
* Unless required by applicable law or agreed to in writing, software
* distributed under the License is distributed on an "AS IS" BASIS,
* WITHOUT WARRANTIES OR CONDITIONS OF ANY KIND, either express or implied.
* See the License for the specific language governing permissions and
* limitations under the License.
*
* SPDX-License-Identifier: Apache-2.0

.SUBCKT sky130_fd_sc_hd__o21a_4 A1 A2 B1 VGND VNB VNB net59 X
*.PININFO A1:I A2:I B1:I VGND:I VNB:I VNB:I net59:I X:O
MMPA0 net59 A1 sndA1 VNB sky130_fd_pr__pfet_01v8_hvt m=2 w=1.0u l=0.15u mult=1 sa=0.265
+ sb=0.265 sd=0.28 area=0.063 perim=1.14
MMPA1 sndA1 A2 y VNB sky130_fd_pr__pfet_01v8_hvt m=2 w=1.0u l=0.15u mult=1 sa=0.265
+ sb=0.265 sd=0.28 area=0.063 perim=1.14
MMPB0 net59 B1 y VNB sky130_fd_pr__pfet_01v8_hvt m=2 w=1.0u l=0.15u mult=1 sa=0.265
+ sb=0.265 sd=0.28 area=0.063 perim=1.14
MMIPX X y net59 VNB sky130_fd_pr__pfet_01v8_hvt m=4 w=1.0u l=0.15u mult=1 sa=0.265
+ sb=0.265 sd=0.28 area=0.063 perim=1.14
MMNA0 pndA A1 VGND VNB sky130_fd_pr__nfet_01v8 m=2 w=0.65u l=0.15u mult=1 sa=0.265
+ sb=0.265 sd=0.28 area=0.063 perim=1.14
MMNA1 pndA A2 VGND VNB sky130_fd_pr__nfet_01v8 m=2 w=0.65u l=0.15u mult=1 sa=0.265
+ sb=0.265 sd=0.28 area=0.063 perim=1.14
MMNB0 y B1 pndA VNB sky130_fd_pr__nfet_01v8 m=2 w=0.65u l=0.15u mult=1 sa=0.265
+ sb=0.265 sd=0.28 area=0.063 perim=1.14
MMINX X y VGND VNB sky130_fd_pr__nfet_01v8 m=4 w=0.65u l=0.15u mult=1 sa=0.265
+ sb=0.265 sd=0.28 area=0.063 perim=1.14
.ENDS sky130_fd_sc_hd__o21a_4
* Copyright 2020 The SkyWater PDK Authors
*
* Licensed under the Apache License, Version 2.0 (the "License");
* you may not use this file except in compliance with the License.
* You may obtain a copy of the License at
*
*     https:  www.apache.org licenses LICENSE-2.0
*
* Unless required by applicable law or agreed to in writing, software
* distributed under the License is distributed on an "AS IS" BASIS,
* WITHOUT WARRANTIES OR CONDITIONS OF ANY KIND, either express or implied.
* See the License for the specific language governing permissions and
* limitations under the License.
*
* SPDX-License-Identifier: Apache-2.0

.SUBCKT sky130_fd_sc_hd__o21ai_0 A1 A2 B1 VGND VNB VNB net59 Y
*.PININFO A1:I A2:I B1:I VGND:I VNB:I VNB:I net59:I Y:O
MMPA0 net59 A1 sndA1 VNB sky130_fd_pr__pfet_01v8_hvt m=1 w=0.64u l=0.15u mult=1
+ sa=0.265 sb=0.265 sd=0.28 area=0.063 perim=1.14
MMPA1 sndA1 A2 Y VNB sky130_fd_pr__pfet_01v8_hvt m=1 w=0.64u l=0.15u mult=1 sa=0.265
+ sb=0.265 sd=0.28 area=0.063 perim=1.14
MMPB0 net59 B1 Y VNB sky130_fd_pr__pfet_01v8_hvt m=1 w=0.64u l=0.15u mult=1 sa=0.265
+ sb=0.265 sd=0.28 area=0.063 perim=1.14
MMNA0 pndA A1 VGND VNB sky130_fd_pr__nfet_01v8 m=1 w=0.42u l=0.15u mult=1 sa=0.265
+ sb=0.265 sd=0.28 area=0.063 perim=1.14
MMNA1 pndA A2 VGND VNB sky130_fd_pr__nfet_01v8 m=1 w=0.42u l=0.15u mult=1 sa=0.265
+ sb=0.265 sd=0.28 area=0.063 perim=1.14
MMNB0 Y B1 pndA VNB sky130_fd_pr__nfet_01v8 m=1 w=0.42u l=0.15u mult=1 sa=0.265
+ sb=0.265 sd=0.28 area=0.063 perim=1.14
.ENDS sky130_fd_sc_hd__o21ai_0
* Copyright 2020 The SkyWater PDK Authors
*
* Licensed under the Apache License, Version 2.0 (the "License");
* you may not use this file except in compliance with the License.
* You may obtain a copy of the License at
*
*     https:  www.apache.org licenses LICENSE-2.0
*
* Unless required by applicable law or agreed to in writing, software
* distributed under the License is distributed on an "AS IS" BASIS,
* WITHOUT WARRANTIES OR CONDITIONS OF ANY KIND, either express or implied.
* See the License for the specific language governing permissions and
* limitations under the License.
*
* SPDX-License-Identifier: Apache-2.0

.SUBCKT sky130_fd_sc_hd__o21ai_1 A1 A2 B1 VGND VNB VNB net59 Y
*.PININFO A1:I A2:I B1:I VGND:I VNB:I VNB:I net59:I Y:O
MMPA0 net59 A1 sndA1 VNB sky130_fd_pr__pfet_01v8_hvt m=1 w=1.0u l=0.15u mult=1 sa=0.265
+ sb=0.265 sd=0.28 area=0.063 perim=1.14
MMPA1 sndA1 A2 Y VNB sky130_fd_pr__pfet_01v8_hvt m=1 w=1.0u l=0.15u mult=1 sa=0.265
+ sb=0.265 sd=0.28 area=0.063 perim=1.14
MMPB0 net59 B1 Y VNB sky130_fd_pr__pfet_01v8_hvt m=1 w=0.7u l=0.15u mult=1 sa=0.265
+ sb=0.265 sd=0.28 area=0.063 perim=1.14
MMNA0 pndA A1 VGND VNB sky130_fd_pr__nfet_01v8 m=1 w=0.65u l=0.15u mult=1 sa=0.265
+ sb=0.265 sd=0.28 area=0.063 perim=1.14
MMNA1 pndA A2 VGND VNB sky130_fd_pr__nfet_01v8 m=1 w=0.65u l=0.15u mult=1 sa=0.265
+ sb=0.265 sd=0.28 area=0.063 perim=1.14
MMNB0 Y B1 pndA VNB sky130_fd_pr__nfet_01v8 m=1 w=0.65u l=0.15u mult=1 sa=0.265
+ sb=0.265 sd=0.28 area=0.063 perim=1.14
.ENDS sky130_fd_sc_hd__o21ai_1
* Copyright 2020 The SkyWater PDK Authors
*
* Licensed under the Apache License, Version 2.0 (the "License");
* you may not use this file except in compliance with the License.
* You may obtain a copy of the License at
*
*     https:  www.apache.org licenses LICENSE-2.0
*
* Unless required by applicable law or agreed to in writing, software
* distributed under the License is distributed on an "AS IS" BASIS,
* WITHOUT WARRANTIES OR CONDITIONS OF ANY KIND, either express or implied.
* See the License for the specific language governing permissions and
* limitations under the License.
*
* SPDX-License-Identifier: Apache-2.0

.SUBCKT sky130_fd_sc_hd__o21ai_2 A1 A2 B1 VGND VNB VNB net59 Y
*.PININFO A1:I A2:I B1:I VGND:I VNB:I VNB:I net59:I Y:O
MMPA0 net59 A1 sndA1 VNB sky130_fd_pr__pfet_01v8_hvt m=2 w=1.0u l=0.15u mult=1 sa=0.265
+ sb=0.265 sd=0.28 area=0.063 perim=1.14
MMPA1 sndA1 A2 Y VNB sky130_fd_pr__pfet_01v8_hvt m=2 w=1.0u l=0.15u mult=1 sa=0.265
+ sb=0.265 sd=0.28 area=0.063 perim=1.14
MMPB0 net59 B1 Y VNB sky130_fd_pr__pfet_01v8_hvt m=2 w=1.0u l=0.15u mult=1 sa=0.265
+ sb=0.265 sd=0.28 area=0.063 perim=1.14
MMNA0 pndA A1 VGND VNB sky130_fd_pr__nfet_01v8 m=2 w=0.65u l=0.15u mult=1 sa=0.265
+ sb=0.265 sd=0.28 area=0.063 perim=1.14
MMNA1 pndA A2 VGND VNB sky130_fd_pr__nfet_01v8 m=2 w=0.65u l=0.15u mult=1 sa=0.265
+ sb=0.265 sd=0.28 area=0.063 perim=1.14
MMNB0 Y B1 pndA VNB sky130_fd_pr__nfet_01v8 m=2 w=0.65u l=0.15u mult=1 sa=0.265
+ sb=0.265 sd=0.28 area=0.063 perim=1.14
.ENDS sky130_fd_sc_hd__o21ai_2
* Copyright 2020 The SkyWater PDK Authors
*
* Licensed under the Apache License, Version 2.0 (the "License");
* you may not use this file except in compliance with the License.
* You may obtain a copy of the License at
*
*     https:  www.apache.org licenses LICENSE-2.0
*
* Unless required by applicable law or agreed to in writing, software
* distributed under the License is distributed on an "AS IS" BASIS,
* WITHOUT WARRANTIES OR CONDITIONS OF ANY KIND, either express or implied.
* See the License for the specific language governing permissions and
* limitations under the License.
*
* SPDX-License-Identifier: Apache-2.0

.SUBCKT sky130_fd_sc_hd__o21ai_4 A1 A2 B1 VGND VNB VNB net59 Y
*.PININFO A1:I A2:I B1:I VGND:I VNB:I VNB:I net59:I Y:O
MMPA0 net59 A1 sndA1 VNB sky130_fd_pr__pfet_01v8_hvt m=4 w=1.0u l=0.15u mult=1 sa=0.265
+ sb=0.265 sd=0.28 area=0.063 perim=1.14
MMPA1 sndA1 A2 Y VNB sky130_fd_pr__pfet_01v8_hvt m=4 w=1.0u l=0.15u mult=1 sa=0.265
+ sb=0.265 sd=0.28 area=0.063 perim=1.14
MMPB0 net59 B1 Y VNB sky130_fd_pr__pfet_01v8_hvt m=4 w=1.0u l=0.15u mult=1 sa=0.265
+ sb=0.265 sd=0.28 area=0.063 perim=1.14
MMNA0 pndA A1 VGND VNB sky130_fd_pr__nfet_01v8 m=4 w=0.65u l=0.15u mult=1 sa=0.265
+ sb=0.265 sd=0.28 area=0.063 perim=1.14
MMNA1 pndA A2 VGND VNB sky130_fd_pr__nfet_01v8 m=4 w=0.65u l=0.15u mult=1 sa=0.265
+ sb=0.265 sd=0.28 area=0.063 perim=1.14
MMNB0 Y B1 pndA VNB sky130_fd_pr__nfet_01v8 m=4 w=0.65u l=0.15u mult=1 sa=0.265
+ sb=0.265 sd=0.28 area=0.063 perim=1.14
.ENDS sky130_fd_sc_hd__o21ai_4
* Copyright 2020 The SkyWater PDK Authors
*
* Licensed under the Apache License, Version 2.0 (the "License");
* you may not use this file except in compliance with the License.
* You may obtain a copy of the License at
*
*     https:  www.apache.org licenses LICENSE-2.0
*
* Unless required by applicable law or agreed to in writing, software
* distributed under the License is distributed on an "AS IS" BASIS,
* WITHOUT WARRANTIES OR CONDITIONS OF ANY KIND, either express or implied.
* See the License for the specific language governing permissions and
* limitations under the License.
*
* SPDX-License-Identifier: Apache-2.0

.SUBCKT sky130_fd_sc_hd__o21ba_1 A1 A2 B1_N VGND VNB VNB net59 X
*.PININFO A1:I A2:I B1_N:I VGND:I VNB:I VNB:I net59:I X:O
MMPA0 net59 A1 sndA1 VNB sky130_fd_pr__pfet_01v8_hvt m=1 w=1.0u l=0.15u mult=1 sa=0.265
+ sb=0.265 sd=0.28 area=0.063 perim=1.14
MMPA1 sndA1 A2 y VNB sky130_fd_pr__pfet_01v8_hvt m=1 w=1.0u l=0.15u mult=1 sa=0.265
+ sb=0.265 sd=0.28 area=0.063 perim=1.14
MMPB0 net59 B1 y VNB sky130_fd_pr__pfet_01v8_hvt m=1 w=1.0u l=0.15u mult=1 sa=0.265
+ sb=0.265 sd=0.28 area=0.063 perim=1.14
MMIPB1N B1 B1_N net59 VNB sky130_fd_pr__pfet_01v8_hvt m=1 w=0.42u l=0.15u mult=1
+ sa=0.265 sb=0.265 sd=0.28 area=0.063 perim=1.14
MMIPX X y net59 VNB sky130_fd_pr__pfet_01v8_hvt m=1 w=1.0u l=0.15u mult=1 sa=0.265
+ sb=0.265 sd=0.28 area=0.063 perim=1.14
MMNA0 pndA A1 VGND VNB sky130_fd_pr__nfet_01v8 m=1 w=0.65u l=0.15u mult=1 sa=0.265
+ sb=0.265 sd=0.28 area=0.063 perim=1.14
MMNA1 pndA A2 VGND VNB sky130_fd_pr__nfet_01v8 m=1 w=0.65u l=0.15u mult=1 sa=0.265
+ sb=0.265 sd=0.28 area=0.063 perim=1.14
MMNB0 y B1 pndA VNB sky130_fd_pr__nfet_01v8 m=1 w=0.65u l=0.15u mult=1 sa=0.265
+ sb=0.265 sd=0.28 area=0.063 perim=1.14
MMINB1N B1 B1_N VGND VNB sky130_fd_pr__nfet_01v8 m=1 w=0.42u l=0.15u mult=1 sa=0.265
+ sb=0.265 sd=0.28 area=0.063 perim=1.14
MMINX X y VGND VNB sky130_fd_pr__nfet_01v8 m=1 w=0.65u l=0.15u mult=1 sa=0.265
+ sb=0.265 sd=0.28 area=0.063 perim=1.14
.ENDS sky130_fd_sc_hd__o21ba_1
* Copyright 2020 The SkyWater PDK Authors
*
* Licensed under the Apache License, Version 2.0 (the "License");
* you may not use this file except in compliance with the License.
* You may obtain a copy of the License at
*
*     https:  www.apache.org licenses LICENSE-2.0
*
* Unless required by applicable law or agreed to in writing, software
* distributed under the License is distributed on an "AS IS" BASIS,
* WITHOUT WARRANTIES OR CONDITIONS OF ANY KIND, either express or implied.
* See the License for the specific language governing permissions and
* limitations under the License.
*
* SPDX-License-Identifier: Apache-2.0

.SUBCKT sky130_fd_sc_hd__o21ba_2 A1 A2 B1_N VGND VNB VNB net59 X
*.PININFO A1:I A2:I B1_N:I VGND:I VNB:I VNB:I net59:I X:O
MMPA0 net59 A1 sndA1 VNB sky130_fd_pr__pfet_01v8_hvt m=1 w=1.0u l=0.15u mult=1 sa=0.265
+ sb=0.265 sd=0.28 area=0.063 perim=1.14
MMPA1 sndA1 A2 y VNB sky130_fd_pr__pfet_01v8_hvt m=1 w=1.0u l=0.15u mult=1 sa=0.265
+ sb=0.265 sd=0.28 area=0.063 perim=1.14
MMPB0 net59 B1 y VNB sky130_fd_pr__pfet_01v8_hvt m=1 w=1.0u l=0.15u mult=1 sa=0.265
+ sb=0.265 sd=0.28 area=0.063 perim=1.14
MMIPB1N B1 B1_N net59 VNB sky130_fd_pr__pfet_01v8_hvt m=1 w=0.42u l=0.15u mult=1
+ sa=0.265 sb=0.265 sd=0.28 area=0.063 perim=1.14
MMIPX X y net59 VNB sky130_fd_pr__pfet_01v8_hvt m=2 w=1.0u l=0.15u mult=1 sa=0.265
+ sb=0.265 sd=0.28 area=0.063 perim=1.14
MMNA0 pndA A1 VGND VNB sky130_fd_pr__nfet_01v8 m=1 w=0.65u l=0.15u mult=1 sa=0.265
+ sb=0.265 sd=0.28 area=0.063 perim=1.14
MMNA1 pndA A2 VGND VNB sky130_fd_pr__nfet_01v8 m=1 w=0.65u l=0.15u mult=1 sa=0.265
+ sb=0.265 sd=0.28 area=0.063 perim=1.14
MMNB0 y B1 pndA VNB sky130_fd_pr__nfet_01v8 m=1 w=0.65u l=0.15u mult=1 sa=0.265
+ sb=0.265 sd=0.28 area=0.063 perim=1.14
MMINB1N B1 B1_N VGND VNB sky130_fd_pr__nfet_01v8 m=1 w=0.42u l=0.15u mult=1 sa=0.265
+ sb=0.265 sd=0.28 area=0.063 perim=1.14
MMINX X y VGND VNB sky130_fd_pr__nfet_01v8 m=2 w=0.65u l=0.15u mult=1 sa=0.265
+ sb=0.265 sd=0.28 area=0.063 perim=1.14
.ENDS sky130_fd_sc_hd__o21ba_2
* Copyright 2020 The SkyWater PDK Authors
*
* Licensed under the Apache License, Version 2.0 (the "License");
* you may not use this file except in compliance with the License.
* You may obtain a copy of the License at
*
*     https:  www.apache.org licenses LICENSE-2.0
*
* Unless required by applicable law or agreed to in writing, software
* distributed under the License is distributed on an "AS IS" BASIS,
* WITHOUT WARRANTIES OR CONDITIONS OF ANY KIND, either express or implied.
* See the License for the specific language governing permissions and
* limitations under the License.
*
* SPDX-License-Identifier: Apache-2.0

.SUBCKT sky130_fd_sc_hd__o21ba_4 A1 A2 B1_N VGND VNB VNB net59 X
*.PININFO A1:I A2:I B1_N:I VGND:I VNB:I VNB:I net59:I X:O
MMPA0 net59 A1 sndA1 VNB sky130_fd_pr__pfet_01v8_hvt m=2 w=1.0u l=0.15u mult=1 sa=0.265
+ sb=0.265 sd=0.28 area=0.063 perim=1.14
MMPA1 sndA1 A2 y VNB sky130_fd_pr__pfet_01v8_hvt m=2 w=1.0u l=0.15u mult=1 sa=0.265
+ sb=0.265 sd=0.28 area=0.063 perim=1.14
MMPB0 net59 B1 y VNB sky130_fd_pr__pfet_01v8_hvt m=2 w=1.0u l=0.15u mult=1 sa=0.265
+ sb=0.265 sd=0.28 area=0.063 perim=1.14
MMIPB1N B1 B1_N net59 VNB sky130_fd_pr__pfet_01v8_hvt m=1 w=1.0u l=0.15u mult=1
+ sa=0.265 sb=0.265 sd=0.28 area=0.063 perim=1.14
MMIPX X y net59 VNB sky130_fd_pr__pfet_01v8_hvt m=4 w=1.0u l=0.15u mult=1 sa=0.265
+ sb=0.265 sd=0.28 area=0.063 perim=1.14
MMNA0 pndA A1 VGND VNB sky130_fd_pr__nfet_01v8 m=2 w=0.65u l=0.15u mult=1 sa=0.265
+ sb=0.265 sd=0.28 area=0.063 perim=1.14
MMNA1 pndA A2 VGND VNB sky130_fd_pr__nfet_01v8 m=2 w=0.65u l=0.15u mult=1 sa=0.265
+ sb=0.265 sd=0.28 area=0.063 perim=1.14
MMNB0 y B1 pndA VNB sky130_fd_pr__nfet_01v8 m=2 w=0.65u l=0.15u mult=1 sa=0.265
+ sb=0.265 sd=0.28 area=0.063 perim=1.14
MMINB1N B1 B1_N VGND VNB sky130_fd_pr__nfet_01v8 m=1 w=0.65u l=0.15u mult=1 sa=0.265
+ sb=0.265 sd=0.28 area=0.063 perim=1.14
MMINX X y VGND VNB sky130_fd_pr__nfet_01v8 m=4 w=0.65u l=0.15u mult=1 sa=0.265
+ sb=0.265 sd=0.28 area=0.063 perim=1.14
.ENDS sky130_fd_sc_hd__o21ba_4
* Copyright 2020 The SkyWater PDK Authors
*
* Licensed under the Apache License, Version 2.0 (the "License");
* you may not use this file except in compliance with the License.
* You may obtain a copy of the License at
*
*     https:  www.apache.org licenses LICENSE-2.0
*
* Unless required by applicable law or agreed to in writing, software
* distributed under the License is distributed on an "AS IS" BASIS,
* WITHOUT WARRANTIES OR CONDITIONS OF ANY KIND, either express or implied.
* See the License for the specific language governing permissions and
* limitations under the License.
*
* SPDX-License-Identifier: Apache-2.0

.SUBCKT sky130_fd_sc_hd__o21bai_1 A1 A2 B1_N VGND VNB VNB net59 Y
*.PININFO A1:I A2:I B1_N:I VGND:I VNB:I VNB:I net59:I Y:O
MMPA0 net59 A1 sndA1 VNB sky130_fd_pr__pfet_01v8_hvt m=1 w=1.0u l=0.15u mult=1 sa=0.265
+ sb=0.265 sd=0.28 area=0.063 perim=1.14
MMPA1 sndA1 A2 Y VNB sky130_fd_pr__pfet_01v8_hvt m=1 w=1.0u l=0.15u mult=1 sa=0.265
+ sb=0.265 sd=0.28 area=0.063 perim=1.14
MMPB0 net59 B1 Y VNB sky130_fd_pr__pfet_01v8_hvt m=1 w=1.0u l=0.15u mult=1 sa=0.265
+ sb=0.265 sd=0.28 area=0.063 perim=1.14
MMIPB1N B1 B1_N net59 VNB sky130_fd_pr__pfet_01v8_hvt m=1 w=0.42u l=0.15u mult=1
+ sa=0.265 sb=0.265 sd=0.28 area=0.063 perim=1.14
MMNA0 pndA A1 VGND VNB sky130_fd_pr__nfet_01v8 m=1 w=0.65u l=0.15u mult=1 sa=0.265
+ sb=0.265 sd=0.28 area=0.063 perim=1.14
MMNA1 pndA A2 VGND VNB sky130_fd_pr__nfet_01v8 m=1 w=0.65u l=0.15u mult=1 sa=0.265
+ sb=0.265 sd=0.28 area=0.063 perim=1.14
MMNB0 Y B1 pndA VNB sky130_fd_pr__nfet_01v8 m=1 w=0.65u l=0.15u mult=1 sa=0.265
+ sb=0.265 sd=0.28 area=0.063 perim=1.14
MMINB1N B1 B1_N VGND VNB sky130_fd_pr__nfet_01v8 m=1 w=0.42u l=0.15u mult=1 sa=0.265
+ sb=0.265 sd=0.28 area=0.063 perim=1.14
.ENDS sky130_fd_sc_hd__o21bai_1
* Copyright 2020 The SkyWater PDK Authors
*
* Licensed under the Apache License, Version 2.0 (the "License");
* you may not use this file except in compliance with the License.
* You may obtain a copy of the License at
*
*     https:  www.apache.org licenses LICENSE-2.0
*
* Unless required by applicable law or agreed to in writing, software
* distributed under the License is distributed on an "AS IS" BASIS,
* WITHOUT WARRANTIES OR CONDITIONS OF ANY KIND, either express or implied.
* See the License for the specific language governing permissions and
* limitations under the License.
*
* SPDX-License-Identifier: Apache-2.0

.SUBCKT sky130_fd_sc_hd__o21bai_2 A1 A2 B1_N VGND VNB VNB net59 Y
*.PININFO A1:I A2:I B1_N:I VGND:I VNB:I VNB:I net59:I Y:O
MMPA0 net59 A1 sndA1 VNB sky130_fd_pr__pfet_01v8_hvt m=2 w=1.0u l=0.15u mult=1 sa=0.265
+ sb=0.265 sd=0.28 area=0.063 perim=1.14
MMPA1 sndA1 A2 Y VNB sky130_fd_pr__pfet_01v8_hvt m=2 w=1.0u l=0.15u mult=1 sa=0.265
+ sb=0.265 sd=0.28 area=0.063 perim=1.14
MMPB0 net59 B1 Y VNB sky130_fd_pr__pfet_01v8_hvt m=2 w=1.0u l=0.15u mult=1 sa=0.265
+ sb=0.265 sd=0.28 area=0.063 perim=1.14
MMIPB1N B1 B1_N net59 VNB sky130_fd_pr__pfet_01v8_hvt m=1 w=0.42u l=0.15u mult=1
+ sa=0.265 sb=0.265 sd=0.28 area=0.063 perim=1.14
MMNA0 pndA A1 VGND VNB sky130_fd_pr__nfet_01v8 m=2 w=0.65u l=0.15u mult=1 sa=0.265
+ sb=0.265 sd=0.28 area=0.063 perim=1.14
MMNA1 pndA A2 VGND VNB sky130_fd_pr__nfet_01v8 m=2 w=0.65u l=0.15u mult=1 sa=0.265
+ sb=0.265 sd=0.28 area=0.063 perim=1.14
MMNB0 Y B1 pndA VNB sky130_fd_pr__nfet_01v8 m=2 w=0.65u l=0.15u mult=1 sa=0.265
+ sb=0.265 sd=0.28 area=0.063 perim=1.14
MMINB1N B1 B1_N VGND VNB sky130_fd_pr__nfet_01v8 m=1 w=0.42u l=0.15u mult=1 sa=0.265
+ sb=0.265 sd=0.28 area=0.063 perim=1.14
.ENDS sky130_fd_sc_hd__o21bai_2
* Copyright 2020 The SkyWater PDK Authors
*
* Licensed under the Apache License, Version 2.0 (the "License");
* you may not use this file except in compliance with the License.
* You may obtain a copy of the License at
*
*     https:  www.apache.org licenses LICENSE-2.0
*
* Unless required by applicable law or agreed to in writing, software
* distributed under the License is distributed on an "AS IS" BASIS,
* WITHOUT WARRANTIES OR CONDITIONS OF ANY KIND, either express or implied.
* See the License for the specific language governing permissions and
* limitations under the License.
*
* SPDX-License-Identifier: Apache-2.0

.SUBCKT sky130_fd_sc_hd__o21bai_4 A1 A2 B1_N VGND VNB VNB net59 Y
*.PININFO A1:I A2:I B1_N:I VGND:I VNB:I VNB:I net59:I Y:O
MMPA0 net59 A1 sndA1 VNB sky130_fd_pr__pfet_01v8_hvt m=4 w=1.0u l=0.15u mult=1 sa=0.265
+ sb=0.265 sd=0.28 area=0.063 perim=1.14
MMPA1 sndA1 A2 Y VNB sky130_fd_pr__pfet_01v8_hvt m=4 w=1.0u l=0.15u mult=1 sa=0.265
+ sb=0.265 sd=0.28 area=0.063 perim=1.14
MMPB0 net59 B1 Y VNB sky130_fd_pr__pfet_01v8_hvt m=4 w=1.0u l=0.15u mult=1 sa=0.265
+ sb=0.265 sd=0.28 area=0.063 perim=1.14
MMIPB1N B1 B1_N net59 VNB sky130_fd_pr__pfet_01v8_hvt m=1 w=1.0u l=0.15u mult=1
+ sa=0.265 sb=0.265 sd=0.28 area=0.063 perim=1.14
MMNA0 pndA A1 VGND VNB sky130_fd_pr__nfet_01v8 m=4 w=0.65u l=0.15u mult=1 sa=0.265
+ sb=0.265 sd=0.28 area=0.063 perim=1.14
MMNA1 pndA A2 VGND VNB sky130_fd_pr__nfet_01v8 m=4 w=0.65u l=0.15u mult=1 sa=0.265
+ sb=0.265 sd=0.28 area=0.063 perim=1.14
MMNB0 Y B1 pndA VNB sky130_fd_pr__nfet_01v8 m=4 w=0.65u l=0.15u mult=1 sa=0.265
+ sb=0.265 sd=0.28 area=0.063 perim=1.14
MMINB1N B1 B1_N VGND VNB sky130_fd_pr__nfet_01v8 m=1 w=0.65u l=0.15u mult=1 sa=0.265
+ sb=0.265 sd=0.28 area=0.063 perim=1.14
.ENDS sky130_fd_sc_hd__o21bai_4
* Copyright 2020 The SkyWater PDK Authors
*
* Licensed under the Apache License, Version 2.0 (the "License");
* you may not use this file except in compliance with the License.
* You may obtain a copy of the License at
*
*     https:  www.apache.org licenses LICENSE-2.0
*
* Unless required by applicable law or agreed to in writing, software
* distributed under the License is distributed on an "AS IS" BASIS,
* WITHOUT WARRANTIES OR CONDITIONS OF ANY KIND, either express or implied.
* See the License for the specific language governing permissions and
* limitations under the License.
*
* SPDX-License-Identifier: Apache-2.0

.SUBCKT sky130_fd_sc_hd__o221a_1 A1 A2 B1 B2 C1 VGND VNB VNB net59 X
*.PININFO A1:I A2:I B1:I B2:I C1:I VGND:I VNB:I VNB:I net59:I X:O
MMPA0 net59 A1 sndA1 VNB sky130_fd_pr__pfet_01v8_hvt m=1 w=1.0u l=0.15u mult=1 sa=0.265
+ sb=0.265 sd=0.28 area=0.063 perim=1.14
MMPA1 sndA1 A2 y VNB sky130_fd_pr__pfet_01v8_hvt m=1 w=1.0u l=0.15u mult=1 sa=0.265
+ sb=0.265 sd=0.28 area=0.063 perim=1.14
MMPB0 net59 B1 sndB1 VNB sky130_fd_pr__pfet_01v8_hvt m=1 w=1.0u l=0.15u mult=1 sa=0.265
+ sb=0.265 sd=0.28 area=0.063 perim=1.14
MMPB1 sndB1 B2 y VNB sky130_fd_pr__pfet_01v8_hvt m=1 w=1.0u l=0.15u mult=1 sa=0.265
+ sb=0.265 sd=0.28 area=0.063 perim=1.14
MMPC0 net59 C1 y VNB sky130_fd_pr__pfet_01v8_hvt m=1 w=1.0u l=0.15u mult=1 sa=0.265
+ sb=0.265 sd=0.28 area=0.063 perim=1.14
MMIPX X y net59 VNB sky130_fd_pr__pfet_01v8_hvt m=1 w=1.0u l=0.15u mult=1 sa=0.265
+ sb=0.265 sd=0.28 area=0.063 perim=1.14
MMNA0 pndA A1 VGND VNB sky130_fd_pr__nfet_01v8 m=1 w=0.65u l=0.15u mult=1 sa=0.265
+ sb=0.265 sd=0.28 area=0.063 perim=1.14
MMNA1 pndA A2 VGND VNB sky130_fd_pr__nfet_01v8 m=1 w=0.65u l=0.15u mult=1 sa=0.265
+ sb=0.265 sd=0.28 area=0.063 perim=1.14
MMNB0 pndB B1 pndA VNB sky130_fd_pr__nfet_01v8 m=1 w=0.65u l=0.15u mult=1 sa=0.265
+ sb=0.265 sd=0.28 area=0.063 perim=1.14
MMNB1 pndB B2 pndA VNB sky130_fd_pr__nfet_01v8 m=1 w=0.65u l=0.15u mult=1 sa=0.265
+ sb=0.265 sd=0.28 area=0.063 perim=1.14
MMNC0 y C1 pndB VNB sky130_fd_pr__nfet_01v8 m=1 w=0.65u l=0.15u mult=1 sa=0.265
+ sb=0.265 sd=0.28 area=0.063 perim=1.14
MMINX X y VGND VNB sky130_fd_pr__nfet_01v8 m=1 w=0.65u l=0.15u mult=1 sa=0.265
+ sb=0.265 sd=0.28 area=0.063 perim=1.14
.ENDS sky130_fd_sc_hd__o221a_1
* Copyright 2020 The SkyWater PDK Authors
*
* Licensed under the Apache License, Version 2.0 (the "License");
* you may not use this file except in compliance with the License.
* You may obtain a copy of the License at
*
*     https:  www.apache.org licenses LICENSE-2.0
*
* Unless required by applicable law or agreed to in writing, software
* distributed under the License is distributed on an "AS IS" BASIS,
* WITHOUT WARRANTIES OR CONDITIONS OF ANY KIND, either express or implied.
* See the License for the specific language governing permissions and
* limitations under the License.
*
* SPDX-License-Identifier: Apache-2.0

.SUBCKT sky130_fd_sc_hd__o221a_2 A1 A2 B1 B2 C1 VGND VNB VNB net59 X
*.PININFO A1:I A2:I B1:I B2:I C1:I VGND:I VNB:I VNB:I net59:I X:O
MMPA0 net59 A1 sndA1 VNB sky130_fd_pr__pfet_01v8_hvt m=1 w=1.0u l=0.15u mult=1 sa=0.265
+ sb=0.265 sd=0.28 area=0.063 perim=1.14
MMPA1 sndA1 A2 y VNB sky130_fd_pr__pfet_01v8_hvt m=1 w=1.0u l=0.15u mult=1 sa=0.265
+ sb=0.265 sd=0.28 area=0.063 perim=1.14
MMPB0 net59 B1 sndB1 VNB sky130_fd_pr__pfet_01v8_hvt m=1 w=1.0u l=0.15u mult=1 sa=0.265
+ sb=0.265 sd=0.28 area=0.063 perim=1.14
MMPB1 sndB1 B2 y VNB sky130_fd_pr__pfet_01v8_hvt m=1 w=1.0u l=0.15u mult=1 sa=0.265
+ sb=0.265 sd=0.28 area=0.063 perim=1.14
MMPC0 net59 C1 y VNB sky130_fd_pr__pfet_01v8_hvt m=1 w=1.0u l=0.15u mult=1 sa=0.265
+ sb=0.265 sd=0.28 area=0.063 perim=1.14
MMIPX X y net59 VNB sky130_fd_pr__pfet_01v8_hvt m=2 w=1.0u l=0.15u mult=1 sa=0.265
+ sb=0.265 sd=0.28 area=0.063 perim=1.14
MMNA0 pndA A1 VGND VNB sky130_fd_pr__nfet_01v8 m=1 w=0.65u l=0.15u mult=1 sa=0.265
+ sb=0.265 sd=0.28 area=0.063 perim=1.14
MMNA1 pndA A2 VGND VNB sky130_fd_pr__nfet_01v8 m=1 w=0.65u l=0.15u mult=1 sa=0.265
+ sb=0.265 sd=0.28 area=0.063 perim=1.14
MMNB0 pndB B1 pndA VNB sky130_fd_pr__nfet_01v8 m=1 w=0.65u l=0.15u mult=1 sa=0.265
+ sb=0.265 sd=0.28 area=0.063 perim=1.14
MMNB1 pndB B2 pndA VNB sky130_fd_pr__nfet_01v8 m=1 w=0.65u l=0.15u mult=1 sa=0.265
+ sb=0.265 sd=0.28 area=0.063 perim=1.14
MMNC0 y C1 pndB VNB sky130_fd_pr__nfet_01v8 m=1 w=0.65u l=0.15u mult=1 sa=0.265
+ sb=0.265 sd=0.28 area=0.063 perim=1.14
MMINX X y VGND VNB sky130_fd_pr__nfet_01v8 m=2 w=0.65u l=0.15u mult=1 sa=0.265
+ sb=0.265 sd=0.28 area=0.063 perim=1.14
.ENDS sky130_fd_sc_hd__o221a_2
* Copyright 2020 The SkyWater PDK Authors
*
* Licensed under the Apache License, Version 2.0 (the "License");
* you may not use this file except in compliance with the License.
* You may obtain a copy of the License at
*
*     https:  www.apache.org licenses LICENSE-2.0
*
* Unless required by applicable law or agreed to in writing, software
* distributed under the License is distributed on an "AS IS" BASIS,
* WITHOUT WARRANTIES OR CONDITIONS OF ANY KIND, either express or implied.
* See the License for the specific language governing permissions and
* limitations under the License.
*
* SPDX-License-Identifier: Apache-2.0

.SUBCKT sky130_fd_sc_hd__o221a_4 A1 A2 B1 B2 C1 VGND VNB VNB net59 X
*.PININFO A1:I A2:I B1:I B2:I C1:I VGND:I VNB:I VNB:I net59:I X:O
MMPA0 net59 A1 sndA1 VNB sky130_fd_pr__pfet_01v8_hvt m=2 w=1.0u l=0.15u mult=1 sa=0.265
+ sb=0.265 sd=0.28 area=0.063 perim=1.14
MMPA1 sndA1 A2 y VNB sky130_fd_pr__pfet_01v8_hvt m=2 w=1.0u l=0.15u mult=1 sa=0.265
+ sb=0.265 sd=0.28 area=0.063 perim=1.14
MMPB0 net59 B1 sndB1 VNB sky130_fd_pr__pfet_01v8_hvt m=2 w=1.0u l=0.15u mult=1 sa=0.265
+ sb=0.265 sd=0.28 area=0.063 perim=1.14
MMPB1 sndB1 B2 y VNB sky130_fd_pr__pfet_01v8_hvt m=2 w=1.0u l=0.15u mult=1 sa=0.265
+ sb=0.265 sd=0.28 area=0.063 perim=1.14
MMPC0 net59 C1 y VNB sky130_fd_pr__pfet_01v8_hvt m=2 w=1.0u l=0.15u mult=1 sa=0.265
+ sb=0.265 sd=0.28 area=0.063 perim=1.14
MMIPX X y net59 VNB sky130_fd_pr__pfet_01v8_hvt m=4 w=1.0u l=0.15u mult=1 sa=0.265
+ sb=0.265 sd=0.28 area=0.063 perim=1.14
MMNA0 pndA A1 VGND VNB sky130_fd_pr__nfet_01v8 m=2 w=0.65u l=0.15u mult=1 sa=0.265
+ sb=0.265 sd=0.28 area=0.063 perim=1.14
MMNA1 pndA A2 VGND VNB sky130_fd_pr__nfet_01v8 m=2 w=0.65u l=0.15u mult=1 sa=0.265
+ sb=0.265 sd=0.28 area=0.063 perim=1.14
MMNB0 pndB B1 pndA VNB sky130_fd_pr__nfet_01v8 m=2 w=0.65u l=0.15u mult=1 sa=0.265
+ sb=0.265 sd=0.28 area=0.063 perim=1.14
MMNB1 pndB B2 pndA VNB sky130_fd_pr__nfet_01v8 m=2 w=0.65u l=0.15u mult=1 sa=0.265
+ sb=0.265 sd=0.28 area=0.063 perim=1.14
MMNC0 y C1 pndB VNB sky130_fd_pr__nfet_01v8 m=2 w=0.65u l=0.15u mult=1 sa=0.265
+ sb=0.265 sd=0.28 area=0.063 perim=1.14
MMINX X y VGND VNB sky130_fd_pr__nfet_01v8 m=4 w=0.65u l=0.15u mult=1 sa=0.265
+ sb=0.265 sd=0.28 area=0.063 perim=1.14
.ENDS sky130_fd_sc_hd__o221a_4
* Copyright 2020 The SkyWater PDK Authors
*
* Licensed under the Apache License, Version 2.0 (the "License");
* you may not use this file except in compliance with the License.
* You may obtain a copy of the License at
*
*     https:  www.apache.org licenses LICENSE-2.0
*
* Unless required by applicable law or agreed to in writing, software
* distributed under the License is distributed on an "AS IS" BASIS,
* WITHOUT WARRANTIES OR CONDITIONS OF ANY KIND, either express or implied.
* See the License for the specific language governing permissions and
* limitations under the License.
*
* SPDX-License-Identifier: Apache-2.0

.SUBCKT sky130_fd_sc_hd__o221ai_1 A1 A2 B1 B2 C1 VGND VNB VNB net59 Y
*.PININFO A1:I A2:I B1:I B2:I C1:I VGND:I VNB:I VNB:I net59:I Y:O
MMPA0 net59 A1 sndA1 VNB sky130_fd_pr__pfet_01v8_hvt m=1 w=1.0u l=0.15u mult=1 sa=0.265
+ sb=0.265 sd=0.28 area=0.063 perim=1.14
MMPA1 sndA1 A2 Y VNB sky130_fd_pr__pfet_01v8_hvt m=1 w=1.0u l=0.15u mult=1 sa=0.265
+ sb=0.265 sd=0.28 area=0.063 perim=1.14
MMPB0 net59 B1 sndB1 VNB sky130_fd_pr__pfet_01v8_hvt m=1 w=1.0u l=0.15u mult=1 sa=0.265
+ sb=0.265 sd=0.28 area=0.063 perim=1.14
MMPB1 sndB1 B2 Y VNB sky130_fd_pr__pfet_01v8_hvt m=1 w=1.0u l=0.15u mult=1 sa=0.265
+ sb=0.265 sd=0.28 area=0.063 perim=1.14
MMPC0 net59 C1 Y VNB sky130_fd_pr__pfet_01v8_hvt m=1 w=1.0u l=0.15u mult=1 sa=0.265
+ sb=0.265 sd=0.28 area=0.063 perim=1.14
MMNA0 pndA A1 VGND VNB sky130_fd_pr__nfet_01v8 m=1 w=0.65u l=0.15u mult=1 sa=0.265
+ sb=0.265 sd=0.28 area=0.063 perim=1.14
MMNA1 pndA A2 VGND VNB sky130_fd_pr__nfet_01v8 m=1 w=0.65u l=0.15u mult=1 sa=0.265
+ sb=0.265 sd=0.28 area=0.063 perim=1.14
MMNB0 pndB B1 pndA VNB sky130_fd_pr__nfet_01v8 m=1 w=0.65u l=0.15u mult=1 sa=0.265
+ sb=0.265 sd=0.28 area=0.063 perim=1.14
MMNB1 pndB B2 pndA VNB sky130_fd_pr__nfet_01v8 m=1 w=0.65u l=0.15u mult=1 sa=0.265
+ sb=0.265 sd=0.28 area=0.063 perim=1.14
MMNC0 Y C1 pndB VNB sky130_fd_pr__nfet_01v8 m=1 w=0.65u l=0.15u mult=1 sa=0.265
+ sb=0.265 sd=0.28 area=0.063 perim=1.14
.ENDS sky130_fd_sc_hd__o221ai_1
* Copyright 2020 The SkyWater PDK Authors
*
* Licensed under the Apache License, Version 2.0 (the "License");
* you may not use this file except in compliance with the License.
* You may obtain a copy of the License at
*
*     https:  www.apache.org licenses LICENSE-2.0
*
* Unless required by applicable law or agreed to in writing, software
* distributed under the License is distributed on an "AS IS" BASIS,
* WITHOUT WARRANTIES OR CONDITIONS OF ANY KIND, either express or implied.
* See the License for the specific language governing permissions and
* limitations under the License.
*
* SPDX-License-Identifier: Apache-2.0

.SUBCKT sky130_fd_sc_hd__o221ai_2 A1 A2 B1 B2 C1 VGND VNB VNB net59 Y
*.PININFO A1:I A2:I B1:I B2:I C1:I VGND:I VNB:I VNB:I net59:I Y:O
MMPA0 net59 A1 sndA1 VNB sky130_fd_pr__pfet_01v8_hvt m=2 w=1.0u l=0.15u mult=1 sa=0.265
+ sb=0.265 sd=0.28 area=0.063 perim=1.14
MMPA1 sndA1 A2 Y VNB sky130_fd_pr__pfet_01v8_hvt m=2 w=1.0u l=0.15u mult=1 sa=0.265
+ sb=0.265 sd=0.28 area=0.063 perim=1.14
MMPB0 net59 B1 sndB1 VNB sky130_fd_pr__pfet_01v8_hvt m=2 w=1.0u l=0.15u mult=1 sa=0.265
+ sb=0.265 sd=0.28 area=0.063 perim=1.14
MMPB1 sndB1 B2 Y VNB sky130_fd_pr__pfet_01v8_hvt m=2 w=1.0u l=0.15u mult=1 sa=0.265
+ sb=0.265 sd=0.28 area=0.063 perim=1.14
MMPC0 net59 C1 Y VNB sky130_fd_pr__pfet_01v8_hvt m=2 w=1.0u l=0.15u mult=1 sa=0.265
+ sb=0.265 sd=0.28 area=0.063 perim=1.14
MMNA0 pndA A1 VGND VNB sky130_fd_pr__nfet_01v8 m=2 w=0.65u l=0.15u mult=1 sa=0.265
+ sb=0.265 sd=0.28 area=0.063 perim=1.14
MMNA1 pndA A2 VGND VNB sky130_fd_pr__nfet_01v8 m=2 w=0.65u l=0.15u mult=1 sa=0.265
+ sb=0.265 sd=0.28 area=0.063 perim=1.14
MMNB0 pndB B1 pndA VNB sky130_fd_pr__nfet_01v8 m=2 w=0.65u l=0.15u mult=1 sa=0.265
+ sb=0.265 sd=0.28 area=0.063 perim=1.14
MMNB1 pndB B2 pndA VNB sky130_fd_pr__nfet_01v8 m=2 w=0.65u l=0.15u mult=1 sa=0.265
+ sb=0.265 sd=0.28 area=0.063 perim=1.14
MMNC0 Y C1 pndB VNB sky130_fd_pr__nfet_01v8 m=2 w=0.65u l=0.15u mult=1 sa=0.265
+ sb=0.265 sd=0.28 area=0.063 perim=1.14
.ENDS sky130_fd_sc_hd__o221ai_2
* Copyright 2020 The SkyWater PDK Authors
*
* Licensed under the Apache License, Version 2.0 (the "License");
* you may not use this file except in compliance with the License.
* You may obtain a copy of the License at
*
*     https:  www.apache.org licenses LICENSE-2.0
*
* Unless required by applicable law or agreed to in writing, software
* distributed under the License is distributed on an "AS IS" BASIS,
* WITHOUT WARRANTIES OR CONDITIONS OF ANY KIND, either express or implied.
* See the License for the specific language governing permissions and
* limitations under the License.
*
* SPDX-License-Identifier: Apache-2.0

.SUBCKT sky130_fd_sc_hd__o221ai_4 A1 A2 B1 B2 C1 VGND VNB VNB net59 Y
*.PININFO A1:I A2:I B1:I B2:I C1:I VGND:I VNB:I VNB:I net59:I Y:O
MMPA0 net59 A1 sndA1 VNB sky130_fd_pr__pfet_01v8_hvt m=4 w=1.0u l=0.15u mult=1 sa=0.265
+ sb=0.265 sd=0.28 area=0.063 perim=1.14
MMPA1 sndA1 A2 Y VNB sky130_fd_pr__pfet_01v8_hvt m=4 w=1.0u l=0.15u mult=1 sa=0.265
+ sb=0.265 sd=0.28 area=0.063 perim=1.14
MMPB0 net59 B1 sndB1 VNB sky130_fd_pr__pfet_01v8_hvt m=4 w=1.0u l=0.15u mult=1 sa=0.265
+ sb=0.265 sd=0.28 area=0.063 perim=1.14
MMPB1 sndB1 B2 Y VNB sky130_fd_pr__pfet_01v8_hvt m=4 w=1.0u l=0.15u mult=1 sa=0.265
+ sb=0.265 sd=0.28 area=0.063 perim=1.14
MMPC0 net59 C1 Y VNB sky130_fd_pr__pfet_01v8_hvt m=4 w=1.0u l=0.15u mult=1 sa=0.265
+ sb=0.265 sd=0.28 area=0.063 perim=1.14
MMNA0 pndA A1 VGND VNB sky130_fd_pr__nfet_01v8 m=4 w=0.65u l=0.15u mult=1 sa=0.265
+ sb=0.265 sd=0.28 area=0.063 perim=1.14
MMNA1 pndA A2 VGND VNB sky130_fd_pr__nfet_01v8 m=4 w=0.65u l=0.15u mult=1 sa=0.265
+ sb=0.265 sd=0.28 area=0.063 perim=1.14
MMNB0 pndB B1 pndA VNB sky130_fd_pr__nfet_01v8 m=4 w=0.65u l=0.15u mult=1 sa=0.265
+ sb=0.265 sd=0.28 area=0.063 perim=1.14
MMNB1 pndB B2 pndA VNB sky130_fd_pr__nfet_01v8 m=4 w=0.65u l=0.15u mult=1 sa=0.265
+ sb=0.265 sd=0.28 area=0.063 perim=1.14
MMNC0 Y C1 pndB VNB sky130_fd_pr__nfet_01v8 m=4 w=0.65u l=0.15u mult=1 sa=0.265
+ sb=0.265 sd=0.28 area=0.063 perim=1.14
.ENDS sky130_fd_sc_hd__o221ai_4
* Copyright 2020 The SkyWater PDK Authors
*
* Licensed under the Apache License, Version 2.0 (the "License");
* you may not use this file except in compliance with the License.
* You may obtain a copy of the License at
*
*     https:  www.apache.org licenses LICENSE-2.0
*
* Unless required by applicable law or agreed to in writing, software
* distributed under the License is distributed on an "AS IS" BASIS,
* WITHOUT WARRANTIES OR CONDITIONS OF ANY KIND, either express or implied.
* See the License for the specific language governing permissions and
* limitations under the License.
*
* SPDX-License-Identifier: Apache-2.0

.SUBCKT sky130_fd_sc_hd__o22a_1 A1 A2 B1 B2 VGND VNB VNB net59 X
*.PININFO A1:I A2:I B1:I B2:I VGND:I VNB:I VNB:I net59:I X:O
MMPA0 net59 A1 sndA1 VNB sky130_fd_pr__pfet_01v8_hvt m=1 w=1.0u l=0.15u mult=1 sa=0.265
+ sb=0.265 sd=0.28 area=0.063 perim=1.14
MMPA1 sndA1 A2 y VNB sky130_fd_pr__pfet_01v8_hvt m=1 w=1.0u l=0.15u mult=1 sa=0.265
+ sb=0.265 sd=0.28 area=0.063 perim=1.14
MMPB0 net59 B1 sndB1 VNB sky130_fd_pr__pfet_01v8_hvt m=1 w=1.0u l=0.15u mult=1 sa=0.265
+ sb=0.265 sd=0.28 area=0.063 perim=1.14
MMPB1 sndB1 B2 y VNB sky130_fd_pr__pfet_01v8_hvt m=1 w=1.0u l=0.15u mult=1 sa=0.265
+ sb=0.265 sd=0.28 area=0.063 perim=1.14
MMIPX X y net59 VNB sky130_fd_pr__pfet_01v8_hvt m=1 w=1.0u l=0.15u mult=1 sa=0.265
+ sb=0.265 sd=0.28 area=0.063 perim=1.14
MMNA0 pndA A1 VGND VNB sky130_fd_pr__nfet_01v8 m=1 w=0.65u l=0.15u mult=1 sa=0.265
+ sb=0.265 sd=0.28 area=0.063 perim=1.14
MMNA1 pndA A2 VGND VNB sky130_fd_pr__nfet_01v8 m=1 w=0.65u l=0.15u mult=1 sa=0.265
+ sb=0.265 sd=0.28 area=0.063 perim=1.14
MMNB0 y B1 pndA VNB sky130_fd_pr__nfet_01v8 m=1 w=0.65u l=0.15u mult=1 sa=0.265
+ sb=0.265 sd=0.28 area=0.063 perim=1.14
MMNB1 y B2 pndA VNB sky130_fd_pr__nfet_01v8 m=1 w=0.65u l=0.15u mult=1 sa=0.265
+ sb=0.265 sd=0.28 area=0.063 perim=1.14
MMINX X y VGND VNB sky130_fd_pr__nfet_01v8 m=1 w=0.65u l=0.15u mult=1 sa=0.265
+ sb=0.265 sd=0.28 area=0.063 perim=1.14
.ENDS sky130_fd_sc_hd__o22a_1
* Copyright 2020 The SkyWater PDK Authors
*
* Licensed under the Apache License, Version 2.0 (the "License");
* you may not use this file except in compliance with the License.
* You may obtain a copy of the License at
*
*     https:  www.apache.org licenses LICENSE-2.0
*
* Unless required by applicable law or agreed to in writing, software
* distributed under the License is distributed on an "AS IS" BASIS,
* WITHOUT WARRANTIES OR CONDITIONS OF ANY KIND, either express or implied.
* See the License for the specific language governing permissions and
* limitations under the License.
*
* SPDX-License-Identifier: Apache-2.0

.SUBCKT sky130_fd_sc_hd__o22a_2 A1 A2 B1 B2 VGND VNB VNB net59 X
*.PININFO A1:I A2:I B1:I B2:I VGND:I VNB:I VNB:I net59:I X:O
MMPA0 net59 A1 sndA1 VNB sky130_fd_pr__pfet_01v8_hvt m=1 w=1.0u l=0.15u mult=1 sa=0.265
+ sb=0.265 sd=0.28 area=0.063 perim=1.14
MMPA1 sndA1 A2 y VNB sky130_fd_pr__pfet_01v8_hvt m=1 w=1.0u l=0.15u mult=1 sa=0.265
+ sb=0.265 sd=0.28 area=0.063 perim=1.14
MMPB0 net59 B1 sndB1 VNB sky130_fd_pr__pfet_01v8_hvt m=1 w=1.0u l=0.15u mult=1 sa=0.265
+ sb=0.265 sd=0.28 area=0.063 perim=1.14
MMPB1 sndB1 B2 y VNB sky130_fd_pr__pfet_01v8_hvt m=1 w=1.0u l=0.15u mult=1 sa=0.265
+ sb=0.265 sd=0.28 area=0.063 perim=1.14
MMIPX X y net59 VNB sky130_fd_pr__pfet_01v8_hvt m=2 w=1.0u l=0.15u mult=1 sa=0.265
+ sb=0.265 sd=0.28 area=0.063 perim=1.14
MMNA0 pndA A1 VGND VNB sky130_fd_pr__nfet_01v8 m=1 w=0.65u l=0.15u mult=1 sa=0.265
+ sb=0.265 sd=0.28 area=0.063 perim=1.14
MMNA1 pndA A2 VGND VNB sky130_fd_pr__nfet_01v8 m=1 w=0.65u l=0.15u mult=1 sa=0.265
+ sb=0.265 sd=0.28 area=0.063 perim=1.14
MMNB0 y B1 pndA VNB sky130_fd_pr__nfet_01v8 m=1 w=0.65u l=0.15u mult=1 sa=0.265
+ sb=0.265 sd=0.28 area=0.063 perim=1.14
MMNB1 y B2 pndA VNB sky130_fd_pr__nfet_01v8 m=1 w=0.65u l=0.15u mult=1 sa=0.265
+ sb=0.265 sd=0.28 area=0.063 perim=1.14
MMINX X y VGND VNB sky130_fd_pr__nfet_01v8 m=2 w=0.65u l=0.15u mult=1 sa=0.265
+ sb=0.265 sd=0.28 area=0.063 perim=1.14
.ENDS sky130_fd_sc_hd__o22a_2
* Copyright 2020 The SkyWater PDK Authors
*
* Licensed under the Apache License, Version 2.0 (the "License");
* you may not use this file except in compliance with the License.
* You may obtain a copy of the License at
*
*     https:  www.apache.org licenses LICENSE-2.0
*
* Unless required by applicable law or agreed to in writing, software
* distributed under the License is distributed on an "AS IS" BASIS,
* WITHOUT WARRANTIES OR CONDITIONS OF ANY KIND, either express or implied.
* See the License for the specific language governing permissions and
* limitations under the License.
*
* SPDX-License-Identifier: Apache-2.0

.SUBCKT sky130_fd_sc_hd__o22a_4 A1 A2 B1 B2 VGND VNB VNB net59 X
*.PININFO A1:I A2:I B1:I B2:I VGND:I VNB:I VNB:I net59:I X:O
MMPA0 net59 A1 sndA1 VNB sky130_fd_pr__pfet_01v8_hvt m=2 w=1.0u l=0.15u mult=1 sa=0.265
+ sb=0.265 sd=0.28 area=0.063 perim=1.14
MMPA1 sndA1 A2 y VNB sky130_fd_pr__pfet_01v8_hvt m=2 w=1.0u l=0.15u mult=1 sa=0.265
+ sb=0.265 sd=0.28 area=0.063 perim=1.14
MMPB0 net59 B1 sndB1 VNB sky130_fd_pr__pfet_01v8_hvt m=2 w=1.0u l=0.15u mult=1 sa=0.265
+ sb=0.265 sd=0.28 area=0.063 perim=1.14
MMPB1 sndB1 B2 y VNB sky130_fd_pr__pfet_01v8_hvt m=2 w=1.0u l=0.15u mult=1 sa=0.265
+ sb=0.265 sd=0.28 area=0.063 perim=1.14
MMIPX X y net59 VNB sky130_fd_pr__pfet_01v8_hvt m=4 w=1.0u l=0.15u mult=1 sa=0.265
+ sb=0.265 sd=0.28 area=0.063 perim=1.14
MMNA0 pndA A1 VGND VNB sky130_fd_pr__nfet_01v8 m=2 w=0.65u l=0.15u mult=1 sa=0.265
+ sb=0.265 sd=0.28 area=0.063 perim=1.14
MMNA1 pndA A2 VGND VNB sky130_fd_pr__nfet_01v8 m=2 w=0.65u l=0.15u mult=1 sa=0.265
+ sb=0.265 sd=0.28 area=0.063 perim=1.14
MMNB0 y B1 pndA VNB sky130_fd_pr__nfet_01v8 m=2 w=0.65u l=0.15u mult=1 sa=0.265
+ sb=0.265 sd=0.28 area=0.063 perim=1.14
MMNB1 y B2 pndA VNB sky130_fd_pr__nfet_01v8 m=2 w=0.65u l=0.15u mult=1 sa=0.265
+ sb=0.265 sd=0.28 area=0.063 perim=1.14
MMINX X y VGND VNB sky130_fd_pr__nfet_01v8 m=4 w=0.65u l=0.15u mult=1 sa=0.265
+ sb=0.265 sd=0.28 area=0.063 perim=1.14
.ENDS sky130_fd_sc_hd__o22a_4
* Copyright 2020 The SkyWater PDK Authors
*
* Licensed under the Apache License, Version 2.0 (the "License");
* you may not use this file except in compliance with the License.
* You may obtain a copy of the License at
*
*     https:  www.apache.org licenses LICENSE-2.0
*
* Unless required by applicable law or agreed to in writing, software
* distributed under the License is distributed on an "AS IS" BASIS,
* WITHOUT WARRANTIES OR CONDITIONS OF ANY KIND, either express or implied.
* See the License for the specific language governing permissions and
* limitations under the License.
*
* SPDX-License-Identifier: Apache-2.0

.SUBCKT sky130_fd_sc_hd__o22ai_1 A1 A2 B1 B2 VGND VNB VNB net59 Y
*.PININFO A1:I A2:I B1:I B2:I VGND:I VNB:I VNB:I net59:I Y:O
MMPA0 net59 A1 sndA1 VNB sky130_fd_pr__pfet_01v8_hvt m=1 w=1.0u l=0.15u mult=1 sa=0.265
+ sb=0.265 sd=0.28 area=0.063 perim=1.14
MMPA1 sndA1 A2 Y VNB sky130_fd_pr__pfet_01v8_hvt m=1 w=1.0u l=0.15u mult=1 sa=0.265
+ sb=0.265 sd=0.28 area=0.063 perim=1.14
MMPB0 net59 B1 sndB1 VNB sky130_fd_pr__pfet_01v8_hvt m=1 w=1.0u l=0.15u mult=1 sa=0.265
+ sb=0.265 sd=0.28 area=0.063 perim=1.14
MMPB1 sndB1 B2 Y VNB sky130_fd_pr__pfet_01v8_hvt m=1 w=1.0u l=0.15u mult=1 sa=0.265
+ sb=0.265 sd=0.28 area=0.063 perim=1.14
MMNA0 pndA A1 VGND VNB sky130_fd_pr__nfet_01v8 m=1 w=0.65u l=0.15u mult=1 sa=0.265
+ sb=0.265 sd=0.28 area=0.063 perim=1.14
MMNA1 pndA A2 VGND VNB sky130_fd_pr__nfet_01v8 m=1 w=0.65u l=0.15u mult=1 sa=0.265
+ sb=0.265 sd=0.28 area=0.063 perim=1.14
MMNB0 Y B1 pndA VNB sky130_fd_pr__nfet_01v8 m=1 w=0.65u l=0.15u mult=1 sa=0.265
+ sb=0.265 sd=0.28 area=0.063 perim=1.14
MMNB1 Y B2 pndA VNB sky130_fd_pr__nfet_01v8 m=1 w=0.65u l=0.15u mult=1 sa=0.265
+ sb=0.265 sd=0.28 area=0.063 perim=1.14
.ENDS sky130_fd_sc_hd__o22ai_1
* Copyright 2020 The SkyWater PDK Authors
*
* Licensed under the Apache License, Version 2.0 (the "License");
* you may not use this file except in compliance with the License.
* You may obtain a copy of the License at
*
*     https:  www.apache.org licenses LICENSE-2.0
*
* Unless required by applicable law or agreed to in writing, software
* distributed under the License is distributed on an "AS IS" BASIS,
* WITHOUT WARRANTIES OR CONDITIONS OF ANY KIND, either express or implied.
* See the License for the specific language governing permissions and
* limitations under the License.
*
* SPDX-License-Identifier: Apache-2.0

.SUBCKT sky130_fd_sc_hd__o22ai_2 A1 A2 B1 B2 VGND VNB VNB net59 Y
*.PININFO A1:I A2:I B1:I B2:I VGND:I VNB:I VNB:I net59:I Y:O
MMPA0 net59 A1 sndA1 VNB sky130_fd_pr__pfet_01v8_hvt m=2 w=1.0u l=0.15u mult=1 sa=0.265
+ sb=0.265 sd=0.28 area=0.063 perim=1.14
MMPA1 sndA1 A2 Y VNB sky130_fd_pr__pfet_01v8_hvt m=2 w=1.0u l=0.15u mult=1 sa=0.265
+ sb=0.265 sd=0.28 area=0.063 perim=1.14
MMPB0 net59 B1 sndB1 VNB sky130_fd_pr__pfet_01v8_hvt m=2 w=1.0u l=0.15u mult=1 sa=0.265
+ sb=0.265 sd=0.28 area=0.063 perim=1.14
MMPB1 sndB1 B2 Y VNB sky130_fd_pr__pfet_01v8_hvt m=2 w=1.0u l=0.15u mult=1 sa=0.265
+ sb=0.265 sd=0.28 area=0.063 perim=1.14
MMNA0 pndA A1 VGND VNB sky130_fd_pr__nfet_01v8 m=2 w=0.65u l=0.15u mult=1 sa=0.265
+ sb=0.265 sd=0.28 area=0.063 perim=1.14
MMNA1 pndA A2 VGND VNB sky130_fd_pr__nfet_01v8 m=2 w=0.65u l=0.15u mult=1 sa=0.265
+ sb=0.265 sd=0.28 area=0.063 perim=1.14
MMNB0 Y B1 pndA VNB sky130_fd_pr__nfet_01v8 m=2 w=0.65u l=0.15u mult=1 sa=0.265
+ sb=0.265 sd=0.28 area=0.063 perim=1.14
MMNB1 Y B2 pndA VNB sky130_fd_pr__nfet_01v8 m=2 w=0.65u l=0.15u mult=1 sa=0.265
+ sb=0.265 sd=0.28 area=0.063 perim=1.14
.ENDS sky130_fd_sc_hd__o22ai_2
* Copyright 2020 The SkyWater PDK Authors
*
* Licensed under the Apache License, Version 2.0 (the "License");
* you may not use this file except in compliance with the License.
* You may obtain a copy of the License at
*
*     https:  www.apache.org licenses LICENSE-2.0
*
* Unless required by applicable law or agreed to in writing, software
* distributed under the License is distributed on an "AS IS" BASIS,
* WITHOUT WARRANTIES OR CONDITIONS OF ANY KIND, either express or implied.
* See the License for the specific language governing permissions and
* limitations under the License.
*
* SPDX-License-Identifier: Apache-2.0

.SUBCKT sky130_fd_sc_hd__o22ai_4 A1 A2 B1 B2 VGND VNB VNB net59 Y
*.PININFO A1:I A2:I B1:I B2:I VGND:I VNB:I VNB:I net59:I Y:O
MMPA0 net59 A1 sndA1 VNB sky130_fd_pr__pfet_01v8_hvt m=4 w=1.0u l=0.15u mult=1 sa=0.265
+ sb=0.265 sd=0.28 area=0.063 perim=1.14
MMPA1 sndA1 A2 Y VNB sky130_fd_pr__pfet_01v8_hvt m=4 w=1.0u l=0.15u mult=1 sa=0.265
+ sb=0.265 sd=0.28 area=0.063 perim=1.14
MMPB0 net59 B1 sndB1 VNB sky130_fd_pr__pfet_01v8_hvt m=4 w=1.0u l=0.15u mult=1 sa=0.265
+ sb=0.265 sd=0.28 area=0.063 perim=1.14
MMPB1 sndB1 B2 Y VNB sky130_fd_pr__pfet_01v8_hvt m=4 w=1.0u l=0.15u mult=1 sa=0.265
+ sb=0.265 sd=0.28 area=0.063 perim=1.14
MMNA0 pndA A1 VGND VNB sky130_fd_pr__nfet_01v8 m=4 w=0.65u l=0.15u mult=1 sa=0.265
+ sb=0.265 sd=0.28 area=0.063 perim=1.14
MMNA1 pndA A2 VGND VNB sky130_fd_pr__nfet_01v8 m=4 w=0.65u l=0.15u mult=1 sa=0.265
+ sb=0.265 sd=0.28 area=0.063 perim=1.14
MMNB0 Y B1 pndA VNB sky130_fd_pr__nfet_01v8 m=4 w=0.65u l=0.15u mult=1 sa=0.265
+ sb=0.265 sd=0.28 area=0.063 perim=1.14
MMNB1 Y B2 pndA VNB sky130_fd_pr__nfet_01v8 m=4 w=0.65u l=0.15u mult=1 sa=0.265
+ sb=0.265 sd=0.28 area=0.063 perim=1.14
.ENDS sky130_fd_sc_hd__o22ai_4
* Copyright 2020 The SkyWater PDK Authors
*
* Licensed under the Apache License, Version 2.0 (the "License");
* you may not use this file except in compliance with the License.
* You may obtain a copy of the License at
*
*     https:  www.apache.org licenses LICENSE-2.0
*
* Unless required by applicable law or agreed to in writing, software
* distributed under the License is distributed on an "AS IS" BASIS,
* WITHOUT WARRANTIES OR CONDITIONS OF ANY KIND, either express or implied.
* See the License for the specific language governing permissions and
* limitations under the License.
*
* SPDX-License-Identifier: Apache-2.0

.SUBCKT sky130_fd_sc_hd__o2bb2a_1 A1_N A2_N B1 B2 VGND VNB VNB net59 X
*.PININFO A1_N:I A2_N:I B1:I B2:I VGND:I VNB:I VNB:I net59:I X:O
MMIN2 X y VGND VNB sky130_fd_pr__nfet_01v8 m=1 w=0.65u l=0.15u mult=1 sa=0.265
+ sb=0.265 sd=0.28 area=0.063 perim=1.14
MMNnand0 VGND A1_N sndNA1N VNB sky130_fd_pr__nfet_01v8 m=1 w=0.42u l=0.15u mult=1
+ sa=0.265 sb=0.265 sd=0.28 area=0.063 perim=1.14
MMNnand1 sndNA1N A2_N inand VNB sky130_fd_pr__nfet_01v8 m=1 w=0.42u l=0.15u mult=1
+ sa=0.265 sb=0.265 sd=0.28 area=0.063 perim=1.14
MMNaoi10 nmid B1 VGND VNB sky130_fd_pr__nfet_01v8 m=1 w=0.42u l=0.15u mult=1 sa=0.265
+ sb=0.265 sd=0.28 area=0.063 perim=1.14
MMNaoi11 nmid B2 VGND VNB sky130_fd_pr__nfet_01v8 m=1 w=0.42u l=0.15u mult=1 sa=0.265
+ sb=0.265 sd=0.28 area=0.063 perim=1.14
MMNaoi20 y inand nmid VNB sky130_fd_pr__nfet_01v8 m=1 w=0.42u l=0.15u mult=1 sa=0.265
+ sb=0.265 sd=0.28 area=0.063 perim=1.14
MMIP2 X y net59 VNB sky130_fd_pr__pfet_01v8_hvt m=1 w=1.0u l=0.15u mult=1 sa=0.265
+ sb=0.265 sd=0.28 area=0.063 perim=1.14
MMPnand0 inand A1_N net59 VNB sky130_fd_pr__pfet_01v8_hvt m=1 w=0.42u l=0.15u mult=1
+ sa=0.265 sb=0.265 sd=0.28 area=0.063 perim=1.14
MMPnand1 inand A2_N net59 VNB sky130_fd_pr__pfet_01v8_hvt m=1 w=0.42u l=0.15u mult=1
+ sa=0.265 sb=0.265 sd=0.28 area=0.063 perim=1.14
MMPaoi10 net59 B1 sndPB1 VNB sky130_fd_pr__pfet_01v8_hvt m=1 w=0.42u l=0.15u mult=1
+ sa=0.265 sb=0.265 sd=0.28 area=0.063 perim=1.14
MMPaoi11 sndPB1 B2 y VNB sky130_fd_pr__pfet_01v8_hvt m=1 w=0.42u l=0.15u mult=1
+ sa=0.265 sb=0.265 sd=0.28 area=0.063 perim=1.14
MMPaoi20 y inand net59 VNB sky130_fd_pr__pfet_01v8_hvt m=1 w=0.42u l=0.15u mult=1
+ sa=0.265 sb=0.265 sd=0.28 area=0.063 perim=1.14
.ENDS sky130_fd_sc_hd__o2bb2a_1
* Copyright 2020 The SkyWater PDK Authors
*
* Licensed under the Apache License, Version 2.0 (the "License");
* you may not use this file except in compliance with the License.
* You may obtain a copy of the License at
*
*     https:  www.apache.org licenses LICENSE-2.0
*
* Unless required by applicable law or agreed to in writing, software
* distributed under the License is distributed on an "AS IS" BASIS,
* WITHOUT WARRANTIES OR CONDITIONS OF ANY KIND, either express or implied.
* See the License for the specific language governing permissions and
* limitations under the License.
*
* SPDX-License-Identifier: Apache-2.0

.SUBCKT sky130_fd_sc_hd__o2bb2a_2 A1_N A2_N B1 B2 VGND VNB VNB net59 X
*.PININFO A1_N:I A2_N:I B1:I B2:I VGND:I VNB:I VNB:I net59:I X:O
MMIN2 X y VGND VNB sky130_fd_pr__nfet_01v8 m=2 w=0.65u l=0.15u mult=1 sa=0.265
+ sb=0.265 sd=0.28 area=0.063 perim=1.14
MMNnand0 VGND A1_N sndNA1N VNB sky130_fd_pr__nfet_01v8 m=1 w=0.42u l=0.15u mult=1
+ sa=0.265 sb=0.265 sd=0.28 area=0.063 perim=1.14
MMNnand1 sndNA1N A2_N inand VNB sky130_fd_pr__nfet_01v8 m=1 w=0.42u l=0.15u mult=1
+ sa=0.265 sb=0.265 sd=0.28 area=0.063 perim=1.14
MMNaoi10 nmid B1 VGND VNB sky130_fd_pr__nfet_01v8 m=1 w=0.42u l=0.15u mult=1 sa=0.265
+ sb=0.265 sd=0.28 area=0.063 perim=1.14
MMNaoi11 nmid B2 VGND VNB sky130_fd_pr__nfet_01v8 m=1 w=0.42u l=0.15u mult=1 sa=0.265
+ sb=0.265 sd=0.28 area=0.063 perim=1.14
MMNaoi20 y inand nmid VNB sky130_fd_pr__nfet_01v8 m=1 w=0.42u l=0.15u mult=1 sa=0.265
+ sb=0.265 sd=0.28 area=0.063 perim=1.14
MMIP2 X y net59 VNB sky130_fd_pr__pfet_01v8_hvt m=2 w=1.0u l=0.15u mult=1 sa=0.265
+ sb=0.265 sd=0.28 area=0.063 perim=1.14
MMPnand0 inand A1_N net59 VNB sky130_fd_pr__pfet_01v8_hvt m=1 w=0.64u l=0.15u mult=1
+ sa=0.265 sb=0.265 sd=0.28 area=0.063 perim=1.14
MMPnand1 inand A2_N net59 VNB sky130_fd_pr__pfet_01v8_hvt m=1 w=0.64u l=0.15u mult=1
+ sa=0.265 sb=0.265 sd=0.28 area=0.063 perim=1.14
MMPaoi10 net59 B1 sndPB1 VNB sky130_fd_pr__pfet_01v8_hvt m=1 w=0.64u l=0.15u mult=1
+ sa=0.265 sb=0.265 sd=0.28 area=0.063 perim=1.14
MMPaoi11 sndPB1 B2 y VNB sky130_fd_pr__pfet_01v8_hvt m=1 w=0.64u l=0.15u mult=1
+ sa=0.265 sb=0.265 sd=0.28 area=0.063 perim=1.14
MMPaoi20 y inand net59 VNB sky130_fd_pr__pfet_01v8_hvt m=1 w=0.64u l=0.15u mult=1
+ sa=0.265 sb=0.265 sd=0.28 area=0.063 perim=1.14
.ENDS sky130_fd_sc_hd__o2bb2a_2
* Copyright 2020 The SkyWater PDK Authors
*
* Licensed under the Apache License, Version 2.0 (the "License");
* you may not use this file except in compliance with the License.
* You may obtain a copy of the License at
*
*     https:  www.apache.org licenses LICENSE-2.0
*
* Unless required by applicable law or agreed to in writing, software
* distributed under the License is distributed on an "AS IS" BASIS,
* WITHOUT WARRANTIES OR CONDITIONS OF ANY KIND, either express or implied.
* See the License for the specific language governing permissions and
* limitations under the License.
*
* SPDX-License-Identifier: Apache-2.0

.SUBCKT sky130_fd_sc_hd__o2bb2a_4 A1_N A2_N B1 B2 VGND VNB VNB net59 X
*.PININFO A1_N:I A2_N:I B1:I B2:I VGND:I VNB:I VNB:I net59:I X:O
MMIN2 X y VGND VNB sky130_fd_pr__nfet_01v8 m=4 w=0.65u l=0.15u mult=1 sa=0.265
+ sb=0.265 sd=0.28 area=0.063 perim=1.14
MMNnand0 VGND A1_N sndNA1N VNB sky130_fd_pr__nfet_01v8 m=2 w=0.65u l=0.15u mult=1
+ sa=0.265 sb=0.265 sd=0.28 area=0.063 perim=1.14
MMNnand1 sndNA1N A2_N inand VNB sky130_fd_pr__nfet_01v8 m=2 w=0.65u l=0.15u mult=1
+ sa=0.265 sb=0.265 sd=0.28 area=0.063 perim=1.14
MMNaoi10 nmid B1 VGND VNB sky130_fd_pr__nfet_01v8 m=2 w=0.65u l=0.15u mult=1 sa=0.265
+ sb=0.265 sd=0.28 area=0.063 perim=1.14
MMNaoi11 nmid B2 VGND VNB sky130_fd_pr__nfet_01v8 m=2 w=0.65u l=0.15u mult=1 sa=0.265
+ sb=0.265 sd=0.28 area=0.063 perim=1.14
MMNaoi20 y inand nmid VNB sky130_fd_pr__nfet_01v8 m=2 w=0.65u l=0.15u mult=1 sa=0.265
+ sb=0.265 sd=0.28 area=0.063 perim=1.14
MMIP2 X y net59 VNB sky130_fd_pr__pfet_01v8_hvt m=4 w=1.0u l=0.15u mult=1 sa=0.265
+ sb=0.265 sd=0.28 area=0.063 perim=1.14
MMPnand0 inand A1_N net59 VNB sky130_fd_pr__pfet_01v8_hvt m=2 w=1.0u l=0.15u mult=1
+ sa=0.265 sb=0.265 sd=0.28 area=0.063 perim=1.14
MMPnand1 inand A2_N net59 VNB sky130_fd_pr__pfet_01v8_hvt m=2 w=1.0u l=0.15u mult=1
+ sa=0.265 sb=0.265 sd=0.28 area=0.063 perim=1.14
MMPaoi10 net59 B1 sndPB1 VNB sky130_fd_pr__pfet_01v8_hvt m=2 w=1.0u l=0.15u mult=1
+ sa=0.265 sb=0.265 sd=0.28 area=0.063 perim=1.14
MMPaoi11 sndPB1 B2 y VNB sky130_fd_pr__pfet_01v8_hvt m=2 w=1.0u l=0.15u mult=1
+ sa=0.265 sb=0.265 sd=0.28 area=0.063 perim=1.14
MMPaoi20 y inand net59 VNB sky130_fd_pr__pfet_01v8_hvt m=2 w=1.0u l=0.15u mult=1
+ sa=0.265 sb=0.265 sd=0.28 area=0.063 perim=1.14
.ENDS sky130_fd_sc_hd__o2bb2a_4
* Copyright 2020 The SkyWater PDK Authors
*
* Licensed under the Apache License, Version 2.0 (the "License");
* you may not use this file except in compliance with the License.
* You may obtain a copy of the License at
*
*     https:  www.apache.org licenses LICENSE-2.0
*
* Unless required by applicable law or agreed to in writing, software
* distributed under the License is distributed on an "AS IS" BASIS,
* WITHOUT WARRANTIES OR CONDITIONS OF ANY KIND, either express or implied.
* See the License for the specific language governing permissions and
* limitations under the License.
*
* SPDX-License-Identifier: Apache-2.0

.SUBCKT sky130_fd_sc_hd__o2bb2ai_1 A1_N A2_N B1 B2 VGND VNB VNB net59 Y
*.PININFO A1_N:I A2_N:I B1:I B2:I VGND:I VNB:I VNB:I net59:I Y:O
MMNnand0 VGND A1_N sndNA1N VNB sky130_fd_pr__nfet_01v8 m=1 w=0.65u l=0.15u mult=1
+ sa=0.265 sb=0.265 sd=0.28 area=0.063 perim=1.14
MMNnand1 sndNA1N A2_N inand VNB sky130_fd_pr__nfet_01v8 m=1 w=0.65u l=0.15u mult=1
+ sa=0.265 sb=0.265 sd=0.28 area=0.063 perim=1.14
MMNaoi10 nmid B1 VGND VNB sky130_fd_pr__nfet_01v8 m=1 w=0.65u l=0.15u mult=1 sa=0.265
+ sb=0.265 sd=0.28 area=0.063 perim=1.14
MMNaoi11 nmid B2 VGND VNB sky130_fd_pr__nfet_01v8 m=1 w=0.65u l=0.15u mult=1 sa=0.265
+ sb=0.265 sd=0.28 area=0.063 perim=1.14
MMNaoi20 Y inand nmid VNB sky130_fd_pr__nfet_01v8 m=1 w=0.65u l=0.15u mult=1 sa=0.265
+ sb=0.265 sd=0.28 area=0.063 perim=1.14
MMPnand0 inand A1_N net59 VNB sky130_fd_pr__pfet_01v8_hvt m=1 w=1.0u l=0.15u mult=1
+ sa=0.265 sb=0.265 sd=0.28 area=0.063 perim=1.14
MMPnand1 inand A2_N net59 VNB sky130_fd_pr__pfet_01v8_hvt m=1 w=1.0u l=0.15u mult=1
+ sa=0.265 sb=0.265 sd=0.28 area=0.063 perim=1.14
MMPaoi10 net59 B1 sndPB1 VNB sky130_fd_pr__pfet_01v8_hvt m=1 w=1.0u l=0.15u mult=1
+ sa=0.265 sb=0.265 sd=0.28 area=0.063 perim=1.14
MMPaoi11 sndPB1 B2 Y VNB sky130_fd_pr__pfet_01v8_hvt m=1 w=1.0u l=0.15u mult=1
+ sa=0.265 sb=0.265 sd=0.28 area=0.063 perim=1.14
MMPaoi20 Y inand net59 VNB sky130_fd_pr__pfet_01v8_hvt m=1 w=1.0u l=0.15u mult=1
+ sa=0.265 sb=0.265 sd=0.28 area=0.063 perim=1.14
.ENDS sky130_fd_sc_hd__o2bb2ai_1
* Copyright 2020 The SkyWater PDK Authors
*
* Licensed under the Apache License, Version 2.0 (the "License");
* you may not use this file except in compliance with the License.
* You may obtain a copy of the License at
*
*     https:  www.apache.org licenses LICENSE-2.0
*
* Unless required by applicable law or agreed to in writing, software
* distributed under the License is distributed on an "AS IS" BASIS,
* WITHOUT WARRANTIES OR CONDITIONS OF ANY KIND, either express or implied.
* See the License for the specific language governing permissions and
* limitations under the License.
*
* SPDX-License-Identifier: Apache-2.0

.SUBCKT sky130_fd_sc_hd__o2bb2ai_2 A1_N A2_N B1 B2 VGND VNB VNB net59 Y
*.PININFO A1_N:I A2_N:I B1:I B2:I VGND:I VNB:I VNB:I net59:I Y:O
MMNnand0 VGND A1_N sndNA1N VNB sky130_fd_pr__nfet_01v8 m=2 w=0.65u l=0.15u mult=1
+ sa=0.265 sb=0.265 sd=0.28 area=0.063 perim=1.14
MMNnand1 sndNA1N A2_N inand VNB sky130_fd_pr__nfet_01v8 m=2 w=0.65u l=0.15u mult=1
+ sa=0.265 sb=0.265 sd=0.28 area=0.063 perim=1.14
MMNaoi10 nmid B1 VGND VNB sky130_fd_pr__nfet_01v8 m=2 w=0.65u l=0.15u mult=1 sa=0.265
+ sb=0.265 sd=0.28 area=0.063 perim=1.14
MMNaoi11 nmid B2 VGND VNB sky130_fd_pr__nfet_01v8 m=2 w=0.65u l=0.15u mult=1 sa=0.265
+ sb=0.265 sd=0.28 area=0.063 perim=1.14
MMNaoi20 Y inand nmid VNB sky130_fd_pr__nfet_01v8 m=2 w=0.65u l=0.15u mult=1 sa=0.265
+ sb=0.265 sd=0.28 area=0.063 perim=1.14
MMPnand0 inand A1_N net59 VNB sky130_fd_pr__pfet_01v8_hvt m=2 w=1.0u l=0.15u mult=1
+ sa=0.265 sb=0.265 sd=0.28 area=0.063 perim=1.14
MMPnand1 inand A2_N net59 VNB sky130_fd_pr__pfet_01v8_hvt m=2 w=1.0u l=0.15u mult=1
+ sa=0.265 sb=0.265 sd=0.28 area=0.063 perim=1.14
MMPaoi10 net59 B1 sndPB1 VNB sky130_fd_pr__pfet_01v8_hvt m=2 w=1.0u l=0.15u mult=1
+ sa=0.265 sb=0.265 sd=0.28 area=0.063 perim=1.14
MMPaoi11 sndPB1 B2 Y VNB sky130_fd_pr__pfet_01v8_hvt m=2 w=1.0u l=0.15u mult=1
+ sa=0.265 sb=0.265 sd=0.28 area=0.063 perim=1.14
MMPaoi20 Y inand net59 VNB sky130_fd_pr__pfet_01v8_hvt m=2 w=1.0u l=0.15u mult=1
+ sa=0.265 sb=0.265 sd=0.28 area=0.063 perim=1.14
.ENDS sky130_fd_sc_hd__o2bb2ai_2
* Copyright 2020 The SkyWater PDK Authors
*
* Licensed under the Apache License, Version 2.0 (the "License");
* you may not use this file except in compliance with the License.
* You may obtain a copy of the License at
*
*     https:  www.apache.org licenses LICENSE-2.0
*
* Unless required by applicable law or agreed to in writing, software
* distributed under the License is distributed on an "AS IS" BASIS,
* WITHOUT WARRANTIES OR CONDITIONS OF ANY KIND, either express or implied.
* See the License for the specific language governing permissions and
* limitations under the License.
*
* SPDX-License-Identifier: Apache-2.0

.SUBCKT sky130_fd_sc_hd__o2bb2ai_4 A1_N A2_N B1 B2 VGND VNB VNB net59 Y
*.PININFO A1_N:I A2_N:I B1:I B2:I VGND:I VNB:I VNB:I net59:I Y:O
MMNnand0 VGND A1_N sndNA1N VNB sky130_fd_pr__nfet_01v8 m=4 w=0.65u l=0.15u mult=1
+ sa=0.265 sb=0.265 sd=0.28 area=0.063 perim=1.14
MMNnand1 sndNA1N A2_N inand VNB sky130_fd_pr__nfet_01v8 m=4 w=0.65u l=0.15u mult=1
+ sa=0.265 sb=0.265 sd=0.28 area=0.063 perim=1.14
MMNaoi10 nmid B1 VGND VNB sky130_fd_pr__nfet_01v8 m=4 w=0.65u l=0.15u mult=1 sa=0.265
+ sb=0.265 sd=0.28 area=0.063 perim=1.14
MMNaoi11 nmid B2 VGND VNB sky130_fd_pr__nfet_01v8 m=4 w=0.65u l=0.15u mult=1 sa=0.265
+ sb=0.265 sd=0.28 area=0.063 perim=1.14
MMNaoi20 Y inand nmid VNB sky130_fd_pr__nfet_01v8 m=4 w=0.65u l=0.15u mult=1 sa=0.265
+ sb=0.265 sd=0.28 area=0.063 perim=1.14
MMPnand0 inand A1_N net59 VNB sky130_fd_pr__pfet_01v8_hvt m=4 w=1.0u l=0.15u mult=1
+ sa=0.265 sb=0.265 sd=0.28 area=0.063 perim=1.14
MMPnand1 inand A2_N net59 VNB sky130_fd_pr__pfet_01v8_hvt m=4 w=1.0u l=0.15u mult=1
+ sa=0.265 sb=0.265 sd=0.28 area=0.063 perim=1.14
MMPaoi10 net59 B1 sndPB1 VNB sky130_fd_pr__pfet_01v8_hvt m=4 w=1.0u l=0.15u mult=1
+ sa=0.265 sb=0.265 sd=0.28 area=0.063 perim=1.14
MMPaoi11 sndPB1 B2 Y VNB sky130_fd_pr__pfet_01v8_hvt m=4 w=1.0u l=0.15u mult=1
+ sa=0.265 sb=0.265 sd=0.28 area=0.063 perim=1.14
MMPaoi20 Y inand net59 VNB sky130_fd_pr__pfet_01v8_hvt m=4 w=1.0u l=0.15u mult=1
+ sa=0.265 sb=0.265 sd=0.28 area=0.063 perim=1.14
.ENDS sky130_fd_sc_hd__o2bb2ai_4
* Copyright 2020 The SkyWater PDK Authors
*
* Licensed under the Apache License, Version 2.0 (the "License");
* you may not use this file except in compliance with the License.
* You may obtain a copy of the License at
*
*     https:  www.apache.org licenses LICENSE-2.0
*
* Unless required by applicable law or agreed to in writing, software
* distributed under the License is distributed on an "AS IS" BASIS,
* WITHOUT WARRANTIES OR CONDITIONS OF ANY KIND, either express or implied.
* See the License for the specific language governing permissions and
* limitations under the License.
*
* SPDX-License-Identifier: Apache-2.0

.SUBCKT sky130_fd_sc_hd__o311a_1 A1 A2 A3 B1 C1 VGND VNB VNB net59 X
*.PININFO A1:I A2:I A3:I B1:I C1:I VGND:I VNB:I VNB:I net59:I X:O
MMPA0 net59 A1 sndA1 VNB sky130_fd_pr__pfet_01v8_hvt m=1 w=1.0u l=0.15u mult=1 sa=0.265
+ sb=0.265 sd=0.28 area=0.063 perim=1.14
MMPA1 sndA1 A2 sndA2 VNB sky130_fd_pr__pfet_01v8_hvt m=1 w=1.0u l=0.15u mult=1
+ sa=0.265 sb=0.265 sd=0.28 area=0.063 perim=1.14
MMPA2 sndA2 A3 y VNB sky130_fd_pr__pfet_01v8_hvt m=1 w=1.0u l=0.15u mult=1 sa=0.265
+ sb=0.265 sd=0.28 area=0.063 perim=1.14
MMPB0 net59 B1 y VNB sky130_fd_pr__pfet_01v8_hvt m=1 w=1.0u l=0.15u mult=1 sa=0.265
+ sb=0.265 sd=0.28 area=0.063 perim=1.14
MMPC0 net59 C1 y VNB sky130_fd_pr__pfet_01v8_hvt m=1 w=1.0u l=0.15u mult=1 sa=0.265
+ sb=0.265 sd=0.28 area=0.063 perim=1.14
MMIPX X y net59 VNB sky130_fd_pr__pfet_01v8_hvt m=1 w=1.0u l=0.15u mult=1 sa=0.265
+ sb=0.265 sd=0.28 area=0.063 perim=1.14
MMNA0 pndA A1 VGND VNB sky130_fd_pr__nfet_01v8 m=1 w=0.65u l=0.15u mult=1 sa=0.265
+ sb=0.265 sd=0.28 area=0.063 perim=1.14
MMNA1 pndA A2 VGND VNB sky130_fd_pr__nfet_01v8 m=1 w=0.65u l=0.15u mult=1 sa=0.265
+ sb=0.265 sd=0.28 area=0.063 perim=1.14
MMNA2 pndA A3 VGND VNB sky130_fd_pr__nfet_01v8 m=1 w=0.65u l=0.15u mult=1 sa=0.265
+ sb=0.265 sd=0.28 area=0.063 perim=1.14
MMNB0 pndB B1 pndA VNB sky130_fd_pr__nfet_01v8 m=1 w=0.65u l=0.15u mult=1 sa=0.265
+ sb=0.265 sd=0.28 area=0.063 perim=1.14
MMNC0 y C1 pndB VNB sky130_fd_pr__nfet_01v8 m=1 w=0.65u l=0.15u mult=1 sa=0.265
+ sb=0.265 sd=0.28 area=0.063 perim=1.14
MMINX X y VGND VNB sky130_fd_pr__nfet_01v8 m=1 w=0.65u l=0.15u mult=1 sa=0.265
+ sb=0.265 sd=0.28 area=0.063 perim=1.14
.ENDS sky130_fd_sc_hd__o311a_1
* Copyright 2020 The SkyWater PDK Authors
*
* Licensed under the Apache License, Version 2.0 (the "License");
* you may not use this file except in compliance with the License.
* You may obtain a copy of the License at
*
*     https:  www.apache.org licenses LICENSE-2.0
*
* Unless required by applicable law or agreed to in writing, software
* distributed under the License is distributed on an "AS IS" BASIS,
* WITHOUT WARRANTIES OR CONDITIONS OF ANY KIND, either express or implied.
* See the License for the specific language governing permissions and
* limitations under the License.
*
* SPDX-License-Identifier: Apache-2.0

.SUBCKT sky130_fd_sc_hd__o311a_2 A1 A2 A3 B1 C1 VGND VNB VNB net59 X
*.PININFO A1:I A2:I A3:I B1:I C1:I VGND:I VNB:I VNB:I net59:I X:O
MMPA0 net59 A1 sndA1 VNB sky130_fd_pr__pfet_01v8_hvt m=1 w=1.0u l=0.15u mult=1 sa=0.265
+ sb=0.265 sd=0.28 area=0.063 perim=1.14
MMPA1 sndA1 A2 sndA2 VNB sky130_fd_pr__pfet_01v8_hvt m=1 w=1.0u l=0.15u mult=1
+ sa=0.265 sb=0.265 sd=0.28 area=0.063 perim=1.14
MMPA2 sndA2 A3 y VNB sky130_fd_pr__pfet_01v8_hvt m=1 w=1.0u l=0.15u mult=1 sa=0.265
+ sb=0.265 sd=0.28 area=0.063 perim=1.14
MMPB0 net59 B1 y VNB sky130_fd_pr__pfet_01v8_hvt m=1 w=1.0u l=0.15u mult=1 sa=0.265
+ sb=0.265 sd=0.28 area=0.063 perim=1.14
MMPC0 net59 C1 y VNB sky130_fd_pr__pfet_01v8_hvt m=1 w=1.0u l=0.15u mult=1 sa=0.265
+ sb=0.265 sd=0.28 area=0.063 perim=1.14
MMIPX X y net59 VNB sky130_fd_pr__pfet_01v8_hvt m=2 w=1.0u l=0.15u mult=1 sa=0.265
+ sb=0.265 sd=0.28 area=0.063 perim=1.14
MMNA0 pndA A1 VGND VNB sky130_fd_pr__nfet_01v8 m=1 w=0.65u l=0.15u mult=1 sa=0.265
+ sb=0.265 sd=0.28 area=0.063 perim=1.14
MMNA1 pndA A2 VGND VNB sky130_fd_pr__nfet_01v8 m=1 w=0.65u l=0.15u mult=1 sa=0.265
+ sb=0.265 sd=0.28 area=0.063 perim=1.14
MMNA2 pndA A3 VGND VNB sky130_fd_pr__nfet_01v8 m=1 w=0.65u l=0.15u mult=1 sa=0.265
+ sb=0.265 sd=0.28 area=0.063 perim=1.14
MMNB0 pndB B1 pndA VNB sky130_fd_pr__nfet_01v8 m=1 w=0.65u l=0.15u mult=1 sa=0.265
+ sb=0.265 sd=0.28 area=0.063 perim=1.14
MMNC0 y C1 pndB VNB sky130_fd_pr__nfet_01v8 m=1 w=0.65u l=0.15u mult=1 sa=0.265
+ sb=0.265 sd=0.28 area=0.063 perim=1.14
MMINX X y VGND VNB sky130_fd_pr__nfet_01v8 m=2 w=0.65u l=0.15u mult=1 sa=0.265
+ sb=0.265 sd=0.28 area=0.063 perim=1.14
.ENDS sky130_fd_sc_hd__o311a_2
* Copyright 2020 The SkyWater PDK Authors
*
* Licensed under the Apache License, Version 2.0 (the "License");
* you may not use this file except in compliance with the License.
* You may obtain a copy of the License at
*
*     https:  www.apache.org licenses LICENSE-2.0
*
* Unless required by applicable law or agreed to in writing, software
* distributed under the License is distributed on an "AS IS" BASIS,
* WITHOUT WARRANTIES OR CONDITIONS OF ANY KIND, either express or implied.
* See the License for the specific language governing permissions and
* limitations under the License.
*
* SPDX-License-Identifier: Apache-2.0

.SUBCKT sky130_fd_sc_hd__o311a_4 A1 A2 A3 B1 C1 VGND VNB VNB net59 X
*.PININFO A1:I A2:I A3:I B1:I C1:I VGND:I VNB:I VNB:I net59:I X:O
MMPA0 net59 A1 sndA1 VNB sky130_fd_pr__pfet_01v8_hvt m=2 w=1.0u l=0.15u mult=1 sa=0.265
+ sb=0.265 sd=0.28 area=0.063 perim=1.14
MMPA1 sndA1 A2 sndA2 VNB sky130_fd_pr__pfet_01v8_hvt m=2 w=1.0u l=0.15u mult=1
+ sa=0.265 sb=0.265 sd=0.28 area=0.063 perim=1.14
MMPA2 sndA2 A3 y VNB sky130_fd_pr__pfet_01v8_hvt m=2 w=1.0u l=0.15u mult=1 sa=0.265
+ sb=0.265 sd=0.28 area=0.063 perim=1.14
MMPB0 net59 B1 y VNB sky130_fd_pr__pfet_01v8_hvt m=2 w=1.0u l=0.15u mult=1 sa=0.265
+ sb=0.265 sd=0.28 area=0.063 perim=1.14
MMPC0 net59 C1 y VNB sky130_fd_pr__pfet_01v8_hvt m=2 w=1.0u l=0.15u mult=1 sa=0.265
+ sb=0.265 sd=0.28 area=0.063 perim=1.14
MMIPX X y net59 VNB sky130_fd_pr__pfet_01v8_hvt m=4 w=1.0u l=0.15u mult=1 sa=0.265
+ sb=0.265 sd=0.28 area=0.063 perim=1.14
MMNA0 pndA A1 VGND VNB sky130_fd_pr__nfet_01v8 m=2 w=0.65u l=0.15u mult=1 sa=0.265
+ sb=0.265 sd=0.28 area=0.063 perim=1.14
MMNA1 pndA A2 VGND VNB sky130_fd_pr__nfet_01v8 m=2 w=0.65u l=0.15u mult=1 sa=0.265
+ sb=0.265 sd=0.28 area=0.063 perim=1.14
MMNA2 pndA A3 VGND VNB sky130_fd_pr__nfet_01v8 m=2 w=0.65u l=0.15u mult=1 sa=0.265
+ sb=0.265 sd=0.28 area=0.063 perim=1.14
MMNB0 pndB B1 pndA VNB sky130_fd_pr__nfet_01v8 m=2 w=0.65u l=0.15u mult=1 sa=0.265
+ sb=0.265 sd=0.28 area=0.063 perim=1.14
MMNC0 y C1 pndB VNB sky130_fd_pr__nfet_01v8 m=2 w=0.65u l=0.15u mult=1 sa=0.265
+ sb=0.265 sd=0.28 area=0.063 perim=1.14
MMINX X y VGND VNB sky130_fd_pr__nfet_01v8 m=4 w=0.65u l=0.15u mult=1 sa=0.265
+ sb=0.265 sd=0.28 area=0.063 perim=1.14
.ENDS sky130_fd_sc_hd__o311a_4
* Copyright 2020 The SkyWater PDK Authors
*
* Licensed under the Apache License, Version 2.0 (the "License");
* you may not use this file except in compliance with the License.
* You may obtain a copy of the License at
*
*     https:  www.apache.org licenses LICENSE-2.0
*
* Unless required by applicable law or agreed to in writing, software
* distributed under the License is distributed on an "AS IS" BASIS,
* WITHOUT WARRANTIES OR CONDITIONS OF ANY KIND, either express or implied.
* See the License for the specific language governing permissions and
* limitations under the License.
*
* SPDX-License-Identifier: Apache-2.0

.SUBCKT sky130_fd_sc_hd__o311ai_0 A1 A2 A3 B1 C1 VGND VNB VNB net59 Y
*.PININFO A1:I A2:I A3:I B1:I C1:I VGND:I VNB:I VNB:I net59:I Y:O
MMPA0 net59 A1 sndA1 VNB sky130_fd_pr__pfet_01v8_hvt m=1 w=0.64u l=0.15u mult=1
+ sa=0.265 sb=0.265 sd=0.28 area=0.063 perim=1.14
MMPA1 sndA1 A2 sndA2 VNB sky130_fd_pr__pfet_01v8_hvt m=1 w=0.64u l=0.15u mult=1
+ sa=0.265 sb=0.265 sd=0.28 area=0.063 perim=1.14
MMPA2 sndA2 A3 Y VNB sky130_fd_pr__pfet_01v8_hvt m=1 w=0.64u l=0.15u mult=1 sa=0.265
+ sb=0.265 sd=0.28 area=0.063 perim=1.14
MMPB0 net59 B1 Y VNB sky130_fd_pr__pfet_01v8_hvt m=1 w=0.64u l=0.15u mult=1 sa=0.265
+ sb=0.265 sd=0.28 area=0.063 perim=1.14
MMPC0 net59 C1 Y VNB sky130_fd_pr__pfet_01v8_hvt m=1 w=0.64u l=0.15u mult=1 sa=0.265
+ sb=0.265 sd=0.28 area=0.063 perim=1.14
MMNA0 pndA A1 VGND VNB sky130_fd_pr__nfet_01v8 m=1 w=0.42u l=0.15u mult=1 sa=0.265
+ sb=0.265 sd=0.28 area=0.063 perim=1.14
MMNA1 pndA A2 VGND VNB sky130_fd_pr__nfet_01v8 m=1 w=0.42u l=0.15u mult=1 sa=0.265
+ sb=0.265 sd=0.28 area=0.063 perim=1.14
MMNA2 pndA A3 VGND VNB sky130_fd_pr__nfet_01v8 m=1 w=0.42u l=0.15u mult=1 sa=0.265
+ sb=0.265 sd=0.28 area=0.063 perim=1.14
MMNB0 pndB B1 pndA VNB sky130_fd_pr__nfet_01v8 m=1 w=0.42u l=0.15u mult=1 sa=0.265
+ sb=0.265 sd=0.28 area=0.063 perim=1.14
MMNC0 Y C1 pndB VNB sky130_fd_pr__nfet_01v8 m=1 w=0.42u l=0.15u mult=1 sa=0.265
+ sb=0.265 sd=0.28 area=0.063 perim=1.14
.ENDS sky130_fd_sc_hd__o311ai_0
* Copyright 2020 The SkyWater PDK Authors
*
* Licensed under the Apache License, Version 2.0 (the "License");
* you may not use this file except in compliance with the License.
* You may obtain a copy of the License at
*
*     https:  www.apache.org licenses LICENSE-2.0
*
* Unless required by applicable law or agreed to in writing, software
* distributed under the License is distributed on an "AS IS" BASIS,
* WITHOUT WARRANTIES OR CONDITIONS OF ANY KIND, either express or implied.
* See the License for the specific language governing permissions and
* limitations under the License.
*
* SPDX-License-Identifier: Apache-2.0

.SUBCKT sky130_fd_sc_hd__o311ai_1 A1 A2 A3 B1 C1 VGND VNB VNB net59 Y
*.PININFO A1:I A2:I A3:I B1:I C1:I VGND:I VNB:I VNB:I net59:I Y:O
MMPA0 net59 A1 sndA1 VNB sky130_fd_pr__pfet_01v8_hvt m=1 w=1.0u l=0.15u mult=1 sa=0.265
+ sb=0.265 sd=0.28 area=0.063 perim=1.14
MMPA1 sndA1 A2 sndA2 VNB sky130_fd_pr__pfet_01v8_hvt m=1 w=1.0u l=0.15u mult=1
+ sa=0.265 sb=0.265 sd=0.28 area=0.063 perim=1.14
MMPA2 sndA2 A3 Y VNB sky130_fd_pr__pfet_01v8_hvt m=1 w=1.0u l=0.15u mult=1 sa=0.265
+ sb=0.265 sd=0.28 area=0.063 perim=1.14
MMPB0 net59 B1 Y VNB sky130_fd_pr__pfet_01v8_hvt m=1 w=1.0u l=0.15u mult=1 sa=0.265
+ sb=0.265 sd=0.28 area=0.063 perim=1.14
MMPC0 net59 C1 Y VNB sky130_fd_pr__pfet_01v8_hvt m=1 w=1.0u l=0.15u mult=1 sa=0.265
+ sb=0.265 sd=0.28 area=0.063 perim=1.14
MMNA0 pndA A1 VGND VNB sky130_fd_pr__nfet_01v8 m=1 w=0.65u l=0.15u mult=1 sa=0.265
+ sb=0.265 sd=0.28 area=0.063 perim=1.14
MMNA1 pndA A2 VGND VNB sky130_fd_pr__nfet_01v8 m=1 w=0.65u l=0.15u mult=1 sa=0.265
+ sb=0.265 sd=0.28 area=0.063 perim=1.14
MMNA2 pndA A3 VGND VNB sky130_fd_pr__nfet_01v8 m=1 w=0.65u l=0.15u mult=1 sa=0.265
+ sb=0.265 sd=0.28 area=0.063 perim=1.14
MMNB0 pndB B1 pndA VNB sky130_fd_pr__nfet_01v8 m=1 w=0.65u l=0.15u mult=1 sa=0.265
+ sb=0.265 sd=0.28 area=0.063 perim=1.14
MMNC0 Y C1 pndB VNB sky130_fd_pr__nfet_01v8 m=1 w=0.65u l=0.15u mult=1 sa=0.265
+ sb=0.265 sd=0.28 area=0.063 perim=1.14
.ENDS sky130_fd_sc_hd__o311ai_1
* Copyright 2020 The SkyWater PDK Authors
*
* Licensed under the Apache License, Version 2.0 (the "License");
* you may not use this file except in compliance with the License.
* You may obtain a copy of the License at
*
*     https:  www.apache.org licenses LICENSE-2.0
*
* Unless required by applicable law or agreed to in writing, software
* distributed under the License is distributed on an "AS IS" BASIS,
* WITHOUT WARRANTIES OR CONDITIONS OF ANY KIND, either express or implied.
* See the License for the specific language governing permissions and
* limitations under the License.
*
* SPDX-License-Identifier: Apache-2.0

.SUBCKT sky130_fd_sc_hd__o311ai_2 A1 A2 A3 B1 C1 VGND VNB VNB net59 Y
*.PININFO A1:I A2:I A3:I B1:I C1:I VGND:I VNB:I VNB:I net59:I Y:O
MMPA0 net59 A1 sndA1 VNB sky130_fd_pr__pfet_01v8_hvt m=2 w=1.0u l=0.15u mult=1 sa=0.265
+ sb=0.265 sd=0.28 area=0.063 perim=1.14
MMPA1 sndA1 A2 sndA2 VNB sky130_fd_pr__pfet_01v8_hvt m=2 w=1.0u l=0.15u mult=1
+ sa=0.265 sb=0.265 sd=0.28 area=0.063 perim=1.14
MMPA2 sndA2 A3 Y VNB sky130_fd_pr__pfet_01v8_hvt m=2 w=1.0u l=0.15u mult=1 sa=0.265
+ sb=0.265 sd=0.28 area=0.063 perim=1.14
MMPB0 net59 B1 Y VNB sky130_fd_pr__pfet_01v8_hvt m=2 w=1.0u l=0.15u mult=1 sa=0.265
+ sb=0.265 sd=0.28 area=0.063 perim=1.14
MMPC0 net59 C1 Y VNB sky130_fd_pr__pfet_01v8_hvt m=2 w=1.0u l=0.15u mult=1 sa=0.265
+ sb=0.265 sd=0.28 area=0.063 perim=1.14
MMNA0 pndA A1 VGND VNB sky130_fd_pr__nfet_01v8 m=2 w=0.65u l=0.15u mult=1 sa=0.265
+ sb=0.265 sd=0.28 area=0.063 perim=1.14
MMNA1 pndA A2 VGND VNB sky130_fd_pr__nfet_01v8 m=2 w=0.65u l=0.15u mult=1 sa=0.265
+ sb=0.265 sd=0.28 area=0.063 perim=1.14
MMNA2 pndA A3 VGND VNB sky130_fd_pr__nfet_01v8 m=2 w=0.65u l=0.15u mult=1 sa=0.265
+ sb=0.265 sd=0.28 area=0.063 perim=1.14
MMNB0 pndB B1 pndA VNB sky130_fd_pr__nfet_01v8 m=2 w=0.65u l=0.15u mult=1 sa=0.265
+ sb=0.265 sd=0.28 area=0.063 perim=1.14
MMNC0 Y C1 pndB VNB sky130_fd_pr__nfet_01v8 m=2 w=0.65u l=0.15u mult=1 sa=0.265
+ sb=0.265 sd=0.28 area=0.063 perim=1.14
.ENDS sky130_fd_sc_hd__o311ai_2
* Copyright 2020 The SkyWater PDK Authors
*
* Licensed under the Apache License, Version 2.0 (the "License");
* you may not use this file except in compliance with the License.
* You may obtain a copy of the License at
*
*     https:  www.apache.org licenses LICENSE-2.0
*
* Unless required by applicable law or agreed to in writing, software
* distributed under the License is distributed on an "AS IS" BASIS,
* WITHOUT WARRANTIES OR CONDITIONS OF ANY KIND, either express or implied.
* See the License for the specific language governing permissions and
* limitations under the License.
*
* SPDX-License-Identifier: Apache-2.0

.SUBCKT sky130_fd_sc_hd__o311ai_4 A1 A2 A3 B1 C1 VGND VNB VNB net59 Y
*.PININFO A1:I A2:I A3:I B1:I C1:I VGND:I VNB:I VNB:I net59:I Y:O
MMPA0 net59 A1 sndA1 VNB sky130_fd_pr__pfet_01v8_hvt m=4 w=1.0u l=0.15u mult=1 sa=0.265
+ sb=0.265 sd=0.28 area=0.063 perim=1.14
MMPA1 sndA1 A2 sndA2 VNB sky130_fd_pr__pfet_01v8_hvt m=4 w=1.0u l=0.15u mult=1
+ sa=0.265 sb=0.265 sd=0.28 area=0.063 perim=1.14
MMPA2 sndA2 A3 Y VNB sky130_fd_pr__pfet_01v8_hvt m=4 w=1.0u l=0.15u mult=1 sa=0.265
+ sb=0.265 sd=0.28 area=0.063 perim=1.14
MMPB0 net59 B1 Y VNB sky130_fd_pr__pfet_01v8_hvt m=4 w=1.0u l=0.15u mult=1 sa=0.265
+ sb=0.265 sd=0.28 area=0.063 perim=1.14
MMPC0 net59 C1 Y VNB sky130_fd_pr__pfet_01v8_hvt m=4 w=1.0u l=0.15u mult=1 sa=0.265
+ sb=0.265 sd=0.28 area=0.063 perim=1.14
MMNA0 pndA A1 VGND VNB sky130_fd_pr__nfet_01v8 m=4 w=0.65u l=0.15u mult=1 sa=0.265
+ sb=0.265 sd=0.28 area=0.063 perim=1.14
MMNA1 pndA A2 VGND VNB sky130_fd_pr__nfet_01v8 m=4 w=0.65u l=0.15u mult=1 sa=0.265
+ sb=0.265 sd=0.28 area=0.063 perim=1.14
MMNA2 pndA A3 VGND VNB sky130_fd_pr__nfet_01v8 m=4 w=0.65u l=0.15u mult=1 sa=0.265
+ sb=0.265 sd=0.28 area=0.063 perim=1.14
MMNB0 pndB B1 pndA VNB sky130_fd_pr__nfet_01v8 m=4 w=0.65u l=0.15u mult=1 sa=0.265
+ sb=0.265 sd=0.28 area=0.063 perim=1.14
MMNC0 Y C1 pndB VNB sky130_fd_pr__nfet_01v8 m=4 w=0.65u l=0.15u mult=1 sa=0.265
+ sb=0.265 sd=0.28 area=0.063 perim=1.14
.ENDS sky130_fd_sc_hd__o311ai_4
* Copyright 2020 The SkyWater PDK Authors
*
* Licensed under the Apache License, Version 2.0 (the "License");
* you may not use this file except in compliance with the License.
* You may obtain a copy of the License at
*
*     https:  www.apache.org licenses LICENSE-2.0
*
* Unless required by applicable law or agreed to in writing, software
* distributed under the License is distributed on an "AS IS" BASIS,
* WITHOUT WARRANTIES OR CONDITIONS OF ANY KIND, either express or implied.
* See the License for the specific language governing permissions and
* limitations under the License.
*
* SPDX-License-Identifier: Apache-2.0

.SUBCKT sky130_fd_sc_hd__o31a_1 A1 A2 A3 B1 VGND VNB VNB net59 X
*.PININFO A1:I A2:I A3:I B1:I VGND:I VNB:I VNB:I net59:I X:O
MMPA0 net59 A1 sndA1 VNB sky130_fd_pr__pfet_01v8_hvt m=1 w=1.0u l=0.15u mult=1 sa=0.265
+ sb=0.265 sd=0.28 area=0.063 perim=1.14
MMPA1 sndA1 A2 sndA2 VNB sky130_fd_pr__pfet_01v8_hvt m=1 w=1.0u l=0.15u mult=1
+ sa=0.265 sb=0.265 sd=0.28 area=0.063 perim=1.14
MMPA2 sndA2 A3 y VNB sky130_fd_pr__pfet_01v8_hvt m=1 w=1.0u l=0.15u mult=1 sa=0.265
+ sb=0.265 sd=0.28 area=0.063 perim=1.14
MMPB0 net59 B1 y VNB sky130_fd_pr__pfet_01v8_hvt m=1 w=1.0u l=0.15u mult=1 sa=0.265
+ sb=0.265 sd=0.28 area=0.063 perim=1.14
MMIPX X y net59 VNB sky130_fd_pr__pfet_01v8_hvt m=1 w=1.0u l=0.15u mult=1 sa=0.265
+ sb=0.265 sd=0.28 area=0.063 perim=1.14
MMNA0 pndA A1 VGND VNB sky130_fd_pr__nfet_01v8 m=1 w=0.65u l=0.15u mult=1 sa=0.265
+ sb=0.265 sd=0.28 area=0.063 perim=1.14
MMNA1 pndA A2 VGND VNB sky130_fd_pr__nfet_01v8 m=1 w=0.65u l=0.15u mult=1 sa=0.265
+ sb=0.265 sd=0.28 area=0.063 perim=1.14
MMNA2 pndA A3 VGND VNB sky130_fd_pr__nfet_01v8 m=1 w=0.65u l=0.15u mult=1 sa=0.265
+ sb=0.265 sd=0.28 area=0.063 perim=1.14
MMNB0 y B1 pndA VNB sky130_fd_pr__nfet_01v8 m=1 w=0.65u l=0.15u mult=1 sa=0.265
+ sb=0.265 sd=0.28 area=0.063 perim=1.14
MMINX X y VGND VNB sky130_fd_pr__nfet_01v8 m=1 w=0.65u l=0.15u mult=1 sa=0.265
+ sb=0.265 sd=0.28 area=0.063 perim=1.14
.ENDS sky130_fd_sc_hd__o31a_1
* Copyright 2020 The SkyWater PDK Authors
*
* Licensed under the Apache License, Version 2.0 (the "License");
* you may not use this file except in compliance with the License.
* You may obtain a copy of the License at
*
*     https:  www.apache.org licenses LICENSE-2.0
*
* Unless required by applicable law or agreed to in writing, software
* distributed under the License is distributed on an "AS IS" BASIS,
* WITHOUT WARRANTIES OR CONDITIONS OF ANY KIND, either express or implied.
* See the License for the specific language governing permissions and
* limitations under the License.
*
* SPDX-License-Identifier: Apache-2.0

.SUBCKT sky130_fd_sc_hd__o31a_2 A1 A2 A3 B1 VGND VNB VNB net59 X
*.PININFO A1:I A2:I A3:I B1:I VGND:I VNB:I VNB:I net59:I X:O
MMPA0 net59 A1 sndA1 VNB sky130_fd_pr__pfet_01v8_hvt m=1 w=1.0u l=0.15u mult=1 sa=0.265
+ sb=0.265 sd=0.28 area=0.063 perim=1.14
MMPA1 sndA1 A2 sndA2 VNB sky130_fd_pr__pfet_01v8_hvt m=1 w=1.0u l=0.15u mult=1
+ sa=0.265 sb=0.265 sd=0.28 area=0.063 perim=1.14
MMPA2 sndA2 A3 y VNB sky130_fd_pr__pfet_01v8_hvt m=1 w=1.0u l=0.15u mult=1 sa=0.265
+ sb=0.265 sd=0.28 area=0.063 perim=1.14
MMPB0 net59 B1 y VNB sky130_fd_pr__pfet_01v8_hvt m=1 w=1.0u l=0.15u mult=1 sa=0.265
+ sb=0.265 sd=0.28 area=0.063 perim=1.14
MMIPX X y net59 VNB sky130_fd_pr__pfet_01v8_hvt m=2 w=1.0u l=0.15u mult=1 sa=0.265
+ sb=0.265 sd=0.28 area=0.063 perim=1.14
MMNA0 pndA A1 VGND VNB sky130_fd_pr__nfet_01v8 m=1 w=0.65u l=0.15u mult=1 sa=0.265
+ sb=0.265 sd=0.28 area=0.063 perim=1.14
MMNA1 pndA A2 VGND VNB sky130_fd_pr__nfet_01v8 m=1 w=0.65u l=0.15u mult=1 sa=0.265
+ sb=0.265 sd=0.28 area=0.063 perim=1.14
MMNA2 pndA A3 VGND VNB sky130_fd_pr__nfet_01v8 m=1 w=0.65u l=0.15u mult=1 sa=0.265
+ sb=0.265 sd=0.28 area=0.063 perim=1.14
MMNB0 y B1 pndA VNB sky130_fd_pr__nfet_01v8 m=1 w=0.65u l=0.15u mult=1 sa=0.265
+ sb=0.265 sd=0.28 area=0.063 perim=1.14
MMINX X y VGND VNB sky130_fd_pr__nfet_01v8 m=2 w=0.65u l=0.15u mult=1 sa=0.265
+ sb=0.265 sd=0.28 area=0.063 perim=1.14
.ENDS sky130_fd_sc_hd__o31a_2
* Copyright 2020 The SkyWater PDK Authors
*
* Licensed under the Apache License, Version 2.0 (the "License");
* you may not use this file except in compliance with the License.
* You may obtain a copy of the License at
*
*     https:  www.apache.org licenses LICENSE-2.0
*
* Unless required by applicable law or agreed to in writing, software
* distributed under the License is distributed on an "AS IS" BASIS,
* WITHOUT WARRANTIES OR CONDITIONS OF ANY KIND, either express or implied.
* See the License for the specific language governing permissions and
* limitations under the License.
*
* SPDX-License-Identifier: Apache-2.0

.SUBCKT sky130_fd_sc_hd__o31a_4 A1 A2 A3 B1 VGND VNB VNB net59 X
*.PININFO A1:I A2:I A3:I B1:I VGND:I VNB:I VNB:I net59:I X:O
MMPA0 net59 A1 sndA1 VNB sky130_fd_pr__pfet_01v8_hvt m=2 w=1.0u l=0.15u mult=1 sa=0.265
+ sb=0.265 sd=0.28 area=0.063 perim=1.14
MMPA1 sndA1 A2 sndA2 VNB sky130_fd_pr__pfet_01v8_hvt m=2 w=1.0u l=0.15u mult=1
+ sa=0.265 sb=0.265 sd=0.28 area=0.063 perim=1.14
MMPA2 sndA2 A3 y VNB sky130_fd_pr__pfet_01v8_hvt m=2 w=1.0u l=0.15u mult=1 sa=0.265
+ sb=0.265 sd=0.28 area=0.063 perim=1.14
MMPB0 net59 B1 y VNB sky130_fd_pr__pfet_01v8_hvt m=2 w=1.0u l=0.15u mult=1 sa=0.265
+ sb=0.265 sd=0.28 area=0.063 perim=1.14
MMIPX X y net59 VNB sky130_fd_pr__pfet_01v8_hvt m=4 w=1.0u l=0.15u mult=1 sa=0.265
+ sb=0.265 sd=0.28 area=0.063 perim=1.14
MMNA0 pndA A1 VGND VNB sky130_fd_pr__nfet_01v8 m=2 w=0.65u l=0.15u mult=1 sa=0.265
+ sb=0.265 sd=0.28 area=0.063 perim=1.14
MMNA1 pndA A2 VGND VNB sky130_fd_pr__nfet_01v8 m=2 w=0.65u l=0.15u mult=1 sa=0.265
+ sb=0.265 sd=0.28 area=0.063 perim=1.14
MMNA2 pndA A3 VGND VNB sky130_fd_pr__nfet_01v8 m=2 w=0.65u l=0.15u mult=1 sa=0.265
+ sb=0.265 sd=0.28 area=0.063 perim=1.14
MMNB0 y B1 pndA VNB sky130_fd_pr__nfet_01v8 m=2 w=0.65u l=0.15u mult=1 sa=0.265
+ sb=0.265 sd=0.28 area=0.063 perim=1.14
MMINX X y VGND VNB sky130_fd_pr__nfet_01v8 m=4 w=0.65u l=0.15u mult=1 sa=0.265
+ sb=0.265 sd=0.28 area=0.063 perim=1.14
.ENDS sky130_fd_sc_hd__o31a_4
* Copyright 2020 The SkyWater PDK Authors
*
* Licensed under the Apache License, Version 2.0 (the "License");
* you may not use this file except in compliance with the License.
* You may obtain a copy of the License at
*
*     https:  www.apache.org licenses LICENSE-2.0
*
* Unless required by applicable law or agreed to in writing, software
* distributed under the License is distributed on an "AS IS" BASIS,
* WITHOUT WARRANTIES OR CONDITIONS OF ANY KIND, either express or implied.
* See the License for the specific language governing permissions and
* limitations under the License.
*
* SPDX-License-Identifier: Apache-2.0

.SUBCKT sky130_fd_sc_hd__o31ai_1 A1 A2 A3 B1 VGND VNB VNB net59 Y
*.PININFO A1:I A2:I A3:I B1:I VGND:I VNB:I VNB:I net59:I Y:O
MMPA0 net59 A1 sndA1 VNB sky130_fd_pr__pfet_01v8_hvt m=1 w=1.0u l=0.15u mult=1 sa=0.265
+ sb=0.265 sd=0.28 area=0.063 perim=1.14
MMPA1 sndA1 A2 sndA2 VNB sky130_fd_pr__pfet_01v8_hvt m=1 w=1.0u l=0.15u mult=1
+ sa=0.265 sb=0.265 sd=0.28 area=0.063 perim=1.14
MMPA2 sndA2 A3 Y VNB sky130_fd_pr__pfet_01v8_hvt m=1 w=1.0u l=0.15u mult=1 sa=0.265
+ sb=0.265 sd=0.28 area=0.063 perim=1.14
MMPB0 net59 B1 Y VNB sky130_fd_pr__pfet_01v8_hvt m=1 w=1.0u l=0.15u mult=1 sa=0.265
+ sb=0.265 sd=0.28 area=0.063 perim=1.14
MMNA0 pndA A1 VGND VNB sky130_fd_pr__nfet_01v8 m=1 w=0.65u l=0.15u mult=1 sa=0.265
+ sb=0.265 sd=0.28 area=0.063 perim=1.14
MMNA1 pndA A2 VGND VNB sky130_fd_pr__nfet_01v8 m=1 w=0.65u l=0.15u mult=1 sa=0.265
+ sb=0.265 sd=0.28 area=0.063 perim=1.14
MMNA2 pndA A3 VGND VNB sky130_fd_pr__nfet_01v8 m=1 w=0.65u l=0.15u mult=1 sa=0.265
+ sb=0.265 sd=0.28 area=0.063 perim=1.14
MMNB0 Y B1 pndA VNB sky130_fd_pr__nfet_01v8 m=1 w=0.65u l=0.15u mult=1 sa=0.265
+ sb=0.265 sd=0.28 area=0.063 perim=1.14
.ENDS sky130_fd_sc_hd__o31ai_1
* Copyright 2020 The SkyWater PDK Authors
*
* Licensed under the Apache License, Version 2.0 (the "License");
* you may not use this file except in compliance with the License.
* You may obtain a copy of the License at
*
*     https:  www.apache.org licenses LICENSE-2.0
*
* Unless required by applicable law or agreed to in writing, software
* distributed under the License is distributed on an "AS IS" BASIS,
* WITHOUT WARRANTIES OR CONDITIONS OF ANY KIND, either express or implied.
* See the License for the specific language governing permissions and
* limitations under the License.
*
* SPDX-License-Identifier: Apache-2.0

.SUBCKT sky130_fd_sc_hd__o31ai_2 A1 A2 A3 B1 VGND VNB VNB net59 Y
*.PININFO A1:I A2:I A3:I B1:I VGND:I VNB:I VNB:I net59:I Y:O
MMPA0 net59 A1 sndA1 VNB sky130_fd_pr__pfet_01v8_hvt m=2 w=1.0u l=0.15u mult=1 sa=0.265
+ sb=0.265 sd=0.28 area=0.063 perim=1.14
MMPA1 sndA1 A2 sndA2 VNB sky130_fd_pr__pfet_01v8_hvt m=2 w=1.0u l=0.15u mult=1
+ sa=0.265 sb=0.265 sd=0.28 area=0.063 perim=1.14
MMPA2 sndA2 A3 Y VNB sky130_fd_pr__pfet_01v8_hvt m=2 w=1.0u l=0.15u mult=1 sa=0.265
+ sb=0.265 sd=0.28 area=0.063 perim=1.14
MMPB0 net59 B1 Y VNB sky130_fd_pr__pfet_01v8_hvt m=2 w=1.0u l=0.15u mult=1 sa=0.265
+ sb=0.265 sd=0.28 area=0.063 perim=1.14
MMNA0 pndA A1 VGND VNB sky130_fd_pr__nfet_01v8 m=2 w=0.65u l=0.15u mult=1 sa=0.265
+ sb=0.265 sd=0.28 area=0.063 perim=1.14
MMNA1 pndA A2 VGND VNB sky130_fd_pr__nfet_01v8 m=2 w=0.65u l=0.15u mult=1 sa=0.265
+ sb=0.265 sd=0.28 area=0.063 perim=1.14
MMNA2 pndA A3 VGND VNB sky130_fd_pr__nfet_01v8 m=2 w=0.65u l=0.15u mult=1 sa=0.265
+ sb=0.265 sd=0.28 area=0.063 perim=1.14
MMNB0 Y B1 pndA VNB sky130_fd_pr__nfet_01v8 m=2 w=0.65u l=0.15u mult=1 sa=0.265
+ sb=0.265 sd=0.28 area=0.063 perim=1.14
.ENDS sky130_fd_sc_hd__o31ai_2
* Copyright 2020 The SkyWater PDK Authors
*
* Licensed under the Apache License, Version 2.0 (the "License");
* you may not use this file except in compliance with the License.
* You may obtain a copy of the License at
*
*     https:  www.apache.org licenses LICENSE-2.0
*
* Unless required by applicable law or agreed to in writing, software
* distributed under the License is distributed on an "AS IS" BASIS,
* WITHOUT WARRANTIES OR CONDITIONS OF ANY KIND, either express or implied.
* See the License for the specific language governing permissions and
* limitations under the License.
*
* SPDX-License-Identifier: Apache-2.0

.SUBCKT sky130_fd_sc_hd__o31ai_4 A1 A2 A3 B1 VGND VNB VNB net59 Y
*.PININFO A1:I A2:I A3:I B1:I VGND:I VNB:I VNB:I net59:I Y:O
MMPA0 net59 A1 sndA1 VNB sky130_fd_pr__pfet_01v8_hvt m=4 w=1.0u l=0.15u mult=1 sa=0.265
+ sb=0.265 sd=0.28 area=0.063 perim=1.14
MMPA1 sndA1 A2 sndA2 VNB sky130_fd_pr__pfet_01v8_hvt m=4 w=1.0u l=0.15u mult=1
+ sa=0.265 sb=0.265 sd=0.28 area=0.063 perim=1.14
MMPA2 sndA2 A3 Y VNB sky130_fd_pr__pfet_01v8_hvt m=4 w=1.0u l=0.15u mult=1 sa=0.265
+ sb=0.265 sd=0.28 area=0.063 perim=1.14
MMPB0 net59 B1 Y VNB sky130_fd_pr__pfet_01v8_hvt m=4 w=1.0u l=0.15u mult=1 sa=0.265
+ sb=0.265 sd=0.28 area=0.063 perim=1.14
MMNA0 pndA A1 VGND VNB sky130_fd_pr__nfet_01v8 m=4 w=0.65u l=0.15u mult=1 sa=0.265
+ sb=0.265 sd=0.28 area=0.063 perim=1.14
MMNA1 pndA A2 VGND VNB sky130_fd_pr__nfet_01v8 m=4 w=0.65u l=0.15u mult=1 sa=0.265
+ sb=0.265 sd=0.28 area=0.063 perim=1.14
MMNA2 pndA A3 VGND VNB sky130_fd_pr__nfet_01v8 m=4 w=0.65u l=0.15u mult=1 sa=0.265
+ sb=0.265 sd=0.28 area=0.063 perim=1.14
MMNB0 Y B1 pndA VNB sky130_fd_pr__nfet_01v8 m=4 w=0.65u l=0.15u mult=1 sa=0.265
+ sb=0.265 sd=0.28 area=0.063 perim=1.14
.ENDS sky130_fd_sc_hd__o31ai_4
* Copyright 2020 The SkyWater PDK Authors
*
* Licensed under the Apache License, Version 2.0 (the "License");
* you may not use this file except in compliance with the License.
* You may obtain a copy of the License at
*
*     https:  www.apache.org licenses LICENSE-2.0
*
* Unless required by applicable law or agreed to in writing, software
* distributed under the License is distributed on an "AS IS" BASIS,
* WITHOUT WARRANTIES OR CONDITIONS OF ANY KIND, either express or implied.
* See the License for the specific language governing permissions and
* limitations under the License.
*
* SPDX-License-Identifier: Apache-2.0

.SUBCKT sky130_fd_sc_hd__o32a_1 A1 A2 A3 B1 B2 VGND VNB VNB net59 X
*.PININFO A1:I A2:I A3:I B1:I B2:I VGND:I VNB:I VNB:I net59:I X:O
MMPA0 net59 A1 sndA1 VNB sky130_fd_pr__pfet_01v8_hvt m=1 w=1.0u l=0.15u mult=1 sa=0.265
+ sb=0.265 sd=0.28 area=0.063 perim=1.14
MMPA1 sndA1 A2 sndA2 VNB sky130_fd_pr__pfet_01v8_hvt m=1 w=1.0u l=0.15u mult=1
+ sa=0.265 sb=0.265 sd=0.28 area=0.063 perim=1.14
MMPA2 sndA2 A3 y VNB sky130_fd_pr__pfet_01v8_hvt m=1 w=1.0u l=0.15u mult=1 sa=0.265
+ sb=0.265 sd=0.28 area=0.063 perim=1.14
MMPB0 net59 B1 sndB1 VNB sky130_fd_pr__pfet_01v8_hvt m=1 w=1.0u l=0.15u mult=1 sa=0.265
+ sb=0.265 sd=0.28 area=0.063 perim=1.14
MMPB1 sndB1 B2 y VNB sky130_fd_pr__pfet_01v8_hvt m=1 w=1.0u l=0.15u mult=1 sa=0.265
+ sb=0.265 sd=0.28 area=0.063 perim=1.14
MMIPX X y net59 VNB sky130_fd_pr__pfet_01v8_hvt m=1 w=1.0u l=0.15u mult=1 sa=0.265
+ sb=0.265 sd=0.28 area=0.063 perim=1.14
MMNA0 pndA A1 VGND VNB sky130_fd_pr__nfet_01v8 m=1 w=0.65u l=0.15u mult=1 sa=0.265
+ sb=0.265 sd=0.28 area=0.063 perim=1.14
MMNA1 pndA A2 VGND VNB sky130_fd_pr__nfet_01v8 m=1 w=0.65u l=0.15u mult=1 sa=0.265
+ sb=0.265 sd=0.28 area=0.063 perim=1.14
MMNA2 pndA A3 VGND VNB sky130_fd_pr__nfet_01v8 m=1 w=0.65u l=0.15u mult=1 sa=0.265
+ sb=0.265 sd=0.28 area=0.063 perim=1.14
MMNB0 y B1 pndA VNB sky130_fd_pr__nfet_01v8 m=1 w=0.65u l=0.15u mult=1 sa=0.265
+ sb=0.265 sd=0.28 area=0.063 perim=1.14
MMNB1 y B2 pndA VNB sky130_fd_pr__nfet_01v8 m=1 w=0.65u l=0.15u mult=1 sa=0.265
+ sb=0.265 sd=0.28 area=0.063 perim=1.14
MMINX X y VGND VNB sky130_fd_pr__nfet_01v8 m=1 w=0.65u l=0.15u mult=1 sa=0.265
+ sb=0.265 sd=0.28 area=0.063 perim=1.14
.ENDS sky130_fd_sc_hd__o32a_1
* Copyright 2020 The SkyWater PDK Authors
*
* Licensed under the Apache License, Version 2.0 (the "License");
* you may not use this file except in compliance with the License.
* You may obtain a copy of the License at
*
*     https:  www.apache.org licenses LICENSE-2.0
*
* Unless required by applicable law or agreed to in writing, software
* distributed under the License is distributed on an "AS IS" BASIS,
* WITHOUT WARRANTIES OR CONDITIONS OF ANY KIND, either express or implied.
* See the License for the specific language governing permissions and
* limitations under the License.
*
* SPDX-License-Identifier: Apache-2.0

.SUBCKT sky130_fd_sc_hd__o32a_2 A1 A2 A3 B1 B2 VGND VNB VNB net59 X
*.PININFO A1:I A2:I A3:I B1:I B2:I VGND:I VNB:I VNB:I net59:I X:O
MMPA0 net59 A1 sndA1 VNB sky130_fd_pr__pfet_01v8_hvt m=1 w=1.0u l=0.15u mult=1 sa=0.265
+ sb=0.265 sd=0.28 area=0.063 perim=1.14
MMPA1 sndA1 A2 sndA2 VNB sky130_fd_pr__pfet_01v8_hvt m=1 w=1.0u l=0.15u mult=1
+ sa=0.265 sb=0.265 sd=0.28 area=0.063 perim=1.14
MMPA2 sndA2 A3 y VNB sky130_fd_pr__pfet_01v8_hvt m=1 w=1.0u l=0.15u mult=1 sa=0.265
+ sb=0.265 sd=0.28 area=0.063 perim=1.14
MMPB0 net59 B1 sndB1 VNB sky130_fd_pr__pfet_01v8_hvt m=1 w=1.0u l=0.15u mult=1 sa=0.265
+ sb=0.265 sd=0.28 area=0.063 perim=1.14
MMPB1 sndB1 B2 y VNB sky130_fd_pr__pfet_01v8_hvt m=1 w=1.0u l=0.15u mult=1 sa=0.265
+ sb=0.265 sd=0.28 area=0.063 perim=1.14
MMIPX X y net59 VNB sky130_fd_pr__pfet_01v8_hvt m=2 w=1.0u l=0.15u mult=1 sa=0.265
+ sb=0.265 sd=0.28 area=0.063 perim=1.14
MMNA0 pndA A1 VGND VNB sky130_fd_pr__nfet_01v8 m=1 w=0.65u l=0.15u mult=1 sa=0.265
+ sb=0.265 sd=0.28 area=0.063 perim=1.14
MMNA1 pndA A2 VGND VNB sky130_fd_pr__nfet_01v8 m=1 w=0.65u l=0.15u mult=1 sa=0.265
+ sb=0.265 sd=0.28 area=0.063 perim=1.14
MMNA2 pndA A3 VGND VNB sky130_fd_pr__nfet_01v8 m=1 w=0.65u l=0.15u mult=1 sa=0.265
+ sb=0.265 sd=0.28 area=0.063 perim=1.14
MMNB0 y B1 pndA VNB sky130_fd_pr__nfet_01v8 m=1 w=0.65u l=0.15u mult=1 sa=0.265
+ sb=0.265 sd=0.28 area=0.063 perim=1.14
MMNB1 y B2 pndA VNB sky130_fd_pr__nfet_01v8 m=1 w=0.65u l=0.15u mult=1 sa=0.265
+ sb=0.265 sd=0.28 area=0.063 perim=1.14
MMINX X y VGND VNB sky130_fd_pr__nfet_01v8 m=2 w=0.65u l=0.15u mult=1 sa=0.265
+ sb=0.265 sd=0.28 area=0.063 perim=1.14
.ENDS sky130_fd_sc_hd__o32a_2
* Copyright 2020 The SkyWater PDK Authors
*
* Licensed under the Apache License, Version 2.0 (the "License");
* you may not use this file except in compliance with the License.
* You may obtain a copy of the License at
*
*     https:  www.apache.org licenses LICENSE-2.0
*
* Unless required by applicable law or agreed to in writing, software
* distributed under the License is distributed on an "AS IS" BASIS,
* WITHOUT WARRANTIES OR CONDITIONS OF ANY KIND, either express or implied.
* See the License for the specific language governing permissions and
* limitations under the License.
*
* SPDX-License-Identifier: Apache-2.0

.SUBCKT sky130_fd_sc_hd__o32a_4 A1 A2 A3 B1 B2 VGND VNB VNB net59 X
*.PININFO A1:I A2:I A3:I B1:I B2:I VGND:I VNB:I VNB:I net59:I X:O
MMPA0 net59 A1 sndA1 VNB sky130_fd_pr__pfet_01v8_hvt m=2 w=1.0u l=0.15u mult=1 sa=0.265
+ sb=0.265 sd=0.28 area=0.063 perim=1.14
MMPA1 sndA1 A2 sndA2 VNB sky130_fd_pr__pfet_01v8_hvt m=2 w=1.0u l=0.15u mult=1
+ sa=0.265 sb=0.265 sd=0.28 area=0.063 perim=1.14
MMPA2 sndA2 A3 y VNB sky130_fd_pr__pfet_01v8_hvt m=2 w=1.0u l=0.15u mult=1 sa=0.265
+ sb=0.265 sd=0.28 area=0.063 perim=1.14
MMPB0 net59 B1 sndB1 VNB sky130_fd_pr__pfet_01v8_hvt m=2 w=1.0u l=0.15u mult=1 sa=0.265
+ sb=0.265 sd=0.28 area=0.063 perim=1.14
MMPB1 sndB1 B2 y VNB sky130_fd_pr__pfet_01v8_hvt m=2 w=1.0u l=0.15u mult=1 sa=0.265
+ sb=0.265 sd=0.28 area=0.063 perim=1.14
MMIPX X y net59 VNB sky130_fd_pr__pfet_01v8_hvt m=4 w=1.0u l=0.15u mult=1 sa=0.265
+ sb=0.265 sd=0.28 area=0.063 perim=1.14
MMNA0 pndA A1 VGND VNB sky130_fd_pr__nfet_01v8 m=2 w=0.65u l=0.15u mult=1 sa=0.265
+ sb=0.265 sd=0.28 area=0.063 perim=1.14
MMNA1 pndA A2 VGND VNB sky130_fd_pr__nfet_01v8 m=2 w=0.65u l=0.15u mult=1 sa=0.265
+ sb=0.265 sd=0.28 area=0.063 perim=1.14
MMNA2 pndA A3 VGND VNB sky130_fd_pr__nfet_01v8 m=2 w=0.65u l=0.15u mult=1 sa=0.265
+ sb=0.265 sd=0.28 area=0.063 perim=1.14
MMNB0 y B1 pndA VNB sky130_fd_pr__nfet_01v8 m=2 w=0.65u l=0.15u mult=1 sa=0.265
+ sb=0.265 sd=0.28 area=0.063 perim=1.14
MMNB1 y B2 pndA VNB sky130_fd_pr__nfet_01v8 m=2 w=0.65u l=0.15u mult=1 sa=0.265
+ sb=0.265 sd=0.28 area=0.063 perim=1.14
MMINX X y VGND VNB sky130_fd_pr__nfet_01v8 m=4 w=0.65u l=0.15u mult=1 sa=0.265
+ sb=0.265 sd=0.28 area=0.063 perim=1.14
.ENDS sky130_fd_sc_hd__o32a_4
* Copyright 2020 The SkyWater PDK Authors
*
* Licensed under the Apache License, Version 2.0 (the "License");
* you may not use this file except in compliance with the License.
* You may obtain a copy of the License at
*
*     https:  www.apache.org licenses LICENSE-2.0
*
* Unless required by applicable law or agreed to in writing, software
* distributed under the License is distributed on an "AS IS" BASIS,
* WITHOUT WARRANTIES OR CONDITIONS OF ANY KIND, either express or implied.
* See the License for the specific language governing permissions and
* limitations under the License.
*
* SPDX-License-Identifier: Apache-2.0

.SUBCKT sky130_fd_sc_hd__o32ai_1 A1 A2 A3 B1 B2 VGND VNB VNB net59 Y
*.PININFO A1:I A2:I A3:I B1:I B2:I VGND:I VNB:I VNB:I net59:I Y:O
MMPA0 net59 A1 sndA1 VNB sky130_fd_pr__pfet_01v8_hvt m=1 w=1.0u l=0.15u mult=1 sa=0.265
+ sb=0.265 sd=0.28 area=0.063 perim=1.14
MMPA1 sndA1 A2 sndA2 VNB sky130_fd_pr__pfet_01v8_hvt m=1 w=1.0u l=0.15u mult=1
+ sa=0.265 sb=0.265 sd=0.28 area=0.063 perim=1.14
MMPA2 sndA2 A3 Y VNB sky130_fd_pr__pfet_01v8_hvt m=1 w=1.0u l=0.15u mult=1 sa=0.265
+ sb=0.265 sd=0.28 area=0.063 perim=1.14
MMPB0 net59 B1 sndB1 VNB sky130_fd_pr__pfet_01v8_hvt m=1 w=1.0u l=0.15u mult=1 sa=0.265
+ sb=0.265 sd=0.28 area=0.063 perim=1.14
MMPB1 sndB1 B2 Y VNB sky130_fd_pr__pfet_01v8_hvt m=1 w=1.0u l=0.15u mult=1 sa=0.265
+ sb=0.265 sd=0.28 area=0.063 perim=1.14
MMNA0 pndA A1 VGND VNB sky130_fd_pr__nfet_01v8 m=1 w=0.65u l=0.15u mult=1 sa=0.265
+ sb=0.265 sd=0.28 area=0.063 perim=1.14
MMNA1 pndA A2 VGND VNB sky130_fd_pr__nfet_01v8 m=1 w=0.65u l=0.15u mult=1 sa=0.265
+ sb=0.265 sd=0.28 area=0.063 perim=1.14
MMNA2 pndA A3 VGND VNB sky130_fd_pr__nfet_01v8 m=1 w=0.65u l=0.15u mult=1 sa=0.265
+ sb=0.265 sd=0.28 area=0.063 perim=1.14
MMNB0 Y B1 pndA VNB sky130_fd_pr__nfet_01v8 m=1 w=0.65u l=0.15u mult=1 sa=0.265
+ sb=0.265 sd=0.28 area=0.063 perim=1.14
MMNB1 Y B2 pndA VNB sky130_fd_pr__nfet_01v8 m=1 w=0.65u l=0.15u mult=1 sa=0.265
+ sb=0.265 sd=0.28 area=0.063 perim=1.14
.ENDS sky130_fd_sc_hd__o32ai_1
* Copyright 2020 The SkyWater PDK Authors
*
* Licensed under the Apache License, Version 2.0 (the "License");
* you may not use this file except in compliance with the License.
* You may obtain a copy of the License at
*
*     https:  www.apache.org licenses LICENSE-2.0
*
* Unless required by applicable law or agreed to in writing, software
* distributed under the License is distributed on an "AS IS" BASIS,
* WITHOUT WARRANTIES OR CONDITIONS OF ANY KIND, either express or implied.
* See the License for the specific language governing permissions and
* limitations under the License.
*
* SPDX-License-Identifier: Apache-2.0

.SUBCKT sky130_fd_sc_hd__o32ai_2 A1 A2 A3 B1 B2 VGND VNB VNB net59 Y
*.PININFO A1:I A2:I A3:I B1:I B2:I VGND:I VNB:I VNB:I net59:I Y:O
MMPA0 net59 A1 sndA1 VNB sky130_fd_pr__pfet_01v8_hvt m=2 w=1.0u l=0.15u mult=1 sa=0.265
+ sb=0.265 sd=0.28 area=0.063 perim=1.14
MMPA1 sndA1 A2 sndA2 VNB sky130_fd_pr__pfet_01v8_hvt m=2 w=1.0u l=0.15u mult=1
+ sa=0.265 sb=0.265 sd=0.28 area=0.063 perim=1.14
MMPA2 sndA2 A3 Y VNB sky130_fd_pr__pfet_01v8_hvt m=2 w=1.0u l=0.15u mult=1 sa=0.265
+ sb=0.265 sd=0.28 area=0.063 perim=1.14
MMPB0 net59 B1 sndB1 VNB sky130_fd_pr__pfet_01v8_hvt m=2 w=1.0u l=0.15u mult=1 sa=0.265
+ sb=0.265 sd=0.28 area=0.063 perim=1.14
MMPB1 sndB1 B2 Y VNB sky130_fd_pr__pfet_01v8_hvt m=2 w=1.0u l=0.15u mult=1 sa=0.265
+ sb=0.265 sd=0.28 area=0.063 perim=1.14
MMNA0 pndA A1 VGND VNB sky130_fd_pr__nfet_01v8 m=2 w=0.65u l=0.15u mult=1 sa=0.265
+ sb=0.265 sd=0.28 area=0.063 perim=1.14
MMNA1 pndA A2 VGND VNB sky130_fd_pr__nfet_01v8 m=2 w=0.65u l=0.15u mult=1 sa=0.265
+ sb=0.265 sd=0.28 area=0.063 perim=1.14
MMNA2 pndA A3 VGND VNB sky130_fd_pr__nfet_01v8 m=2 w=0.65u l=0.15u mult=1 sa=0.265
+ sb=0.265 sd=0.28 area=0.063 perim=1.14
MMNB0 Y B1 pndA VNB sky130_fd_pr__nfet_01v8 m=2 w=0.65u l=0.15u mult=1 sa=0.265
+ sb=0.265 sd=0.28 area=0.063 perim=1.14
MMNB1 Y B2 pndA VNB sky130_fd_pr__nfet_01v8 m=2 w=0.65u l=0.15u mult=1 sa=0.265
+ sb=0.265 sd=0.28 area=0.063 perim=1.14
.ENDS sky130_fd_sc_hd__o32ai_2
* Copyright 2020 The SkyWater PDK Authors
*
* Licensed under the Apache License, Version 2.0 (the "License");
* you may not use this file except in compliance with the License.
* You may obtain a copy of the License at
*
*     https:  www.apache.org licenses LICENSE-2.0
*
* Unless required by applicable law or agreed to in writing, software
* distributed under the License is distributed on an "AS IS" BASIS,
* WITHOUT WARRANTIES OR CONDITIONS OF ANY KIND, either express or implied.
* See the License for the specific language governing permissions and
* limitations under the License.
*
* SPDX-License-Identifier: Apache-2.0

.SUBCKT sky130_fd_sc_hd__o32ai_4 A1 A2 A3 B1 B2 VGND VNB VNB net59 Y
*.PININFO A1:I A2:I A3:I B1:I B2:I VGND:I VNB:I VNB:I net59:I Y:O
MMPA0 net59 A1 sndA1 VNB sky130_fd_pr__pfet_01v8_hvt m=4 w=1.0u l=0.15u mult=1 sa=0.265
+ sb=0.265 sd=0.28 area=0.063 perim=1.14
MMPA1 sndA1 A2 sndA2 VNB sky130_fd_pr__pfet_01v8_hvt m=4 w=1.0u l=0.15u mult=1
+ sa=0.265 sb=0.265 sd=0.28 area=0.063 perim=1.14
MMPA2 sndA2 A3 Y VNB sky130_fd_pr__pfet_01v8_hvt m=4 w=1.0u l=0.15u mult=1 sa=0.265
+ sb=0.265 sd=0.28 area=0.063 perim=1.14
MMPB0 net59 B1 sndB1 VNB sky130_fd_pr__pfet_01v8_hvt m=4 w=1.0u l=0.15u mult=1 sa=0.265
+ sb=0.265 sd=0.28 area=0.063 perim=1.14
MMPB1 sndB1 B2 Y VNB sky130_fd_pr__pfet_01v8_hvt m=4 w=1.0u l=0.15u mult=1 sa=0.265
+ sb=0.265 sd=0.28 area=0.063 perim=1.14
MMNA0 pndA A1 VGND VNB sky130_fd_pr__nfet_01v8 m=4 w=0.65u l=0.15u mult=1 sa=0.265
+ sb=0.265 sd=0.28 area=0.063 perim=1.14
MMNA1 pndA A2 VGND VNB sky130_fd_pr__nfet_01v8 m=4 w=0.65u l=0.15u mult=1 sa=0.265
+ sb=0.265 sd=0.28 area=0.063 perim=1.14
MMNA2 pndA A3 VGND VNB sky130_fd_pr__nfet_01v8 m=4 w=0.65u l=0.15u mult=1 sa=0.265
+ sb=0.265 sd=0.28 area=0.063 perim=1.14
MMNB0 Y B1 pndA VNB sky130_fd_pr__nfet_01v8 m=4 w=0.65u l=0.15u mult=1 sa=0.265
+ sb=0.265 sd=0.28 area=0.063 perim=1.14
MMNB1 Y B2 pndA VNB sky130_fd_pr__nfet_01v8 m=4 w=0.65u l=0.15u mult=1 sa=0.265
+ sb=0.265 sd=0.28 area=0.063 perim=1.14
.ENDS sky130_fd_sc_hd__o32ai_4
* Copyright 2020 The SkyWater PDK Authors
*
* Licensed under the Apache License, Version 2.0 (the "License");
* you may not use this file except in compliance with the License.
* You may obtain a copy of the License at
*
*     https:  www.apache.org licenses LICENSE-2.0
*
* Unless required by applicable law or agreed to in writing, software
* distributed under the License is distributed on an "AS IS" BASIS,
* WITHOUT WARRANTIES OR CONDITIONS OF ANY KIND, either express or implied.
* See the License for the specific language governing permissions and
* limitations under the License.
*
* SPDX-License-Identifier: Apache-2.0

.SUBCKT sky130_fd_sc_hd__o41a_1 A1 A2 A3 A4 B1 VGND VNB VNB net59 X
*.PININFO A1:I A2:I A3:I A4:I B1:I VGND:I VNB:I VNB:I net59:I X:O
MMPA0 net59 A1 sndA1 VNB sky130_fd_pr__pfet_01v8_hvt m=1 w=1.0u l=0.15u mult=1 sa=0.265
+ sb=0.265 sd=0.28 area=0.063 perim=1.14
MMPA1 sndA1 A2 sndA2 VNB sky130_fd_pr__pfet_01v8_hvt m=1 w=1.0u l=0.15u mult=1
+ sa=0.265 sb=0.265 sd=0.28 area=0.063 perim=1.14
MMPA2 sndA2 A3 sndA3 VNB sky130_fd_pr__pfet_01v8_hvt m=1 w=1.0u l=0.15u mult=1
+ sa=0.265 sb=0.265 sd=0.28 area=0.063 perim=1.14
MMPA3 sndA3 A4 y VNB sky130_fd_pr__pfet_01v8_hvt m=1 w=1.0u l=0.15u mult=1 sa=0.265
+ sb=0.265 sd=0.28 area=0.063 perim=1.14
MMPB0 net59 B1 y VNB sky130_fd_pr__pfet_01v8_hvt m=1 w=1.0u l=0.15u mult=1 sa=0.265
+ sb=0.265 sd=0.28 area=0.063 perim=1.14
MMIPX X y net59 VNB sky130_fd_pr__pfet_01v8_hvt m=1 w=1.0u l=0.15u mult=1 sa=0.265
+ sb=0.265 sd=0.28 area=0.063 perim=1.14
MMNA0 pndA A1 VGND VNB sky130_fd_pr__nfet_01v8 m=1 w=0.65u l=0.15u mult=1 sa=0.265
+ sb=0.265 sd=0.28 area=0.063 perim=1.14
MMNA1 pndA A2 VGND VNB sky130_fd_pr__nfet_01v8 m=1 w=0.65u l=0.15u mult=1 sa=0.265
+ sb=0.265 sd=0.28 area=0.063 perim=1.14
MMNA2 pndA A3 VGND VNB sky130_fd_pr__nfet_01v8 m=1 w=0.65u l=0.15u mult=1 sa=0.265
+ sb=0.265 sd=0.28 area=0.063 perim=1.14
MMNA3 pndA A4 VGND VNB sky130_fd_pr__nfet_01v8 m=1 w=0.65u l=0.15u mult=1 sa=0.265
+ sb=0.265 sd=0.28 area=0.063 perim=1.14
MMNB0 y B1 pndA VNB sky130_fd_pr__nfet_01v8 m=1 w=0.65u l=0.15u mult=1 sa=0.265
+ sb=0.265 sd=0.28 area=0.063 perim=1.14
MMINX X y VGND VNB sky130_fd_pr__nfet_01v8 m=1 w=0.65u l=0.15u mult=1 sa=0.265
+ sb=0.265 sd=0.28 area=0.063 perim=1.14
.ENDS sky130_fd_sc_hd__o41a_1
* Copyright 2020 The SkyWater PDK Authors
*
* Licensed under the Apache License, Version 2.0 (the "License");
* you may not use this file except in compliance with the License.
* You may obtain a copy of the License at
*
*     https:  www.apache.org licenses LICENSE-2.0
*
* Unless required by applicable law or agreed to in writing, software
* distributed under the License is distributed on an "AS IS" BASIS,
* WITHOUT WARRANTIES OR CONDITIONS OF ANY KIND, either express or implied.
* See the License for the specific language governing permissions and
* limitations under the License.
*
* SPDX-License-Identifier: Apache-2.0

.SUBCKT sky130_fd_sc_hd__o41a_2 A1 A2 A3 A4 B1 VGND VNB VNB net59 X
*.PININFO A1:I A2:I A3:I A4:I B1:I VGND:I VNB:I VNB:I net59:I X:O
MMPA0 net59 A1 sndA1 VNB sky130_fd_pr__pfet_01v8_hvt m=1 w=1.0u l=0.15u mult=1 sa=0.265
+ sb=0.265 sd=0.28 area=0.063 perim=1.14
MMPA1 sndA1 A2 sndA2 VNB sky130_fd_pr__pfet_01v8_hvt m=1 w=1.0u l=0.15u mult=1
+ sa=0.265 sb=0.265 sd=0.28 area=0.063 perim=1.14
MMPA2 sndA2 A3 sndA3 VNB sky130_fd_pr__pfet_01v8_hvt m=1 w=1.0u l=0.15u mult=1
+ sa=0.265 sb=0.265 sd=0.28 area=0.063 perim=1.14
MMPA3 sndA3 A4 y VNB sky130_fd_pr__pfet_01v8_hvt m=1 w=1.0u l=0.15u mult=1 sa=0.265
+ sb=0.265 sd=0.28 area=0.063 perim=1.14
MMPB0 net59 B1 y VNB sky130_fd_pr__pfet_01v8_hvt m=1 w=1.0u l=0.15u mult=1 sa=0.265
+ sb=0.265 sd=0.28 area=0.063 perim=1.14
MMIPX X y net59 VNB sky130_fd_pr__pfet_01v8_hvt m=2 w=1.0u l=0.15u mult=1 sa=0.265
+ sb=0.265 sd=0.28 area=0.063 perim=1.14
MMNA0 pndA A1 VGND VNB sky130_fd_pr__nfet_01v8 m=1 w=0.65u l=0.15u mult=1 sa=0.265
+ sb=0.265 sd=0.28 area=0.063 perim=1.14
MMNA1 pndA A2 VGND VNB sky130_fd_pr__nfet_01v8 m=1 w=0.65u l=0.15u mult=1 sa=0.265
+ sb=0.265 sd=0.28 area=0.063 perim=1.14
MMNA2 pndA A3 VGND VNB sky130_fd_pr__nfet_01v8 m=1 w=0.65u l=0.15u mult=1 sa=0.265
+ sb=0.265 sd=0.28 area=0.063 perim=1.14
MMNA3 pndA A4 VGND VNB sky130_fd_pr__nfet_01v8 m=1 w=0.65u l=0.15u mult=1 sa=0.265
+ sb=0.265 sd=0.28 area=0.063 perim=1.14
MMNB0 y B1 pndA VNB sky130_fd_pr__nfet_01v8 m=1 w=0.65u l=0.15u mult=1 sa=0.265
+ sb=0.265 sd=0.28 area=0.063 perim=1.14
MMINX X y VGND VNB sky130_fd_pr__nfet_01v8 m=2 w=0.65u l=0.15u mult=1 sa=0.265
+ sb=0.265 sd=0.28 area=0.063 perim=1.14
.ENDS sky130_fd_sc_hd__o41a_2
* Copyright 2020 The SkyWater PDK Authors
*
* Licensed under the Apache License, Version 2.0 (the "License");
* you may not use this file except in compliance with the License.
* You may obtain a copy of the License at
*
*     https:  www.apache.org licenses LICENSE-2.0
*
* Unless required by applicable law or agreed to in writing, software
* distributed under the License is distributed on an "AS IS" BASIS,
* WITHOUT WARRANTIES OR CONDITIONS OF ANY KIND, either express or implied.
* See the License for the specific language governing permissions and
* limitations under the License.
*
* SPDX-License-Identifier: Apache-2.0

.SUBCKT sky130_fd_sc_hd__o41a_4 A1 A2 A3 A4 B1 VGND VNB VNB net59 X
*.PININFO A1:I A2:I A3:I A4:I B1:I VGND:I VNB:I VNB:I net59:I X:O
MMPA0 net59 A1 sndA1 VNB sky130_fd_pr__pfet_01v8_hvt m=2 w=1.0u l=0.15u mult=1 sa=0.265
+ sb=0.265 sd=0.28 area=0.063 perim=1.14
MMPA1 sndA1 A2 sndA2 VNB sky130_fd_pr__pfet_01v8_hvt m=2 w=1.0u l=0.15u mult=1
+ sa=0.265 sb=0.265 sd=0.28 area=0.063 perim=1.14
MMPA2 sndA2 A3 sndA3 VNB sky130_fd_pr__pfet_01v8_hvt m=2 w=1.0u l=0.15u mult=1
+ sa=0.265 sb=0.265 sd=0.28 area=0.063 perim=1.14
MMPA3 sndA3 A4 y VNB sky130_fd_pr__pfet_01v8_hvt m=2 w=1.0u l=0.15u mult=1 sa=0.265
+ sb=0.265 sd=0.28 area=0.063 perim=1.14
MMPB0 net59 B1 y VNB sky130_fd_pr__pfet_01v8_hvt m=2 w=1.0u l=0.15u mult=1 sa=0.265
+ sb=0.265 sd=0.28 area=0.063 perim=1.14
MMIPX X y net59 VNB sky130_fd_pr__pfet_01v8_hvt m=4 w=1.0u l=0.15u mult=1 sa=0.265
+ sb=0.265 sd=0.28 area=0.063 perim=1.14
MMNA0 pndA A1 VGND VNB sky130_fd_pr__nfet_01v8 m=2 w=0.65u l=0.15u mult=1 sa=0.265
+ sb=0.265 sd=0.28 area=0.063 perim=1.14
MMNA1 pndA A2 VGND VNB sky130_fd_pr__nfet_01v8 m=2 w=0.65u l=0.15u mult=1 sa=0.265
+ sb=0.265 sd=0.28 area=0.063 perim=1.14
MMNA2 pndA A3 VGND VNB sky130_fd_pr__nfet_01v8 m=2 w=0.65u l=0.15u mult=1 sa=0.265
+ sb=0.265 sd=0.28 area=0.063 perim=1.14
MMNA3 pndA A4 VGND VNB sky130_fd_pr__nfet_01v8 m=2 w=0.65u l=0.15u mult=1 sa=0.265
+ sb=0.265 sd=0.28 area=0.063 perim=1.14
MMNB0 y B1 pndA VNB sky130_fd_pr__nfet_01v8 m=2 w=0.65u l=0.15u mult=1 sa=0.265
+ sb=0.265 sd=0.28 area=0.063 perim=1.14
MMINX X y VGND VNB sky130_fd_pr__nfet_01v8 m=4 w=0.65u l=0.15u mult=1 sa=0.265
+ sb=0.265 sd=0.28 area=0.063 perim=1.14
.ENDS sky130_fd_sc_hd__o41a_4
* Copyright 2020 The SkyWater PDK Authors
*
* Licensed under the Apache License, Version 2.0 (the "License");
* you may not use this file except in compliance with the License.
* You may obtain a copy of the License at
*
*     https:  www.apache.org licenses LICENSE-2.0
*
* Unless required by applicable law or agreed to in writing, software
* distributed under the License is distributed on an "AS IS" BASIS,
* WITHOUT WARRANTIES OR CONDITIONS OF ANY KIND, either express or implied.
* See the License for the specific language governing permissions and
* limitations under the License.
*
* SPDX-License-Identifier: Apache-2.0

.SUBCKT sky130_fd_sc_hd__o41ai_1 A1 A2 A3 A4 B1 VGND VNB VNB net59 Y
*.PININFO A1:I A2:I A3:I A4:I B1:I VGND:I VNB:I VNB:I net59:I Y:O
MMPA0 net59 A1 sndA1 VNB sky130_fd_pr__pfet_01v8_hvt m=1 w=1.0u l=0.15u mult=1 sa=0.265
+ sb=0.265 sd=0.28 area=0.063 perim=1.14
MMPA1 sndA1 A2 sndA2 VNB sky130_fd_pr__pfet_01v8_hvt m=1 w=1.0u l=0.15u mult=1
+ sa=0.265 sb=0.265 sd=0.28 area=0.063 perim=1.14
MMPA2 sndA2 A3 sndA3 VNB sky130_fd_pr__pfet_01v8_hvt m=1 w=1.0u l=0.15u mult=1
+ sa=0.265 sb=0.265 sd=0.28 area=0.063 perim=1.14
MMPA3 sndA3 A4 Y VNB sky130_fd_pr__pfet_01v8_hvt m=1 w=1.0u l=0.15u mult=1 sa=0.265
+ sb=0.265 sd=0.28 area=0.063 perim=1.14
MMPB0 net59 B1 Y VNB sky130_fd_pr__pfet_01v8_hvt m=1 w=1.0u l=0.15u mult=1 sa=0.265
+ sb=0.265 sd=0.28 area=0.063 perim=1.14
MMNA0 pndA A1 VGND VNB sky130_fd_pr__nfet_01v8 m=1 w=0.65u l=0.15u mult=1 sa=0.265
+ sb=0.265 sd=0.28 area=0.063 perim=1.14
MMNA1 pndA A2 VGND VNB sky130_fd_pr__nfet_01v8 m=1 w=0.65u l=0.15u mult=1 sa=0.265
+ sb=0.265 sd=0.28 area=0.063 perim=1.14
MMNA2 pndA A3 VGND VNB sky130_fd_pr__nfet_01v8 m=1 w=0.65u l=0.15u mult=1 sa=0.265
+ sb=0.265 sd=0.28 area=0.063 perim=1.14
MMNA3 pndA A4 VGND VNB sky130_fd_pr__nfet_01v8 m=1 w=0.65u l=0.15u mult=1 sa=0.265
+ sb=0.265 sd=0.28 area=0.063 perim=1.14
MMNB0 Y B1 pndA VNB sky130_fd_pr__nfet_01v8 m=1 w=0.65u l=0.15u mult=1 sa=0.265
+ sb=0.265 sd=0.28 area=0.063 perim=1.14
.ENDS sky130_fd_sc_hd__o41ai_1
* Copyright 2020 The SkyWater PDK Authors
*
* Licensed under the Apache License, Version 2.0 (the "License");
* you may not use this file except in compliance with the License.
* You may obtain a copy of the License at
*
*     https:  www.apache.org licenses LICENSE-2.0
*
* Unless required by applicable law or agreed to in writing, software
* distributed under the License is distributed on an "AS IS" BASIS,
* WITHOUT WARRANTIES OR CONDITIONS OF ANY KIND, either express or implied.
* See the License for the specific language governing permissions and
* limitations under the License.
*
* SPDX-License-Identifier: Apache-2.0

.SUBCKT sky130_fd_sc_hd__o41ai_2 A1 A2 A3 A4 B1 VGND VNB VNB net59 Y
*.PININFO A1:I A2:I A3:I A4:I B1:I VGND:I VNB:I VNB:I net59:I Y:O
MMPA0 net59 A1 sndA1 VNB sky130_fd_pr__pfet_01v8_hvt m=2 w=1.0u l=0.15u mult=1 sa=0.265
+ sb=0.265 sd=0.28 area=0.063 perim=1.14
MMPA1 sndA1 A2 sndA2 VNB sky130_fd_pr__pfet_01v8_hvt m=2 w=1.0u l=0.15u mult=1
+ sa=0.265 sb=0.265 sd=0.28 area=0.063 perim=1.14
MMPA2 sndA2 A3 sndA3 VNB sky130_fd_pr__pfet_01v8_hvt m=2 w=1.0u l=0.15u mult=1
+ sa=0.265 sb=0.265 sd=0.28 area=0.063 perim=1.14
MMPA3 sndA3 A4 Y VNB sky130_fd_pr__pfet_01v8_hvt m=2 w=1.0u l=0.15u mult=1 sa=0.265
+ sb=0.265 sd=0.28 area=0.063 perim=1.14
MMPB0 net59 B1 Y VNB sky130_fd_pr__pfet_01v8_hvt m=2 w=1.0u l=0.15u mult=1 sa=0.265
+ sb=0.265 sd=0.28 area=0.063 perim=1.14
MMNA0 pndA A1 VGND VNB sky130_fd_pr__nfet_01v8 m=2 w=0.65u l=0.15u mult=1 sa=0.265
+ sb=0.265 sd=0.28 area=0.063 perim=1.14
MMNA1 pndA A2 VGND VNB sky130_fd_pr__nfet_01v8 m=2 w=0.65u l=0.15u mult=1 sa=0.265
+ sb=0.265 sd=0.28 area=0.063 perim=1.14
MMNA2 pndA A3 VGND VNB sky130_fd_pr__nfet_01v8 m=2 w=0.65u l=0.15u mult=1 sa=0.265
+ sb=0.265 sd=0.28 area=0.063 perim=1.14
MMNA3 pndA A4 VGND VNB sky130_fd_pr__nfet_01v8 m=2 w=0.65u l=0.15u mult=1 sa=0.265
+ sb=0.265 sd=0.28 area=0.063 perim=1.14
MMNB0 Y B1 pndA VNB sky130_fd_pr__nfet_01v8 m=2 w=0.65u l=0.15u mult=1 sa=0.265
+ sb=0.265 sd=0.28 area=0.063 perim=1.14
.ENDS sky130_fd_sc_hd__o41ai_2
* Copyright 2020 The SkyWater PDK Authors
*
* Licensed under the Apache License, Version 2.0 (the "License");
* you may not use this file except in compliance with the License.
* You may obtain a copy of the License at
*
*     https:  www.apache.org licenses LICENSE-2.0
*
* Unless required by applicable law or agreed to in writing, software
* distributed under the License is distributed on an "AS IS" BASIS,
* WITHOUT WARRANTIES OR CONDITIONS OF ANY KIND, either express or implied.
* See the License for the specific language governing permissions and
* limitations under the License.
*
* SPDX-License-Identifier: Apache-2.0

.SUBCKT sky130_fd_sc_hd__o41ai_4 A1 A2 A3 A4 B1 VGND VNB VNB net59 Y
*.PININFO A1:I A2:I A3:I A4:I B1:I VGND:I VNB:I VNB:I net59:I Y:O
MMPA0 net59 A1 sndA1 VNB sky130_fd_pr__pfet_01v8_hvt m=4 w=1.0u l=0.15u mult=1 sa=0.265
+ sb=0.265 sd=0.28 area=0.063 perim=1.14
MMPA1 sndA1 A2 sndA2 VNB sky130_fd_pr__pfet_01v8_hvt m=4 w=1.0u l=0.15u mult=1
+ sa=0.265 sb=0.265 sd=0.28 area=0.063 perim=1.14
MMPA2 sndA2 A3 sndA3 VNB sky130_fd_pr__pfet_01v8_hvt m=4 w=1.0u l=0.15u mult=1
+ sa=0.265 sb=0.265 sd=0.28 area=0.063 perim=1.14
MMPA3 sndA3 A4 Y VNB sky130_fd_pr__pfet_01v8_hvt m=4 w=1.0u l=0.15u mult=1 sa=0.265
+ sb=0.265 sd=0.28 area=0.063 perim=1.14
MMPB0 net59 B1 Y VNB sky130_fd_pr__pfet_01v8_hvt m=4 w=1.0u l=0.15u mult=1 sa=0.265
+ sb=0.265 sd=0.28 area=0.063 perim=1.14
MMNA0 pndA A1 VGND VNB sky130_fd_pr__nfet_01v8 m=4 w=0.65u l=0.15u mult=1 sa=0.265
+ sb=0.265 sd=0.28 area=0.063 perim=1.14
MMNA1 pndA A2 VGND VNB sky130_fd_pr__nfet_01v8 m=4 w=0.65u l=0.15u mult=1 sa=0.265
+ sb=0.265 sd=0.28 area=0.063 perim=1.14
MMNA2 pndA A3 VGND VNB sky130_fd_pr__nfet_01v8 m=4 w=0.65u l=0.15u mult=1 sa=0.265
+ sb=0.265 sd=0.28 area=0.063 perim=1.14
MMNA3 pndA A4 VGND VNB sky130_fd_pr__nfet_01v8 m=4 w=0.65u l=0.15u mult=1 sa=0.265
+ sb=0.265 sd=0.28 area=0.063 perim=1.14
MMNB0 Y B1 pndA VNB sky130_fd_pr__nfet_01v8 m=4 w=0.65u l=0.15u mult=1 sa=0.265
+ sb=0.265 sd=0.28 area=0.063 perim=1.14
.ENDS sky130_fd_sc_hd__o41ai_4
* Copyright 2020 The SkyWater PDK Authors
*
* Licensed under the Apache License, Version 2.0 (the "License");
* you may not use this file except in compliance with the License.
* You may obtain a copy of the License at
*
*     https:  www.apache.org licenses LICENSE-2.0
*
* Unless required by applicable law or agreed to in writing, software
* distributed under the License is distributed on an "AS IS" BASIS,
* WITHOUT WARRANTIES OR CONDITIONS OF ANY KIND, either express or implied.
* See the License for the specific language governing permissions and
* limitations under the License.
*
* SPDX-License-Identifier: Apache-2.0

.SUBCKT sky130_fd_sc_hd__or2_0 A B VGND VNB VNB net59 X
*.PININFO A:I B:I VGND:I VNB:I VNB:I net59:I X:O
MMP0 net59 A sndPA VNB sky130_fd_pr__pfet_01v8_hvt m=1 w=0.42u l=0.15u mult=1 sa=0.265
+ sb=0.265 sd=0.28 area=0.063 perim=1.14
MMP1 sndPA B y VNB sky130_fd_pr__pfet_01v8_hvt m=1 w=0.42u l=0.15u mult=1 sa=0.265
+ sb=0.265 sd=0.28 area=0.063 perim=1.14
MMIP2 X y net59 VNB sky130_fd_pr__pfet_01v8_hvt m=1 w=0.64u l=0.15u mult=1 sa=0.265
+ sb=0.265 sd=0.28 area=0.063 perim=1.14
MMN0 y A VGND VNB sky130_fd_pr__nfet_01v8 m=1 w=0.42u l=0.15u mult=1 sa=0.265 sb=0.265
+ sd=0.28 area=0.063 perim=1.14
MMN1 y B VGND VNB sky130_fd_pr__nfet_01v8 m=1 w=0.42u l=0.15u mult=1 sa=0.265 sb=0.265
+ sd=0.28 area=0.063 perim=1.14
MMIN2 X y VGND VNB sky130_fd_pr__nfet_01v8 m=1 w=0.42u l=0.15u mult=1 sa=0.265
+ sb=0.265 sd=0.28 area=0.063 perim=1.14
.ENDS sky130_fd_sc_hd__or2_0
* Copyright 2020 The SkyWater PDK Authors
*
* Licensed under the Apache License, Version 2.0 (the "License");
* you may not use this file except in compliance with the License.
* You may obtain a copy of the License at
*
*     https:  www.apache.org licenses LICENSE-2.0
*
* Unless required by applicable law or agreed to in writing, software
* distributed under the License is distributed on an "AS IS" BASIS,
* WITHOUT WARRANTIES OR CONDITIONS OF ANY KIND, either express or implied.
* See the License for the specific language governing permissions and
* limitations under the License.
*
* SPDX-License-Identifier: Apache-2.0

.SUBCKT sky130_fd_sc_hd__or2_1 A B VGND VNB VNB net59 X
*.PININFO A:I B:I VGND:I VNB:I VNB:I net59:I X:O
MMP0 net59 A sndPA VNB sky130_fd_pr__pfet_01v8_hvt m=1 w=0.42u l=0.15u mult=1 sa=0.265
+ sb=0.265 sd=0.28 area=0.063 perim=1.14
MMP1 sndPA B y VNB sky130_fd_pr__pfet_01v8_hvt m=1 w=0.42u l=0.15u mult=1 sa=0.265
+ sb=0.265 sd=0.28 area=0.063 perim=1.14
MMIP2 X y net59 VNB sky130_fd_pr__pfet_01v8_hvt m=1 w=1.0u l=0.15u mult=1 sa=0.265
+ sb=0.265 sd=0.28 area=0.063 perim=1.14
MMN0 y A VGND VNB sky130_fd_pr__nfet_01v8 m=1 w=0.42u l=0.15u mult=1 sa=0.265 sb=0.265
+ sd=0.28 area=0.063 perim=1.14
MMN1 y B VGND VNB sky130_fd_pr__nfet_01v8 m=1 w=0.42u l=0.15u mult=1 sa=0.265 sb=0.265
+ sd=0.28 area=0.063 perim=1.14
MMIN2 X y VGND VNB sky130_fd_pr__nfet_01v8 m=1 w=0.65u l=0.15u mult=1 sa=0.265
+ sb=0.265 sd=0.28 area=0.063 perim=1.14
.ENDS sky130_fd_sc_hd__or2_1
* Copyright 2020 The SkyWater PDK Authors
*
* Licensed under the Apache License, Version 2.0 (the "License");
* you may not use this file except in compliance with the License.
* You may obtain a copy of the License at
*
*     https:  www.apache.org licenses LICENSE-2.0
*
* Unless required by applicable law or agreed to in writing, software
* distributed under the License is distributed on an "AS IS" BASIS,
* WITHOUT WARRANTIES OR CONDITIONS OF ANY KIND, either express or implied.
* See the License for the specific language governing permissions and
* limitations under the License.
*
* SPDX-License-Identifier: Apache-2.0

.SUBCKT sky130_fd_sc_hd__or2_2 A B VGND VNB VNB net59 X
*.PININFO A:I B:I VGND:I VNB:I VNB:I net59:I X:O
MMP0 net59 A sndPA VNB sky130_fd_pr__pfet_01v8_hvt m=1 w=0.42u l=0.15u mult=1 sa=0.265
+ sb=0.265 sd=0.28 area=0.063 perim=1.14
MMP1 sndPA B y VNB sky130_fd_pr__pfet_01v8_hvt m=1 w=0.42u l=0.15u mult=1 sa=0.265
+ sb=0.265 sd=0.28 area=0.063 perim=1.14
MMIP2 X y net59 VNB sky130_fd_pr__pfet_01v8_hvt m=2 w=1.0u l=0.15u mult=1 sa=0.265
+ sb=0.265 sd=0.28 area=0.063 perim=1.14
MMN0 y A VGND VNB sky130_fd_pr__nfet_01v8 m=1 w=0.42u l=0.15u mult=1 sa=0.265 sb=0.265
+ sd=0.28 area=0.063 perim=1.14
MMN1 y B VGND VNB sky130_fd_pr__nfet_01v8 m=1 w=0.42u l=0.15u mult=1 sa=0.265 sb=0.265
+ sd=0.28 area=0.063 perim=1.14
MMIN2 X y VGND VNB sky130_fd_pr__nfet_01v8 m=2 w=0.65u l=0.15u mult=1 sa=0.265
+ sb=0.265 sd=0.28 area=0.063 perim=1.14
.ENDS sky130_fd_sc_hd__or2_2
* Copyright 2020 The SkyWater PDK Authors
*
* Licensed under the Apache License, Version 2.0 (the "License");
* you may not use this file except in compliance with the License.
* You may obtain a copy of the License at
*
*     https:  www.apache.org licenses LICENSE-2.0
*
* Unless required by applicable law or agreed to in writing, software
* distributed under the License is distributed on an "AS IS" BASIS,
* WITHOUT WARRANTIES OR CONDITIONS OF ANY KIND, either express or implied.
* See the License for the specific language governing permissions and
* limitations under the License.
*
* SPDX-License-Identifier: Apache-2.0

.SUBCKT sky130_fd_sc_hd__or2_4 A B VGND VNB VNB net59 X
*.PININFO A:I B:I VGND:I VNB:I VNB:I net59:I X:O
MMP0 net59 A sndPA VNB sky130_fd_pr__pfet_01v8_hvt m=1 w=1.0u l=0.15u mult=1 sa=0.265
+ sb=0.265 sd=0.28 area=0.063 perim=1.14
MMP1 sndPA B y VNB sky130_fd_pr__pfet_01v8_hvt m=1 w=1.0u l=0.15u mult=1 sa=0.265
+ sb=0.265 sd=0.28 area=0.063 perim=1.14
MMIP2 X y net59 VNB sky130_fd_pr__pfet_01v8_hvt m=4 w=1.0u l=0.15u mult=1 sa=0.265
+ sb=0.265 sd=0.28 area=0.063 perim=1.14
MMN0 y A VGND VNB sky130_fd_pr__nfet_01v8 m=1 w=0.65u l=0.15u mult=1 sa=0.265 sb=0.265
+ sd=0.28 area=0.063 perim=1.14
MMN1 y B VGND VNB sky130_fd_pr__nfet_01v8 m=1 w=0.65u l=0.15u mult=1 sa=0.265 sb=0.265
+ sd=0.28 area=0.063 perim=1.14
MMIN2 X y VGND VNB sky130_fd_pr__nfet_01v8 m=4 w=0.65u l=0.15u mult=1 sa=0.265
+ sb=0.265 sd=0.28 area=0.063 perim=1.14
.ENDS sky130_fd_sc_hd__or2_4
* Copyright 2020 The SkyWater PDK Authors
*
* Licensed under the Apache License, Version 2.0 (the "License");
* you may not use this file except in compliance with the License.
* You may obtain a copy of the License at
*
*     https:  www.apache.org licenses LICENSE-2.0
*
* Unless required by applicable law or agreed to in writing, software
* distributed under the License is distributed on an "AS IS" BASIS,
* WITHOUT WARRANTIES OR CONDITIONS OF ANY KIND, either express or implied.
* See the License for the specific language governing permissions and
* limitations under the License.
*
* SPDX-License-Identifier: Apache-2.0

.SUBCKT sky130_fd_sc_hd__or2b_1 A B_N VGND VNB VNB net59 X
*.PININFO A:I B_N:I VGND:I VNB:I VNB:I net59:I X:O
MMP0 net59 A sndPA VNB sky130_fd_pr__pfet_01v8_hvt m=1 w=0.42u l=0.15u mult=1 sa=0.265
+ sb=0.265 sd=0.28 area=0.063 perim=1.14
MMP1 sndPA B y VNB sky130_fd_pr__pfet_01v8_hvt m=1 w=0.42u l=0.15u mult=1 sa=0.265
+ sb=0.265 sd=0.28 area=0.063 perim=1.14
MMIP1 B B_N net59 VNB sky130_fd_pr__pfet_01v8_hvt m=1 w=0.42u l=0.15u mult=1 sa=0.265
+ sb=0.265 sd=0.28 area=0.063 perim=1.14
MMIP2 X y net59 VNB sky130_fd_pr__pfet_01v8_hvt m=1 w=1.0u l=0.15u mult=1 sa=0.265
+ sb=0.265 sd=0.28 area=0.063 perim=1.14
MMN0 y A VGND VNB sky130_fd_pr__nfet_01v8 m=1 w=0.42u l=0.15u mult=1 sa=0.265 sb=0.265
+ sd=0.28 area=0.063 perim=1.14
MMN1 y B VGND VNB sky130_fd_pr__nfet_01v8 m=1 w=0.42u l=0.15u mult=1 sa=0.265 sb=0.265
+ sd=0.28 area=0.063 perim=1.14
MMIN1 B B_N VGND VNB sky130_fd_pr__nfet_01v8 m=1 w=0.42u l=0.15u mult=1 sa=0.265
+ sb=0.265 sd=0.28 area=0.063 perim=1.14
MMIN2 X y VGND VNB sky130_fd_pr__nfet_01v8 m=1 w=0.65u l=0.15u mult=1 sa=0.265
+ sb=0.265 sd=0.28 area=0.063 perim=1.14
.ENDS sky130_fd_sc_hd__or2b_1
* Copyright 2020 The SkyWater PDK Authors
*
* Licensed under the Apache License, Version 2.0 (the "License");
* you may not use this file except in compliance with the License.
* You may obtain a copy of the License at
*
*     https:  www.apache.org licenses LICENSE-2.0
*
* Unless required by applicable law or agreed to in writing, software
* distributed under the License is distributed on an "AS IS" BASIS,
* WITHOUT WARRANTIES OR CONDITIONS OF ANY KIND, either express or implied.
* See the License for the specific language governing permissions and
* limitations under the License.
*
* SPDX-License-Identifier: Apache-2.0

.SUBCKT sky130_fd_sc_hd__or2b_2 A B_N VGND VNB VNB net59 X
*.PININFO A:I B_N:I VGND:I VNB:I VNB:I net59:I X:O
MMP0 net59 A sndPA VNB sky130_fd_pr__pfet_01v8_hvt m=1 w=0.42u l=0.15u mult=1 sa=0.265
+ sb=0.265 sd=0.28 area=0.063 perim=1.14
MMP1 sndPA B y VNB sky130_fd_pr__pfet_01v8_hvt m=1 w=0.42u l=0.15u mult=1 sa=0.265
+ sb=0.265 sd=0.28 area=0.063 perim=1.14
MMIP1 B B_N net59 VNB sky130_fd_pr__pfet_01v8_hvt m=1 w=0.42u l=0.15u mult=1 sa=0.265
+ sb=0.265 sd=0.28 area=0.063 perim=1.14
MMIP2 X y net59 VNB sky130_fd_pr__pfet_01v8_hvt m=2 w=1.0u l=0.15u mult=1 sa=0.265
+ sb=0.265 sd=0.28 area=0.063 perim=1.14
MMN0 y A VGND VNB sky130_fd_pr__nfet_01v8 m=1 w=0.42u l=0.15u mult=1 sa=0.265 sb=0.265
+ sd=0.28 area=0.063 perim=1.14
MMN1 y B VGND VNB sky130_fd_pr__nfet_01v8 m=1 w=0.42u l=0.15u mult=1 sa=0.265 sb=0.265
+ sd=0.28 area=0.063 perim=1.14
MMIN1 B B_N VGND VNB sky130_fd_pr__nfet_01v8 m=1 w=0.42u l=0.15u mult=1 sa=0.265
+ sb=0.265 sd=0.28 area=0.063 perim=1.14
MMIN2 X y VGND VNB sky130_fd_pr__nfet_01v8 m=2 w=0.65u l=0.15u mult=1 sa=0.265
+ sb=0.265 sd=0.28 area=0.063 perim=1.14
.ENDS sky130_fd_sc_hd__or2b_2
* Copyright 2020 The SkyWater PDK Authors
*
* Licensed under the Apache License, Version 2.0 (the "License");
* you may not use this file except in compliance with the License.
* You may obtain a copy of the License at
*
*     https:  www.apache.org licenses LICENSE-2.0
*
* Unless required by applicable law or agreed to in writing, software
* distributed under the License is distributed on an "AS IS" BASIS,
* WITHOUT WARRANTIES OR CONDITIONS OF ANY KIND, either express or implied.
* See the License for the specific language governing permissions and
* limitations under the License.
*
* SPDX-License-Identifier: Apache-2.0

.SUBCKT sky130_fd_sc_hd__or2b_4 A B_N VGND VNB VNB net59 X
*.PININFO A:I B_N:I VGND:I VNB:I VNB:I net59:I X:O
MMP0 net59 A sndPA VNB sky130_fd_pr__pfet_01v8_hvt m=1 w=1.0u l=0.15u mult=1 sa=0.265
+ sb=0.265 sd=0.28 area=0.063 perim=1.14
MMP1 sndPA B y VNB sky130_fd_pr__pfet_01v8_hvt m=1 w=1.0u l=0.15u mult=1 sa=0.265
+ sb=0.265 sd=0.28 area=0.063 perim=1.14
MMIP1 B B_N net59 VNB sky130_fd_pr__pfet_01v8_hvt m=1 w=0.42u l=0.15u mult=1 sa=0.265
+ sb=0.265 sd=0.28 area=0.063 perim=1.14
MMIP2 X y net59 VNB sky130_fd_pr__pfet_01v8_hvt m=4 w=1.0u l=0.15u mult=1 sa=0.265
+ sb=0.265 sd=0.28 area=0.063 perim=1.14
MMN0 y A VGND VNB sky130_fd_pr__nfet_01v8 m=1 w=0.65u l=0.15u mult=1 sa=0.265 sb=0.265
+ sd=0.28 area=0.063 perim=1.14
MMN1 y B VGND VNB sky130_fd_pr__nfet_01v8 m=1 w=0.65u l=0.15u mult=1 sa=0.265 sb=0.265
+ sd=0.28 area=0.063 perim=1.14
MMIN1 B B_N VGND VNB sky130_fd_pr__nfet_01v8 m=1 w=0.42u l=0.15u mult=1 sa=0.265
+ sb=0.265 sd=0.28 area=0.063 perim=1.14
MMIN2 X y VGND VNB sky130_fd_pr__nfet_01v8 m=4 w=0.65u l=0.15u mult=1 sa=0.265
+ sb=0.265 sd=0.28 area=0.063 perim=1.14
.ENDS sky130_fd_sc_hd__or2b_4
* Copyright 2020 The SkyWater PDK Authors
*
* Licensed under the Apache License, Version 2.0 (the "License");
* you may not use this file except in compliance with the License.
* You may obtain a copy of the License at
*
*     https:  www.apache.org licenses LICENSE-2.0
*
* Unless required by applicable law or agreed to in writing, software
* distributed under the License is distributed on an "AS IS" BASIS,
* WITHOUT WARRANTIES OR CONDITIONS OF ANY KIND, either express or implied.
* See the License for the specific language governing permissions and
* limitations under the License.
*
* SPDX-License-Identifier: Apache-2.0

.SUBCKT sky130_fd_sc_hd__or3_1 A B C VGND VNB VNB net59 X
*.PININFO A:I B:I C:I VGND:I VNB:I VNB:I net59:I X:O
MMP0 net59 A sndPA VNB sky130_fd_pr__pfet_01v8_hvt m=1 w=0.42u l=0.15u mult=1 sa=0.265
+ sb=0.265 sd=0.28 area=0.063 perim=1.14
MMP1 sndPA B sndPB VNB sky130_fd_pr__pfet_01v8_hvt m=1 w=0.42u l=0.15u mult=1 sa=0.265
+ sb=0.265 sd=0.28 area=0.063 perim=1.14
MMP2 sndPB C y VNB sky130_fd_pr__pfet_01v8_hvt m=1 w=0.42u l=0.15u mult=1 sa=0.265
+ sb=0.265 sd=0.28 area=0.063 perim=1.14
MMIP3 X y net59 VNB sky130_fd_pr__pfet_01v8_hvt m=1 w=1.0u l=0.15u mult=1 sa=0.265
+ sb=0.265 sd=0.28 area=0.063 perim=1.14
MMN0 y A VGND VNB sky130_fd_pr__nfet_01v8 m=1 w=0.42u l=0.15u mult=1 sa=0.265 sb=0.265
+ sd=0.28 area=0.063 perim=1.14
MMN1 y B VGND VNB sky130_fd_pr__nfet_01v8 m=1 w=0.42u l=0.15u mult=1 sa=0.265 sb=0.265
+ sd=0.28 area=0.063 perim=1.14
MMN2 y C VGND VNB sky130_fd_pr__nfet_01v8 m=1 w=0.42u l=0.15u mult=1 sa=0.265 sb=0.265
+ sd=0.28 area=0.063 perim=1.14
MMIN3 X y VGND VNB sky130_fd_pr__nfet_01v8 m=1 w=0.65u l=0.15u mult=1 sa=0.265
+ sb=0.265 sd=0.28 area=0.063 perim=1.14
.ENDS sky130_fd_sc_hd__or3_1
* Copyright 2020 The SkyWater PDK Authors
*
* Licensed under the Apache License, Version 2.0 (the "License");
* you may not use this file except in compliance with the License.
* You may obtain a copy of the License at
*
*     https:  www.apache.org licenses LICENSE-2.0
*
* Unless required by applicable law or agreed to in writing, software
* distributed under the License is distributed on an "AS IS" BASIS,
* WITHOUT WARRANTIES OR CONDITIONS OF ANY KIND, either express or implied.
* See the License for the specific language governing permissions and
* limitations under the License.
*
* SPDX-License-Identifier: Apache-2.0

.SUBCKT sky130_fd_sc_hd__or3_2 A B C VGND VNB VNB net59 X
*.PININFO A:I B:I C:I VGND:I VNB:I VNB:I net59:I X:O
MMP0 net59 A sndPA VNB sky130_fd_pr__pfet_01v8_hvt m=1 w=0.42u l=0.15u mult=1 sa=0.265
+ sb=0.265 sd=0.28 area=0.063 perim=1.14
MMP1 sndPA B sndPB VNB sky130_fd_pr__pfet_01v8_hvt m=1 w=0.42u l=0.15u mult=1 sa=0.265
+ sb=0.265 sd=0.28 area=0.063 perim=1.14
MMP2 sndPB C y VNB sky130_fd_pr__pfet_01v8_hvt m=1 w=0.42u l=0.15u mult=1 sa=0.265
+ sb=0.265 sd=0.28 area=0.063 perim=1.14
MMIP3 X y net59 VNB sky130_fd_pr__pfet_01v8_hvt m=2 w=1.0u l=0.15u mult=1 sa=0.265
+ sb=0.265 sd=0.28 area=0.063 perim=1.14
MMN0 y A VGND VNB sky130_fd_pr__nfet_01v8 m=1 w=0.42u l=0.15u mult=1 sa=0.265 sb=0.265
+ sd=0.28 area=0.063 perim=1.14
MMN1 y B VGND VNB sky130_fd_pr__nfet_01v8 m=1 w=0.42u l=0.15u mult=1 sa=0.265 sb=0.265
+ sd=0.28 area=0.063 perim=1.14
MMN2 y C VGND VNB sky130_fd_pr__nfet_01v8 m=1 w=0.42u l=0.15u mult=1 sa=0.265 sb=0.265
+ sd=0.28 area=0.063 perim=1.14
MMIN3 X y VGND VNB sky130_fd_pr__nfet_01v8 m=2 w=0.65u l=0.15u mult=1 sa=0.265
+ sb=0.265 sd=0.28 area=0.063 perim=1.14
.ENDS sky130_fd_sc_hd__or3_2
* Copyright 2020 The SkyWater PDK Authors
*
* Licensed under the Apache License, Version 2.0 (the "License");
* you may not use this file except in compliance with the License.
* You may obtain a copy of the License at
*
*     https:  www.apache.org licenses LICENSE-2.0
*
* Unless required by applicable law or agreed to in writing, software
* distributed under the License is distributed on an "AS IS" BASIS,
* WITHOUT WARRANTIES OR CONDITIONS OF ANY KIND, either express or implied.
* See the License for the specific language governing permissions and
* limitations under the License.
*
* SPDX-License-Identifier: Apache-2.0

.SUBCKT sky130_fd_sc_hd__or3_4 A B C VGND VNB VNB net59 X
*.PININFO A:I B:I C:I VGND:I VNB:I VNB:I net59:I X:O
MMP0 net59 A sndPA VNB sky130_fd_pr__pfet_01v8_hvt m=1 w=1.0u l=0.15u mult=1 sa=0.265
+ sb=0.265 sd=0.28 area=0.063 perim=1.14
MMP1 sndPA B sndPB VNB sky130_fd_pr__pfet_01v8_hvt m=1 w=1.0u l=0.15u mult=1 sa=0.265
+ sb=0.265 sd=0.28 area=0.063 perim=1.14
MMP2 sndPB C y VNB sky130_fd_pr__pfet_01v8_hvt m=1 w=1.0u l=0.15u mult=1 sa=0.265
+ sb=0.265 sd=0.28 area=0.063 perim=1.14
MMIP3 X y net59 VNB sky130_fd_pr__pfet_01v8_hvt m=4 w=1.0u l=0.15u mult=1 sa=0.265
+ sb=0.265 sd=0.28 area=0.063 perim=1.14
MMN0 y A VGND VNB sky130_fd_pr__nfet_01v8 m=1 w=0.65u l=0.15u mult=1 sa=0.265 sb=0.265
+ sd=0.28 area=0.063 perim=1.14
MMN1 y B VGND VNB sky130_fd_pr__nfet_01v8 m=1 w=0.65u l=0.15u mult=1 sa=0.265 sb=0.265
+ sd=0.28 area=0.063 perim=1.14
MMN2 y C VGND VNB sky130_fd_pr__nfet_01v8 m=1 w=0.65u l=0.15u mult=1 sa=0.265 sb=0.265
+ sd=0.28 area=0.063 perim=1.14
MMIN3 X y VGND VNB sky130_fd_pr__nfet_01v8 m=4 w=0.65u l=0.15u mult=1 sa=0.265
+ sb=0.265 sd=0.28 area=0.063 perim=1.14
.ENDS sky130_fd_sc_hd__or3_4
* Copyright 2020 The SkyWater PDK Authors
*
* Licensed under the Apache License, Version 2.0 (the "License");
* you may not use this file except in compliance with the License.
* You may obtain a copy of the License at
*
*     https:  www.apache.org licenses LICENSE-2.0
*
* Unless required by applicable law or agreed to in writing, software
* distributed under the License is distributed on an "AS IS" BASIS,
* WITHOUT WARRANTIES OR CONDITIONS OF ANY KIND, either express or implied.
* See the License for the specific language governing permissions and
* limitations under the License.
*
* SPDX-License-Identifier: Apache-2.0

.SUBCKT sky130_fd_sc_hd__or3b_1 A B C_N VGND VNB VNB net59 X
*.PININFO A:I B:I C_N:I VGND:I VNB:I VNB:I net59:I X:O
MMP0 net59 A sndPA VNB sky130_fd_pr__pfet_01v8_hvt m=1 w=0.42u l=0.15u mult=1 sa=0.265
+ sb=0.265 sd=0.28 area=0.063 perim=1.14
MMP1 sndPA B sndPB VNB sky130_fd_pr__pfet_01v8_hvt m=1 w=0.42u l=0.15u mult=1 sa=0.265
+ sb=0.265 sd=0.28 area=0.063 perim=1.14
MMP2 sndPB C y VNB sky130_fd_pr__pfet_01v8_hvt m=1 w=0.42u l=0.15u mult=1 sa=0.265
+ sb=0.265 sd=0.28 area=0.063 perim=1.14
MMIP2 C C_N net59 VNB sky130_fd_pr__pfet_01v8_hvt m=1 w=0.42u l=0.15u mult=1 sa=0.265
+ sb=0.265 sd=0.28 area=0.063 perim=1.14
MMIP3 X y net59 VNB sky130_fd_pr__pfet_01v8_hvt m=1 w=1.0u l=0.15u mult=1 sa=0.265
+ sb=0.265 sd=0.28 area=0.063 perim=1.14
MMN0 y A VGND VNB sky130_fd_pr__nfet_01v8 m=1 w=0.42u l=0.15u mult=1 sa=0.265 sb=0.265
+ sd=0.28 area=0.063 perim=1.14
MMN1 y B VGND VNB sky130_fd_pr__nfet_01v8 m=1 w=0.42u l=0.15u mult=1 sa=0.265 sb=0.265
+ sd=0.28 area=0.063 perim=1.14
MMN2 y C VGND VNB sky130_fd_pr__nfet_01v8 m=1 w=0.42u l=0.15u mult=1 sa=0.265 sb=0.265
+ sd=0.28 area=0.063 perim=1.14
MMIN2 C C_N VGND VNB sky130_fd_pr__nfet_01v8 m=1 w=0.42u l=0.15u mult=1 sa=0.265
+ sb=0.265 sd=0.28 area=0.063 perim=1.14
MMIN3 X y VGND VNB sky130_fd_pr__nfet_01v8 m=1 w=0.65u l=0.15u mult=1 sa=0.265
+ sb=0.265 sd=0.28 area=0.063 perim=1.14
.ENDS sky130_fd_sc_hd__or3b_1
* Copyright 2020 The SkyWater PDK Authors
*
* Licensed under the Apache License, Version 2.0 (the "License");
* you may not use this file except in compliance with the License.
* You may obtain a copy of the License at
*
*     https:  www.apache.org licenses LICENSE-2.0
*
* Unless required by applicable law or agreed to in writing, software
* distributed under the License is distributed on an "AS IS" BASIS,
* WITHOUT WARRANTIES OR CONDITIONS OF ANY KIND, either express or implied.
* See the License for the specific language governing permissions and
* limitations under the License.
*
* SPDX-License-Identifier: Apache-2.0

.SUBCKT sky130_fd_sc_hd__or3b_2 A B C_N VGND VNB VNB net59 X
*.PININFO A:I B:I C_N:I VGND:I VNB:I VNB:I net59:I X:O
MMP0 net59 A sndPA VNB sky130_fd_pr__pfet_01v8_hvt m=1 w=0.42u l=0.15u mult=1 sa=0.265
+ sb=0.265 sd=0.28 area=0.063 perim=1.14
MMP1 sndPA B sndPB VNB sky130_fd_pr__pfet_01v8_hvt m=1 w=0.42u l=0.15u mult=1 sa=0.265
+ sb=0.265 sd=0.28 area=0.063 perim=1.14
MMP2 sndPB C y VNB sky130_fd_pr__pfet_01v8_hvt m=1 w=0.42u l=0.15u mult=1 sa=0.265
+ sb=0.265 sd=0.28 area=0.063 perim=1.14
MMIP2 C C_N net59 VNB sky130_fd_pr__pfet_01v8_hvt m=1 w=0.42u l=0.15u mult=1 sa=0.265
+ sb=0.265 sd=0.28 area=0.063 perim=1.14
MMIP3 X y net59 VNB sky130_fd_pr__pfet_01v8_hvt m=2 w=1.0u l=0.15u mult=1 sa=0.265
+ sb=0.265 sd=0.28 area=0.063 perim=1.14
MMN0 y A VGND VNB sky130_fd_pr__nfet_01v8 m=1 w=0.42u l=0.15u mult=1 sa=0.265 sb=0.265
+ sd=0.28 area=0.063 perim=1.14
MMN1 y B VGND VNB sky130_fd_pr__nfet_01v8 m=1 w=0.42u l=0.15u mult=1 sa=0.265 sb=0.265
+ sd=0.28 area=0.063 perim=1.14
MMN2 y C VGND VNB sky130_fd_pr__nfet_01v8 m=1 w=0.42u l=0.15u mult=1 sa=0.265 sb=0.265
+ sd=0.28 area=0.063 perim=1.14
MMIN2 C C_N VGND VNB sky130_fd_pr__nfet_01v8 m=1 w=0.42u l=0.15u mult=1 sa=0.265
+ sb=0.265 sd=0.28 area=0.063 perim=1.14
MMIN3 X y VGND VNB sky130_fd_pr__nfet_01v8 m=2 w=0.65u l=0.15u mult=1 sa=0.265
+ sb=0.265 sd=0.28 area=0.063 perim=1.14
.ENDS sky130_fd_sc_hd__or3b_2
* Copyright 2020 The SkyWater PDK Authors
*
* Licensed under the Apache License, Version 2.0 (the "License");
* you may not use this file except in compliance with the License.
* You may obtain a copy of the License at
*
*     https:  www.apache.org licenses LICENSE-2.0
*
* Unless required by applicable law or agreed to in writing, software
* distributed under the License is distributed on an "AS IS" BASIS,
* WITHOUT WARRANTIES OR CONDITIONS OF ANY KIND, either express or implied.
* See the License for the specific language governing permissions and
* limitations under the License.
*
* SPDX-License-Identifier: Apache-2.0

.SUBCKT sky130_fd_sc_hd__or3b_4 A B C_N VGND VNB VNB net59 X
*.PININFO A:I B:I C_N:I VGND:I VNB:I VNB:I net59:I X:O
MMP0 net59 A sndPA VNB sky130_fd_pr__pfet_01v8_hvt m=1 w=1.0u l=0.15u mult=1 sa=0.265
+ sb=0.265 sd=0.28 area=0.063 perim=1.14
MMP1 sndPA B sndPB VNB sky130_fd_pr__pfet_01v8_hvt m=1 w=1.0u l=0.15u mult=1 sa=0.265
+ sb=0.265 sd=0.28 area=0.063 perim=1.14
MMP2 sndPB C y VNB sky130_fd_pr__pfet_01v8_hvt m=1 w=1.0u l=0.15u mult=1 sa=0.265
+ sb=0.265 sd=0.28 area=0.063 perim=1.14
MMIP2 C C_N net59 VNB sky130_fd_pr__pfet_01v8_hvt m=1 w=0.42u l=0.15u mult=1 sa=0.265
+ sb=0.265 sd=0.28 area=0.063 perim=1.14
MMIP3 X y net59 VNB sky130_fd_pr__pfet_01v8_hvt m=4 w=1.0u l=0.15u mult=1 sa=0.265
+ sb=0.265 sd=0.28 area=0.063 perim=1.14
MMN0 y A VGND VNB sky130_fd_pr__nfet_01v8 m=1 w=0.65u l=0.15u mult=1 sa=0.265 sb=0.265
+ sd=0.28 area=0.063 perim=1.14
MMN1 y B VGND VNB sky130_fd_pr__nfet_01v8 m=1 w=0.65u l=0.15u mult=1 sa=0.265 sb=0.265
+ sd=0.28 area=0.063 perim=1.14
MMN2 y C VGND VNB sky130_fd_pr__nfet_01v8 m=1 w=0.65u l=0.15u mult=1 sa=0.265 sb=0.265
+ sd=0.28 area=0.063 perim=1.14
MMIN2 C C_N VGND VNB sky130_fd_pr__nfet_01v8 m=1 w=0.42u l=0.15u mult=1 sa=0.265
+ sb=0.265 sd=0.28 area=0.063 perim=1.14
MMIN3 X y VGND VNB sky130_fd_pr__nfet_01v8 m=4 w=0.65u l=0.15u mult=1 sa=0.265
+ sb=0.265 sd=0.28 area=0.063 perim=1.14
.ENDS sky130_fd_sc_hd__or3b_4
* Copyright 2020 The SkyWater PDK Authors
*
* Licensed under the Apache License, Version 2.0 (the "License");
* you may not use this file except in compliance with the License.
* You may obtain a copy of the License at
*
*     https:  www.apache.org licenses LICENSE-2.0
*
* Unless required by applicable law or agreed to in writing, software
* distributed under the License is distributed on an "AS IS" BASIS,
* WITHOUT WARRANTIES OR CONDITIONS OF ANY KIND, either express or implied.
* See the License for the specific language governing permissions and
* limitations under the License.
*
* SPDX-License-Identifier: Apache-2.0

.SUBCKT sky130_fd_sc_hd__or4_1 A B C D VGND VNB VNB net59 X
*.PININFO A:I B:I C:I D:I VGND:I VNB:I VNB:I net59:I X:O
MMP0 net59 A sndPA VNB sky130_fd_pr__pfet_01v8_hvt m=1 w=0.42u l=0.15u mult=1 sa=0.265
+ sb=0.265 sd=0.28 area=0.063 perim=1.14
MMP1 sndPA B sndPB VNB sky130_fd_pr__pfet_01v8_hvt m=1 w=0.42u l=0.15u mult=1 sa=0.265
+ sb=0.265 sd=0.28 area=0.063 perim=1.14
MMP2 sndPB C sndPC VNB sky130_fd_pr__pfet_01v8_hvt m=1 w=0.42u l=0.15u mult=1 sa=0.265
+ sb=0.265 sd=0.28 area=0.063 perim=1.14
MMP3 sndPC D y VNB sky130_fd_pr__pfet_01v8_hvt m=1 w=0.42u l=0.15u mult=1 sa=0.265
+ sb=0.265 sd=0.28 area=0.063 perim=1.14
MMIP4 X y net59 VNB sky130_fd_pr__pfet_01v8_hvt m=1 w=1.0u l=0.15u mult=1 sa=0.265
+ sb=0.265 sd=0.28 area=0.063 perim=1.14
MMN0 y A VGND VNB sky130_fd_pr__nfet_01v8 m=1 w=0.42u l=0.15u mult=1 sa=0.265 sb=0.265
+ sd=0.28 area=0.063 perim=1.14
MMN1 y B VGND VNB sky130_fd_pr__nfet_01v8 m=1 w=0.42u l=0.15u mult=1 sa=0.265 sb=0.265
+ sd=0.28 area=0.063 perim=1.14
MMN2 y C VGND VNB sky130_fd_pr__nfet_01v8 m=1 w=0.42u l=0.15u mult=1 sa=0.265 sb=0.265
+ sd=0.28 area=0.063 perim=1.14
MMN3 y D VGND VNB sky130_fd_pr__nfet_01v8 m=1 w=0.42u l=0.15u mult=1 sa=0.265 sb=0.265
+ sd=0.28 area=0.063 perim=1.14
MMIN4 X y VGND VNB sky130_fd_pr__nfet_01v8 m=1 w=0.65u l=0.15u mult=1 sa=0.265
+ sb=0.265 sd=0.28 area=0.063 perim=1.14
.ENDS sky130_fd_sc_hd__or4_1
* Copyright 2020 The SkyWater PDK Authors
*
* Licensed under the Apache License, Version 2.0 (the "License");
* you may not use this file except in compliance with the License.
* You may obtain a copy of the License at
*
*     https:  www.apache.org licenses LICENSE-2.0
*
* Unless required by applicable law or agreed to in writing, software
* distributed under the License is distributed on an "AS IS" BASIS,
* WITHOUT WARRANTIES OR CONDITIONS OF ANY KIND, either express or implied.
* See the License for the specific language governing permissions and
* limitations under the License.
*
* SPDX-License-Identifier: Apache-2.0

.SUBCKT sky130_fd_sc_hd__or4_2 A B C D VGND VNB VNB net59 X
*.PININFO A:I B:I C:I D:I VGND:I VNB:I VNB:I net59:I X:O
MMP0 net59 A sndPA VNB sky130_fd_pr__pfet_01v8_hvt m=1 w=0.42u l=0.15u mult=1 sa=0.265
+ sb=0.265 sd=0.28 area=0.063 perim=1.14
MMP1 sndPA B sndPB VNB sky130_fd_pr__pfet_01v8_hvt m=1 w=0.42u l=0.15u mult=1 sa=0.265
+ sb=0.265 sd=0.28 area=0.063 perim=1.14
MMP2 sndPB C sndPC VNB sky130_fd_pr__pfet_01v8_hvt m=1 w=0.42u l=0.15u mult=1 sa=0.265
+ sb=0.265 sd=0.28 area=0.063 perim=1.14
MMP3 sndPC D y VNB sky130_fd_pr__pfet_01v8_hvt m=1 w=0.42u l=0.15u mult=1 sa=0.265
+ sb=0.265 sd=0.28 area=0.063 perim=1.14
MMIP4 X y net59 VNB sky130_fd_pr__pfet_01v8_hvt m=2 w=1.0u l=0.15u mult=1 sa=0.265
+ sb=0.265 sd=0.28 area=0.063 perim=1.14
MMN0 y A VGND VNB sky130_fd_pr__nfet_01v8 m=1 w=0.42u l=0.15u mult=1 sa=0.265 sb=0.265
+ sd=0.28 area=0.063 perim=1.14
MMN1 y B VGND VNB sky130_fd_pr__nfet_01v8 m=1 w=0.42u l=0.15u mult=1 sa=0.265 sb=0.265
+ sd=0.28 area=0.063 perim=1.14
MMN2 y C VGND VNB sky130_fd_pr__nfet_01v8 m=1 w=0.42u l=0.15u mult=1 sa=0.265 sb=0.265
+ sd=0.28 area=0.063 perim=1.14
MMN3 y D VGND VNB sky130_fd_pr__nfet_01v8 m=1 w=0.42u l=0.15u mult=1 sa=0.265 sb=0.265
+ sd=0.28 area=0.063 perim=1.14
MMIN4 X y VGND VNB sky130_fd_pr__nfet_01v8 m=2 w=0.65u l=0.15u mult=1 sa=0.265
+ sb=0.265 sd=0.28 area=0.063 perim=1.14
.ENDS sky130_fd_sc_hd__or4_2
* Copyright 2020 The SkyWater PDK Authors
*
* Licensed under the Apache License, Version 2.0 (the "License");
* you may not use this file except in compliance with the License.
* You may obtain a copy of the License at
*
*     https:  www.apache.org licenses LICENSE-2.0
*
* Unless required by applicable law or agreed to in writing, software
* distributed under the License is distributed on an "AS IS" BASIS,
* WITHOUT WARRANTIES OR CONDITIONS OF ANY KIND, either express or implied.
* See the License for the specific language governing permissions and
* limitations under the License.
*
* SPDX-License-Identifier: Apache-2.0

.SUBCKT sky130_fd_sc_hd__or4_4 A B C D VGND VNB VNB net59 X
*.PININFO A:I B:I C:I D:I VGND:I VNB:I VNB:I net59:I X:O
MMP0 net59 A sndPA VNB sky130_fd_pr__pfet_01v8_hvt m=1 w=1.0u l=0.15u mult=1 sa=0.265
+ sb=0.265 sd=0.28 area=0.063 perim=1.14
MMP1 sndPA B sndPB VNB sky130_fd_pr__pfet_01v8_hvt m=1 w=1.0u l=0.15u mult=1 sa=0.265
+ sb=0.265 sd=0.28 area=0.063 perim=1.14
MMP2 sndPB C sndPC VNB sky130_fd_pr__pfet_01v8_hvt m=1 w=1.0u l=0.15u mult=1 sa=0.265
+ sb=0.265 sd=0.28 area=0.063 perim=1.14
MMP3 sndPC D y VNB sky130_fd_pr__pfet_01v8_hvt m=1 w=1.0u l=0.15u mult=1 sa=0.265
+ sb=0.265 sd=0.28 area=0.063 perim=1.14
MMIP4 X y net59 VNB sky130_fd_pr__pfet_01v8_hvt m=4 w=1.0u l=0.15u mult=1 sa=0.265
+ sb=0.265 sd=0.28 area=0.063 perim=1.14
MMN0 y A VGND VNB sky130_fd_pr__nfet_01v8 m=1 w=0.65u l=0.15u mult=1 sa=0.265 sb=0.265
+ sd=0.28 area=0.063 perim=1.14
MMN1 y B VGND VNB sky130_fd_pr__nfet_01v8 m=1 w=0.65u l=0.15u mult=1 sa=0.265 sb=0.265
+ sd=0.28 area=0.063 perim=1.14
MMN2 y C VGND VNB sky130_fd_pr__nfet_01v8 m=1 w=0.65u l=0.15u mult=1 sa=0.265 sb=0.265
+ sd=0.28 area=0.063 perim=1.14
MMN3 y D VGND VNB sky130_fd_pr__nfet_01v8 m=1 w=0.65u l=0.15u mult=1 sa=0.265 sb=0.265
+ sd=0.28 area=0.063 perim=1.14
MMIN4 X y VGND VNB sky130_fd_pr__nfet_01v8 m=4 w=0.65u l=0.15u mult=1 sa=0.265
+ sb=0.265 sd=0.28 area=0.063 perim=1.14
.ENDS sky130_fd_sc_hd__or4_4
* Copyright 2020 The SkyWater PDK Authors
*
* Licensed under the Apache License, Version 2.0 (the "License");
* you may not use this file except in compliance with the License.
* You may obtain a copy of the License at
*
*     https:  www.apache.org licenses LICENSE-2.0
*
* Unless required by applicable law or agreed to in writing, software
* distributed under the License is distributed on an "AS IS" BASIS,
* WITHOUT WARRANTIES OR CONDITIONS OF ANY KIND, either express or implied.
* See the License for the specific language governing permissions and
* limitations under the License.
*
* SPDX-License-Identifier: Apache-2.0

.SUBCKT sky130_fd_sc_hd__or4b_1 A B C D_N VGND VNB VNB net59 X
*.PININFO A:I B:I C:I D_N:I VGND:I VNB:I VNB:I net59:I X:O
MMP0 net59 A sndPA VNB sky130_fd_pr__pfet_01v8_hvt m=1 w=0.42u l=0.15u mult=1 sa=0.265
+ sb=0.265 sd=0.28 area=0.063 perim=1.14
MMP1 sndPA B sndPB VNB sky130_fd_pr__pfet_01v8_hvt m=1 w=0.42u l=0.15u mult=1 sa=0.265
+ sb=0.265 sd=0.28 area=0.063 perim=1.14
MMP2 sndPB C sndPC VNB sky130_fd_pr__pfet_01v8_hvt m=1 w=0.42u l=0.15u mult=1 sa=0.265
+ sb=0.265 sd=0.28 area=0.063 perim=1.14
MMP3 sndPC D y VNB sky130_fd_pr__pfet_01v8_hvt m=1 w=0.42u l=0.15u mult=1 sa=0.265
+ sb=0.265 sd=0.28 area=0.063 perim=1.14
MMIP3 D D_N net59 VNB sky130_fd_pr__pfet_01v8_hvt m=1 w=0.42u l=0.15u mult=1 sa=0.265
+ sb=0.265 sd=0.28 area=0.063 perim=1.14
MMIP4 X y net59 VNB sky130_fd_pr__pfet_01v8_hvt m=1 w=1.0u l=0.15u mult=1 sa=0.265
+ sb=0.265 sd=0.28 area=0.063 perim=1.14
MMN0 y A VGND VNB sky130_fd_pr__nfet_01v8 m=1 w=0.42u l=0.15u mult=1 sa=0.265 sb=0.265
+ sd=0.28 area=0.063 perim=1.14
MMN1 y B VGND VNB sky130_fd_pr__nfet_01v8 m=1 w=0.42u l=0.15u mult=1 sa=0.265 sb=0.265
+ sd=0.28 area=0.063 perim=1.14
MMN2 y C VGND VNB sky130_fd_pr__nfet_01v8 m=1 w=0.42u l=0.15u mult=1 sa=0.265 sb=0.265
+ sd=0.28 area=0.063 perim=1.14
MMN3 y D VGND VNB sky130_fd_pr__nfet_01v8 m=1 w=0.42u l=0.15u mult=1 sa=0.265 sb=0.265
+ sd=0.28 area=0.063 perim=1.14
MMIN3 D D_N VGND VNB sky130_fd_pr__nfet_01v8 m=1 w=0.42u l=0.15u mult=1 sa=0.265
+ sb=0.265 sd=0.28 area=0.063 perim=1.14
MMIN4 X y VGND VNB sky130_fd_pr__nfet_01v8 m=1 w=0.65u l=0.15u mult=1 sa=0.265
+ sb=0.265 sd=0.28 area=0.063 perim=1.14
.ENDS sky130_fd_sc_hd__or4b_1
* Copyright 2020 The SkyWater PDK Authors
*
* Licensed under the Apache License, Version 2.0 (the "License");
* you may not use this file except in compliance with the License.
* You may obtain a copy of the License at
*
*     https:  www.apache.org licenses LICENSE-2.0
*
* Unless required by applicable law or agreed to in writing, software
* distributed under the License is distributed on an "AS IS" BASIS,
* WITHOUT WARRANTIES OR CONDITIONS OF ANY KIND, either express or implied.
* See the License for the specific language governing permissions and
* limitations under the License.
*
* SPDX-License-Identifier: Apache-2.0

.SUBCKT sky130_fd_sc_hd__or4b_2 A B C D_N VGND VNB VNB net59 X
*.PININFO A:I B:I C:I D_N:I VGND:I VNB:I VNB:I net59:I X:O
MMP0 net59 A sndPA VNB sky130_fd_pr__pfet_01v8_hvt m=1 w=0.42u l=0.15u mult=1 sa=0.265
+ sb=0.265 sd=0.28 area=0.063 perim=1.14
MMP1 sndPA B sndPB VNB sky130_fd_pr__pfet_01v8_hvt m=1 w=0.42u l=0.15u mult=1 sa=0.265
+ sb=0.265 sd=0.28 area=0.063 perim=1.14
MMP2 sndPB C sndPC VNB sky130_fd_pr__pfet_01v8_hvt m=1 w=0.42u l=0.15u mult=1 sa=0.265
+ sb=0.265 sd=0.28 area=0.063 perim=1.14
MMP3 sndPC D y VNB sky130_fd_pr__pfet_01v8_hvt m=1 w=0.42u l=0.15u mult=1 sa=0.265
+ sb=0.265 sd=0.28 area=0.063 perim=1.14
MMIP3 D D_N net59 VNB sky130_fd_pr__pfet_01v8_hvt m=1 w=0.42u l=0.15u mult=1 sa=0.265
+ sb=0.265 sd=0.28 area=0.063 perim=1.14
MMIP4 X y net59 VNB sky130_fd_pr__pfet_01v8_hvt m=2 w=1.0u l=0.15u mult=1 sa=0.265
+ sb=0.265 sd=0.28 area=0.063 perim=1.14
MMN0 y A VGND VNB sky130_fd_pr__nfet_01v8 m=1 w=0.42u l=0.15u mult=1 sa=0.265 sb=0.265
+ sd=0.28 area=0.063 perim=1.14
MMN1 y B VGND VNB sky130_fd_pr__nfet_01v8 m=1 w=0.42u l=0.15u mult=1 sa=0.265 sb=0.265
+ sd=0.28 area=0.063 perim=1.14
MMN2 y C VGND VNB sky130_fd_pr__nfet_01v8 m=1 w=0.42u l=0.15u mult=1 sa=0.265 sb=0.265
+ sd=0.28 area=0.063 perim=1.14
MMN3 y D VGND VNB sky130_fd_pr__nfet_01v8 m=1 w=0.42u l=0.15u mult=1 sa=0.265 sb=0.265
+ sd=0.28 area=0.063 perim=1.14
MMIN3 D D_N VGND VNB sky130_fd_pr__nfet_01v8 m=1 w=0.42u l=0.15u mult=1 sa=0.265
+ sb=0.265 sd=0.28 area=0.063 perim=1.14
MMIN4 X y VGND VNB sky130_fd_pr__nfet_01v8 m=2 w=0.65u l=0.15u mult=1 sa=0.265
+ sb=0.265 sd=0.28 area=0.063 perim=1.14
.ENDS sky130_fd_sc_hd__or4b_2
* Copyright 2020 The SkyWater PDK Authors
*
* Licensed under the Apache License, Version 2.0 (the "License");
* you may not use this file except in compliance with the License.
* You may obtain a copy of the License at
*
*     https:  www.apache.org licenses LICENSE-2.0
*
* Unless required by applicable law or agreed to in writing, software
* distributed under the License is distributed on an "AS IS" BASIS,
* WITHOUT WARRANTIES OR CONDITIONS OF ANY KIND, either express or implied.
* See the License for the specific language governing permissions and
* limitations under the License.
*
* SPDX-License-Identifier: Apache-2.0

.SUBCKT sky130_fd_sc_hd__or4b_4 A B C D_N VGND VNB VNB net59 X
*.PININFO A:I B:I C:I D_N:I VGND:I VNB:I VNB:I net59:I X:O
MMP0 net59 A sndPA VNB sky130_fd_pr__pfet_01v8_hvt m=1 w=1.0u l=0.15u mult=1 sa=0.265
+ sb=0.265 sd=0.28 area=0.063 perim=1.14
MMP1 sndPA B sndPB VNB sky130_fd_pr__pfet_01v8_hvt m=1 w=1.0u l=0.15u mult=1 sa=0.265
+ sb=0.265 sd=0.28 area=0.063 perim=1.14
MMP2 sndPB C sndPC VNB sky130_fd_pr__pfet_01v8_hvt m=1 w=1.0u l=0.15u mult=1 sa=0.265
+ sb=0.265 sd=0.28 area=0.063 perim=1.14
MMP3 sndPC D y VNB sky130_fd_pr__pfet_01v8_hvt m=1 w=1.0u l=0.15u mult=1 sa=0.265
+ sb=0.265 sd=0.28 area=0.063 perim=1.14
MMIP3 D D_N net59 VNB sky130_fd_pr__pfet_01v8_hvt m=1 w=0.42u l=0.15u mult=1 sa=0.265
+ sb=0.265 sd=0.28 area=0.063 perim=1.14
MMIP4 X y net59 VNB sky130_fd_pr__pfet_01v8_hvt m=4 w=1.0u l=0.15u mult=1 sa=0.265
+ sb=0.265 sd=0.28 area=0.063 perim=1.14
MMN0 y A VGND VNB sky130_fd_pr__nfet_01v8 m=1 w=0.65u l=0.15u mult=1 sa=0.265 sb=0.265
+ sd=0.28 area=0.063 perim=1.14
MMN1 y B VGND VNB sky130_fd_pr__nfet_01v8 m=1 w=0.65u l=0.15u mult=1 sa=0.265 sb=0.265
+ sd=0.28 area=0.063 perim=1.14
MMN2 y C VGND VNB sky130_fd_pr__nfet_01v8 m=1 w=0.65u l=0.15u mult=1 sa=0.265 sb=0.265
+ sd=0.28 area=0.063 perim=1.14
MMN3 y D VGND VNB sky130_fd_pr__nfet_01v8 m=1 w=0.65u l=0.15u mult=1 sa=0.265 sb=0.265
+ sd=0.28 area=0.063 perim=1.14
MMIN3 D D_N VGND VNB sky130_fd_pr__nfet_01v8 m=1 w=0.42u l=0.15u mult=1 sa=0.265
+ sb=0.265 sd=0.28 area=0.063 perim=1.14
MMIN4 X y VGND VNB sky130_fd_pr__nfet_01v8 m=4 w=0.65u l=0.15u mult=1 sa=0.265
+ sb=0.265 sd=0.28 area=0.063 perim=1.14
.ENDS sky130_fd_sc_hd__or4b_4
* Copyright 2020 The SkyWater PDK Authors
*
* Licensed under the Apache License, Version 2.0 (the "License");
* you may not use this file except in compliance with the License.
* You may obtain a copy of the License at
*
*     https:  www.apache.org licenses LICENSE-2.0
*
* Unless required by applicable law or agreed to in writing, software
* distributed under the License is distributed on an "AS IS" BASIS,
* WITHOUT WARRANTIES OR CONDITIONS OF ANY KIND, either express or implied.
* See the License for the specific language governing permissions and
* limitations under the License.
*
* SPDX-License-Identifier: Apache-2.0

.SUBCKT sky130_fd_sc_hd__or4bb_1 A B C_N D_N VGND VNB VNB net59 X
*.PININFO A:I B:I C_N:I D_N:I VGND:I VNB:I VNB:I net59:I X:O
MMP0 net59 A sndPA VNB sky130_fd_pr__pfet_01v8_hvt m=1 w=0.42u l=0.15u mult=1 sa=0.265
+ sb=0.265 sd=0.28 area=0.063 perim=1.14
MMP1 sndPA B sndPB VNB sky130_fd_pr__pfet_01v8_hvt m=1 w=0.42u l=0.15u mult=1 sa=0.265
+ sb=0.265 sd=0.28 area=0.063 perim=1.14
MMP2 sndPB C sndPC VNB sky130_fd_pr__pfet_01v8_hvt m=1 w=0.42u l=0.15u mult=1 sa=0.265
+ sb=0.265 sd=0.28 area=0.063 perim=1.14
MMP3 sndPC D y VNB sky130_fd_pr__pfet_01v8_hvt m=1 w=0.42u l=0.15u mult=1 sa=0.265
+ sb=0.265 sd=0.28 area=0.063 perim=1.14
MMIP2 C C_N net59 VNB sky130_fd_pr__pfet_01v8_hvt m=1 w=0.42u l=0.15u mult=1 sa=0.265
+ sb=0.265 sd=0.28 area=0.063 perim=1.14
MMIP3 D D_N net59 VNB sky130_fd_pr__pfet_01v8_hvt m=1 w=0.42u l=0.15u mult=1 sa=0.265
+ sb=0.265 sd=0.28 area=0.063 perim=1.14
MMIP4 X y net59 VNB sky130_fd_pr__pfet_01v8_hvt m=1 w=1.0u l=0.15u mult=1 sa=0.265
+ sb=0.265 sd=0.28 area=0.063 perim=1.14
MMN0 y A VGND VNB sky130_fd_pr__nfet_01v8 m=1 w=0.42u l=0.15u mult=1 sa=0.265 sb=0.265
+ sd=0.28 area=0.063 perim=1.14
MMN1 y B VGND VNB sky130_fd_pr__nfet_01v8 m=1 w=0.42u l=0.15u mult=1 sa=0.265 sb=0.265
+ sd=0.28 area=0.063 perim=1.14
MMN2 y C VGND VNB sky130_fd_pr__nfet_01v8 m=1 w=0.42u l=0.15u mult=1 sa=0.265 sb=0.265
+ sd=0.28 area=0.063 perim=1.14
MMN3 y D VGND VNB sky130_fd_pr__nfet_01v8 m=1 w=0.42u l=0.15u mult=1 sa=0.265 sb=0.265
+ sd=0.28 area=0.063 perim=1.14
MMIN2 C C_N VGND VNB sky130_fd_pr__nfet_01v8 m=1 w=0.42u l=0.15u mult=1 sa=0.265
+ sb=0.265 sd=0.28 area=0.063 perim=1.14
MMIN3 D D_N VGND VNB sky130_fd_pr__nfet_01v8 m=1 w=0.42u l=0.15u mult=1 sa=0.265
+ sb=0.265 sd=0.28 area=0.063 perim=1.14
MMIN4 X y VGND VNB sky130_fd_pr__nfet_01v8 m=1 w=0.65u l=0.15u mult=1 sa=0.265
+ sb=0.265 sd=0.28 area=0.063 perim=1.14
.ENDS sky130_fd_sc_hd__or4bb_1
* Copyright 2020 The SkyWater PDK Authors
*
* Licensed under the Apache License, Version 2.0 (the "License");
* you may not use this file except in compliance with the License.
* You may obtain a copy of the License at
*
*     https:  www.apache.org licenses LICENSE-2.0
*
* Unless required by applicable law or agreed to in writing, software
* distributed under the License is distributed on an "AS IS" BASIS,
* WITHOUT WARRANTIES OR CONDITIONS OF ANY KIND, either express or implied.
* See the License for the specific language governing permissions and
* limitations under the License.
*
* SPDX-License-Identifier: Apache-2.0

.SUBCKT sky130_fd_sc_hd__or4bb_2 A B C_N D_N VGND VNB VNB net59 X
*.PININFO A:I B:I C_N:I D_N:I VGND:I VNB:I VNB:I net59:I X:O
MMP0 net59 A sndPA VNB sky130_fd_pr__pfet_01v8_hvt m=1 w=0.42u l=0.15u mult=1 sa=0.265
+ sb=0.265 sd=0.28 area=0.063 perim=1.14
MMP1 sndPA B sndPB VNB sky130_fd_pr__pfet_01v8_hvt m=1 w=0.42u l=0.15u mult=1 sa=0.265
+ sb=0.265 sd=0.28 area=0.063 perim=1.14
MMP2 sndPB C sndPC VNB sky130_fd_pr__pfet_01v8_hvt m=1 w=0.42u l=0.15u mult=1 sa=0.265
+ sb=0.265 sd=0.28 area=0.063 perim=1.14
MMP3 sndPC D y VNB sky130_fd_pr__pfet_01v8_hvt m=1 w=0.42u l=0.15u mult=1 sa=0.265
+ sb=0.265 sd=0.28 area=0.063 perim=1.14
MMIP2 C C_N net59 VNB sky130_fd_pr__pfet_01v8_hvt m=1 w=0.42u l=0.15u mult=1 sa=0.265
+ sb=0.265 sd=0.28 area=0.063 perim=1.14
MMIP3 D D_N net59 VNB sky130_fd_pr__pfet_01v8_hvt m=1 w=0.42u l=0.15u mult=1 sa=0.265
+ sb=0.265 sd=0.28 area=0.063 perim=1.14
MMIP4 X y net59 VNB sky130_fd_pr__pfet_01v8_hvt m=2 w=1.0u l=0.15u mult=1 sa=0.265
+ sb=0.265 sd=0.28 area=0.063 perim=1.14
MMN0 y A VGND VNB sky130_fd_pr__nfet_01v8 m=1 w=0.42u l=0.15u mult=1 sa=0.265 sb=0.265
+ sd=0.28 area=0.063 perim=1.14
MMN1 y B VGND VNB sky130_fd_pr__nfet_01v8 m=1 w=0.42u l=0.15u mult=1 sa=0.265 sb=0.265
+ sd=0.28 area=0.063 perim=1.14
MMN2 y C VGND VNB sky130_fd_pr__nfet_01v8 m=1 w=0.42u l=0.15u mult=1 sa=0.265 sb=0.265
+ sd=0.28 area=0.063 perim=1.14
MMN3 y D VGND VNB sky130_fd_pr__nfet_01v8 m=1 w=0.42u l=0.15u mult=1 sa=0.265 sb=0.265
+ sd=0.28 area=0.063 perim=1.14
MMIN2 C C_N VGND VNB sky130_fd_pr__nfet_01v8 m=1 w=0.42u l=0.15u mult=1 sa=0.265
+ sb=0.265 sd=0.28 area=0.063 perim=1.14
MMIN3 D D_N VGND VNB sky130_fd_pr__nfet_01v8 m=1 w=0.42u l=0.15u mult=1 sa=0.265
+ sb=0.265 sd=0.28 area=0.063 perim=1.14
MMIN4 X y VGND VNB sky130_fd_pr__nfet_01v8 m=2 w=0.65u l=0.15u mult=1 sa=0.265
+ sb=0.265 sd=0.28 area=0.063 perim=1.14
.ENDS sky130_fd_sc_hd__or4bb_2
* Copyright 2020 The SkyWater PDK Authors
*
* Licensed under the Apache License, Version 2.0 (the "License");
* you may not use this file except in compliance with the License.
* You may obtain a copy of the License at
*
*     https:  www.apache.org licenses LICENSE-2.0
*
* Unless required by applicable law or agreed to in writing, software
* distributed under the License is distributed on an "AS IS" BASIS,
* WITHOUT WARRANTIES OR CONDITIONS OF ANY KIND, either express or implied.
* See the License for the specific language governing permissions and
* limitations under the License.
*
* SPDX-License-Identifier: Apache-2.0

.SUBCKT sky130_fd_sc_hd__or4bb_4 A B C_N D_N VGND VNB VNB net59 X
*.PININFO A:I B:I C_N:I D_N:I VGND:I VNB:I VNB:I net59:I X:O
MMP0 net59 A sndPA VNB sky130_fd_pr__pfet_01v8_hvt m=1 w=1.0u l=0.15u mult=1 sa=0.265
+ sb=0.265 sd=0.28 area=0.063 perim=1.14
MMP1 sndPA B sndPB VNB sky130_fd_pr__pfet_01v8_hvt m=1 w=1.0u l=0.15u mult=1 sa=0.265
+ sb=0.265 sd=0.28 area=0.063 perim=1.14
MMP2 sndPB C sndPC VNB sky130_fd_pr__pfet_01v8_hvt m=1 w=1.0u l=0.15u mult=1 sa=0.265
+ sb=0.265 sd=0.28 area=0.063 perim=1.14
MMP3 sndPC D y VNB sky130_fd_pr__pfet_01v8_hvt m=1 w=1.0u l=0.15u mult=1 sa=0.265
+ sb=0.265 sd=0.28 area=0.063 perim=1.14
MMIP2 C C_N net59 VNB sky130_fd_pr__pfet_01v8_hvt m=1 w=0.42u l=0.15u mult=1 sa=0.265
+ sb=0.265 sd=0.28 area=0.063 perim=1.14
MMIP3 D D_N net59 VNB sky130_fd_pr__pfet_01v8_hvt m=1 w=0.42u l=0.15u mult=1 sa=0.265
+ sb=0.265 sd=0.28 area=0.063 perim=1.14
MMIP4 X y net59 VNB sky130_fd_pr__pfet_01v8_hvt m=4 w=1.0u l=0.15u mult=1 sa=0.265
+ sb=0.265 sd=0.28 area=0.063 perim=1.14
MMN0 y A VGND VNB sky130_fd_pr__nfet_01v8 m=1 w=0.65u l=0.15u mult=1 sa=0.265 sb=0.265
+ sd=0.28 area=0.063 perim=1.14
MMN1 y B VGND VNB sky130_fd_pr__nfet_01v8 m=1 w=0.65u l=0.15u mult=1 sa=0.265 sb=0.265
+ sd=0.28 area=0.063 perim=1.14
MMN2 y C VGND VNB sky130_fd_pr__nfet_01v8 m=1 w=0.65u l=0.15u mult=1 sa=0.265 sb=0.265
+ sd=0.28 area=0.063 perim=1.14
MMN3 y D VGND VNB sky130_fd_pr__nfet_01v8 m=1 w=0.65u l=0.15u mult=1 sa=0.265 sb=0.265
+ sd=0.28 area=0.063 perim=1.14
MMIN2 C C_N VGND VNB sky130_fd_pr__nfet_01v8 m=1 w=0.42u l=0.15u mult=1 sa=0.265
+ sb=0.265 sd=0.28 area=0.063 perim=1.14
MMIN3 D D_N VGND VNB sky130_fd_pr__nfet_01v8 m=1 w=0.42u l=0.15u mult=1 sa=0.265
+ sb=0.265 sd=0.28 area=0.063 perim=1.14
MMIN4 X y VGND VNB sky130_fd_pr__nfet_01v8 m=4 w=0.65u l=0.15u mult=1 sa=0.265
+ sb=0.265 sd=0.28 area=0.063 perim=1.14
.ENDS sky130_fd_sc_hd__or4bb_4
* Copyright 2020 The SkyWater PDK Authors
*
* Licensed under the Apache License, Version 2.0 (the "License");
* you may not use this file except in compliance with the License.
* You may obtain a copy of the License at
*
*     https:  www.apache.org licenses LICENSE-2.0
*
* Unless required by applicable law or agreed to in writing, software
* distributed under the License is distributed on an "AS IS" BASIS,
* WITHOUT WARRANTIES OR CONDITIONS OF ANY KIND, either express or implied.
* See the License for the specific language governing permissions and
* limitations under the License.
*
* SPDX-License-Identifier: Apache-2.0

.SUBCKT sky130_fd_sc_hd__probe_p_8 A VGND VNB VNB net59 X
*.PININFO A:I VGND:I VNB:I VNB:I net59:I X:O
MMIP1 Ab A net59 VNB sky130_fd_pr__pfet_01v8_hvt m=3 w=1.0u l=0.15u mult=1 sa=0.265
+ sb=0.265 sd=0.28 area=0.063 perim=1.14
MMIP2 net29 Ab net59 VNB sky130_fd_pr__pfet_01v8_hvt m=8 w=1.0u l=0.15u mult=1 sa=0.265
+ sb=0.265 sd=0.28 area=0.063 perim=1.14
MMIN1 Ab A VGND VNB sky130_fd_pr__nfet_01v8 m=3 w=0.65u l=0.15u mult=1 sa=0.265
+ sb=0.265 sd=0.28 area=0.063 perim=1.14
MMIN2 net29 Ab VGND VNB sky130_fd_pr__nfet_01v8 m=8 w=0.65u l=0.15u mult=1 sa=0.265
+ sb=0.265 sd=0.28 area=0.063 perim=1.14
rI112 net29 X 1
.ENDS sky130_fd_sc_hd__probe_p_8
* Copyright 2020 The SkyWater PDK Authors
*
* Licensed under the Apache License, Version 2.0 (the "License");
* you may not use this file except in compliance with the License.
* You may obtain a copy of the License at
*
*     https:  www.apache.org licenses LICENSE-2.0
*
* Unless required by applicable law or agreed to in writing, software
* distributed under the License is distributed on an "AS IS" BASIS,
* WITHOUT WARRANTIES OR CONDITIONS OF ANY KIND, either express or implied.
* See the License for the specific language governing permissions and
* limitations under the License.
*
* SPDX-License-Identifier: Apache-2.0

.SUBCKT sky130_fd_sc_hd__probec_p_8 A VGND VNB VNB net59 X
*.PININFO A:I VGND:I VNB:I VNB:I net59:I X:O
MMIP1 Ab A net59 VNB sky130_fd_pr__pfet_01v8_hvt m=3 w=1.0u l=0.15u mult=1 sa=0.265
+ sb=0.265 sd=0.28 area=0.063 perim=1.14
MMIP2 net33 Ab net59 VNB sky130_fd_pr__pfet_01v8_hvt m=8 w=1.0u l=0.15u mult=1 sa=0.265
+ sb=0.265 sd=0.28 area=0.063 perim=1.14
MMIN1 Ab A VGND VNB sky130_fd_pr__nfet_01v8 m=3 w=0.65u l=0.15u mult=1 sa=0.265
+ sb=0.265 sd=0.28 area=0.063 perim=1.14
MMIN2 net33 Ab VGND VNB sky130_fd_pr__nfet_01v8 m=8 w=0.65u l=0.15u mult=1 sa=0.265
+ sb=0.265 sd=0.28 area=0.063 perim=1.14
rI112 net33 X 1
rI120 VGND met5vgnd 1
rI119 net59 met5vpwr 1
.ENDS sky130_fd_sc_hd__probec_p_8
* Copyright 2020 The SkyWater PDK Authors
*
* Licensed under the Apache License, Version 2.0 (the "License");
* you may not use this file except in compliance with the License.
* You may obtain a copy of the License at
*
*     https:  www.apache.org licenses LICENSE-2.0
*
* Unless required by applicable law or agreed to in writing, software
* distributed under the License is distributed on an "AS IS" BASIS,
* WITHOUT WARRANTIES OR CONDITIONS OF ANY KIND, either express or implied.
* See the License for the specific language governing permissions and
* limitations under the License.
*
* SPDX-License-Identifier: Apache-2.0

.SUBCKT sky130_fd_sc_hd__sdfbbn_1 CLK_N D RESET_B SCD SCE SET_B VGND VNB VNB net59 Q Q_N
*.PININFO CLK_N:I D:I RESET_B:I SCD:I SCE:I SET_B:I VGND:I VNB:I VNB:I
*.PININFO net59:I Q:O Q_N:O
MI98 net105 D n0 VNB sky130_fd_pr__nfet_01v8 m=1 w=0.42u l=0.15u mult=1 sa=0.265
+ sb=0.265 sd=0.28 area=0.525 perim=3.1
MI103 n1 SCD VGND VNB sky130_fd_pr__nfet_01v8 m=1 w=0.42u l=0.15u mult=1 sa=0.265
+ sb=0.265 sd=0.28 area=0.525 perim=3.1
MI104 n0 sceb VGND VNB sky130_fd_pr__nfet_01v8 m=1 w=0.42u l=0.15u mult=1 sa=0.265
+ sb=0.265 sd=0.28 area=0.525 perim=3.1
MI120 net105 SCE n1 VNB sky130_fd_pr__nfet_01v8 m=1 w=0.42u l=0.15u mult=1 sa=0.265
+ sb=0.265 sd=0.28 area=0.525 perim=3.1
MI46 clkneg clkpos VGND VNB sky130_fd_pr__nfet_01v8 m=1 w=0.42u l=0.15u mult=1
+ sa=0.265 sb=0.265 sd=0.28 area=0.063 perim=1.14
MI642 RESET RESET_B VGND VNB sky130_fd_pr__nfet_01v8 m=1 w=0.42u l=0.15u mult=1
+ sa=0.265 sb=0.265 sd=0.28 area=0.063 perim=1.14
MI676 M1 M0 net176 VNB sky130_fd_pr__nfet_01v8 m=1 w=0.64u l=0.15u mult=1 sa=0.265
+ sb=0.265 sd=0.28 area=0.063 perim=1.14
MI675 net176 SET_B VGND VNB sky130_fd_pr__nfet_01v8 m=1 w=0.42u l=0.15u mult=1
+ sa=0.265 sb=0.265 sd=0.28 area=0.063 perim=1.14
MI653 Q net213 VGND VNB sky130_fd_pr__nfet_01v8 m=1 w=0.65u l=0.15u mult=1 sa=0.265
+ sb=0.265 sd=0.28 area=0.063 perim=1.14
MI677 M1 RESET net176 VNB sky130_fd_pr__nfet_01v8 m=1 w=0.64u l=0.15u mult=1 sa=0.265
+ sb=0.265 sd=0.28 area=0.063 perim=1.14
MI648 M0 clkpos net153 VNB sky130_fd_pr__nfet_01v8 m=1 w=0.36u l=0.15u mult=1 sa=0.265
+ sb=0.265 sd=0.28 area=0.063 perim=1.14
MI44 clkpos CLK_N VGND VNB sky130_fd_pr__nfet_01v8 m=1 w=0.42u l=0.15u mult=1 sa=0.265
+ sb=0.265 sd=0.28 area=0.063 perim=1.14
MI649 net153 M1 VGND VNB sky130_fd_pr__nfet_01v8 m=1 w=0.42u l=0.15u mult=1 sa=0.265
+ sb=0.265 sd=0.28 area=0.063 perim=1.14
MI655 S0 clkneg net145 VNB sky130_fd_pr__nfet_01v8 m=1 w=0.36u l=0.15u mult=1 sa=0.265
+ sb=0.265 sd=0.28 area=0.063 perim=1.14
MI654 net145 net117 VGND VNB sky130_fd_pr__nfet_01v8 m=1 w=0.42u l=0.15u mult=1
+ sa=0.265 sb=0.265 sd=0.28 area=0.063 perim=1.14
MI651 Q_N net117 VGND VNB sky130_fd_pr__nfet_01v8 m=1 w=0.65u l=0.15u mult=1 sa=0.265
+ sb=0.265 sd=0.28 area=0.063 perim=1.14
MI652 net213 net117 VGND VNB sky130_fd_pr__nfet_01v8 m=1 w=0.42u l=0.15u mult=1
+ sa=0.265 sb=0.265 sd=0.28 area=0.063 perim=1.14
MI42 net105 clkneg M0 VNB sky130_fd_pr__nfet_01v8 m=1 w=0.36u l=0.15u mult=1 sa=0.265
+ sb=0.265 sd=0.28 area=0.063 perim=1.14
MI668 S0 clkpos net125 VNB sky130_fd_pr__nfet_01v8 m=1 w=0.36u l=0.15u mult=1 sa=0.265
+ sb=0.265 sd=0.28 area=0.063 perim=1.14
MI667 net125 M1 VGND VNB sky130_fd_pr__nfet_01v8 m=1 w=0.64u l=0.15u mult=1 sa=0.265
+ sb=0.265 sd=0.28 area=0.063 perim=1.14
MI630 net117 RESET net116 VNB sky130_fd_pr__nfet_01v8 m=1 w=0.64u l=0.15u mult=1
+ sa=0.265 sb=0.265 sd=0.28 area=0.063 perim=1.14
MI3 net117 S0 net116 VNB sky130_fd_pr__nfet_01v8 m=1 w=0.64u l=0.15u mult=1 sa=0.265
+ sb=0.265 sd=0.28 area=0.063 perim=1.14
MI7 net116 SET_B VGND VNB sky130_fd_pr__nfet_01v8 m=1 w=0.42u l=0.15u mult=1 sa=0.265
+ sb=0.265 sd=0.28 area=0.063 perim=1.14
MI639 sceb SCE VGND VNB sky130_fd_pr__nfet_01v8 m=1 w=0.42u l=0.15u mult=1 sa=0.265
+ sb=0.265 sd=0.28 area=0.063 perim=1.14
MI107 p0 SCE net59 VNB sky130_fd_pr__pfet_01v8_hvt m=1 w=0.42u l=0.15u mult=1 sa=0.265
+ sb=0.265 sd=0.28 area=0.063 perim=1.14
MI94 net105 D p0 VNB sky130_fd_pr__pfet_01v8_hvt m=1 w=0.42u l=0.15u mult=1 sa=0.265
+ sb=0.265 sd=0.28 area=0.063 perim=1.14
MI101 net105 sceb p1 VNB sky130_fd_pr__pfet_01v8_hvt m=1 w=0.64u l=0.15u mult=1
+ sa=0.265 sb=0.265 sd=0.28 area=0.063 perim=1.14
MI108 p1 SCD net59 VNB sky130_fd_pr__pfet_01v8_hvt m=1 w=0.64u l=0.15u mult=1 sa=0.265
+ sb=0.265 sd=0.28 area=0.063 perim=1.14
MI679 M1 SET_B net59 VNB sky130_fd_pr__pfet_01v8_hvt m=1 w=0.42u l=0.15u mult=1
+ sa=0.265 sb=0.265 sd=0.28 area=0.063 perim=1.14
MI669 S0 clkneg net265 VNB sky130_fd_pr__pfet_01v8_hvt m=1 w=0.42u l=0.15u mult=1
+ sa=0.265 sb=0.265 sd=0.28 area=0.063 perim=1.14
MI660 Q net213 net59 VNB sky130_fd_pr__pfet_01v8_hvt m=1 w=1.0u l=0.15u mult=1 sa=0.265
+ sb=0.265 sd=0.28 area=0.063 perim=1.14
MI9 net117 S0 net268 VNB sky130_fd_pr__pfet_01v8_hvt m=1 w=0.84u l=0.15u mult=1
+ sa=0.265 sb=0.265 sd=0.28 area=0.063 perim=1.14
MI670 net265 M1 net59 VNB sky130_fd_pr__pfet_01v8_hvt m=1 w=0.84u l=0.15u mult=1
+ sa=0.265 sb=0.265 sd=0.28 area=0.063 perim=1.14
MI678 net216 RESET net59 VNB sky130_fd_pr__pfet_01v8_hvt m=1 w=0.84u l=0.15u mult=1
+ sa=0.265 sb=0.265 sd=0.28 area=0.063 perim=1.14
MI662 net257 net117 net59 VNB sky130_fd_pr__pfet_01v8_hvt m=1 w=0.42u l=0.15u mult=1
+ sa=0.265 sb=0.265 sd=0.28 area=0.063 perim=1.14
MI664 S0 clkpos net257 VNB sky130_fd_pr__pfet_01v8_hvt m=1 w=0.42u l=0.15u mult=1
+ sa=0.265 sb=0.265 sd=0.28 area=0.063 perim=1.14
MI10 net117 SET_B net59 VNB sky130_fd_pr__pfet_01v8_hvt m=1 w=0.42u l=0.15u mult=1
+ sa=0.265 sb=0.265 sd=0.28 area=0.063 perim=1.14
MI11 net268 RESET net59 VNB sky130_fd_pr__pfet_01v8_hvt m=1 w=0.84u l=0.15u mult=1
+ sa=0.265 sb=0.265 sd=0.28 area=0.063 perim=1.14
MI650 net241 M1 net59 VNB sky130_fd_pr__pfet_01v8_hvt m=1 w=0.42u l=0.15u mult=1
+ sa=0.265 sb=0.265 sd=0.28 area=0.063 perim=1.14
MI43 net105 clkpos M0 VNB sky130_fd_pr__pfet_01v8_hvt m=1 w=0.42u l=0.15u mult=1
+ sa=0.265 sb=0.265 sd=0.28 area=0.063 perim=1.14
MI656 M0 clkneg net241 VNB sky130_fd_pr__pfet_01v8_hvt m=1 w=0.42u l=0.15u mult=1
+ sa=0.265 sb=0.265 sd=0.28 area=0.063 perim=1.14
MI643 RESET RESET_B net59 VNB sky130_fd_pr__pfet_01v8_hvt m=1 w=0.64u l=0.15u mult=1
+ sa=0.265 sb=0.265 sd=0.28 area=0.063 perim=1.14
MI47 clkneg clkpos net59 VNB sky130_fd_pr__pfet_01v8_hvt m=1 w=0.64u l=0.15u mult=1
+ sa=0.265 sb=0.265 sd=0.28 area=0.063 perim=1.14
MI45 clkpos CLK_N net59 VNB sky130_fd_pr__pfet_01v8_hvt m=1 w=0.64u l=0.15u mult=1
+ sa=0.265 sb=0.265 sd=0.28 area=0.063 perim=1.14
MI680 M1 M0 net216 VNB sky130_fd_pr__pfet_01v8_hvt m=1 w=0.84u l=0.15u mult=1 sa=0.265
+ sb=0.265 sd=0.28 area=0.063 perim=1.14
MI663 net213 net117 net59 VNB sky130_fd_pr__pfet_01v8_hvt m=1 w=0.64u l=0.15u mult=1
+ sa=0.265 sb=0.265 sd=0.28 area=0.063 perim=1.14
MI661 Q_N net117 net59 VNB sky130_fd_pr__pfet_01v8_hvt m=1 w=1.0u l=0.15u mult=1
+ sa=0.265 sb=0.265 sd=0.28 area=0.063 perim=1.14
MI640 sceb SCE net59 VNB sky130_fd_pr__pfet_01v8_hvt m=1 w=0.42u l=0.15u mult=1
+ sa=0.265 sb=0.265 sd=0.28 area=0.063 perim=1.14
.ENDS sky130_fd_sc_hd__sdfbbn_1
* Copyright 2020 The SkyWater PDK Authors
*
* Licensed under the Apache License, Version 2.0 (the "License");
* you may not use this file except in compliance with the License.
* You may obtain a copy of the License at
*
*     https:  www.apache.org licenses LICENSE-2.0
*
* Unless required by applicable law or agreed to in writing, software
* distributed under the License is distributed on an "AS IS" BASIS,
* WITHOUT WARRANTIES OR CONDITIONS OF ANY KIND, either express or implied.
* See the License for the specific language governing permissions and
* limitations under the License.
*
* SPDX-License-Identifier: Apache-2.0

.SUBCKT sky130_fd_sc_hd__sdfbbn_2 CLK_N D RESET_B SCD SCE SET_B VGND VNB VNB net59 Q Q_N
*.PININFO CLK_N:I D:I RESET_B:I SCD:I SCE:I SET_B:I VGND:I VNB:I VNB:I
*.PININFO net59:I Q:O Q_N:O
MI98 net105 D n0 VNB sky130_fd_pr__nfet_01v8 m=1 w=0.42u l=0.15u mult=1 sa=0.265
+ sb=0.265 sd=0.28 area=0.525 perim=3.1
MI103 n1 SCD VGND VNB sky130_fd_pr__nfet_01v8 m=1 w=0.42u l=0.15u mult=1 sa=0.265
+ sb=0.265 sd=0.28 area=0.525 perim=3.1
MI104 n0 sceb VGND VNB sky130_fd_pr__nfet_01v8 m=1 w=0.42u l=0.15u mult=1 sa=0.265
+ sb=0.265 sd=0.28 area=0.525 perim=3.1
MI120 net105 SCE n1 VNB sky130_fd_pr__nfet_01v8 m=1 w=0.42u l=0.15u mult=1 sa=0.265
+ sb=0.265 sd=0.28 area=0.525 perim=3.1
MI46 clkneg clkpos VGND VNB sky130_fd_pr__nfet_01v8 m=1 w=0.42u l=0.15u mult=1
+ sa=0.265 sb=0.265 sd=0.28 area=0.063 perim=1.14
MI642 RESET RESET_B VGND VNB sky130_fd_pr__nfet_01v8 m=1 w=0.42u l=0.15u mult=1
+ sa=0.265 sb=0.265 sd=0.28 area=0.063 perim=1.14
MI676 M1 M0 net176 VNB sky130_fd_pr__nfet_01v8 m=1 w=0.64u l=0.15u mult=1 sa=0.265
+ sb=0.265 sd=0.28 area=0.063 perim=1.14
MI675 net176 SET_B VGND VNB sky130_fd_pr__nfet_01v8 m=1 w=0.42u l=0.15u mult=1
+ sa=0.265 sb=0.265 sd=0.28 area=0.063 perim=1.14
MI653 Q net213 VGND VNB sky130_fd_pr__nfet_01v8 m=2 w=0.65u l=0.15u mult=1 sa=0.265
+ sb=0.265 sd=0.28 area=0.063 perim=1.14
MI677 M1 RESET net176 VNB sky130_fd_pr__nfet_01v8 m=1 w=0.64u l=0.15u mult=1 sa=0.265
+ sb=0.265 sd=0.28 area=0.063 perim=1.14
MI648 M0 clkpos net160 VNB sky130_fd_pr__nfet_01v8 m=1 w=0.36u l=0.15u mult=1 sa=0.265
+ sb=0.265 sd=0.28 area=0.063 perim=1.14
MI44 clkpos CLK_N VGND VNB sky130_fd_pr__nfet_01v8 m=1 w=0.42u l=0.15u mult=1 sa=0.265
+ sb=0.265 sd=0.28 area=0.063 perim=1.14
MI649 net160 M1 VGND VNB sky130_fd_pr__nfet_01v8 m=1 w=0.42u l=0.15u mult=1 sa=0.265
+ sb=0.265 sd=0.28 area=0.063 perim=1.14
MI655 S0 clkneg net145 VNB sky130_fd_pr__nfet_01v8 m=1 w=0.36u l=0.15u mult=1 sa=0.265
+ sb=0.265 sd=0.28 area=0.063 perim=1.14
MI654 net145 net117 VGND VNB sky130_fd_pr__nfet_01v8 m=1 w=0.42u l=0.15u mult=1
+ sa=0.265 sb=0.265 sd=0.28 area=0.063 perim=1.14
MI651 Q_N net117 VGND VNB sky130_fd_pr__nfet_01v8 m=2 w=0.65u l=0.15u mult=1 sa=0.265
+ sb=0.265 sd=0.28 area=0.063 perim=1.14
MI652 net213 net117 VGND VNB sky130_fd_pr__nfet_01v8 m=1 w=0.42u l=0.15u mult=1
+ sa=0.265 sb=0.265 sd=0.28 area=0.063 perim=1.14
MI42 net105 clkneg M0 VNB sky130_fd_pr__nfet_01v8 m=1 w=0.36u l=0.15u mult=1 sa=0.265
+ sb=0.265 sd=0.28 area=0.063 perim=1.14
MI668 S0 clkpos net128 VNB sky130_fd_pr__nfet_01v8 m=1 w=0.36u l=0.15u mult=1 sa=0.265
+ sb=0.265 sd=0.28 area=0.063 perim=1.14
MI667 net128 M1 VGND VNB sky130_fd_pr__nfet_01v8 m=1 w=0.64u l=0.15u mult=1 sa=0.265
+ sb=0.265 sd=0.28 area=0.063 perim=1.14
MI630 net117 RESET net116 VNB sky130_fd_pr__nfet_01v8 m=1 w=0.64u l=0.15u mult=1
+ sa=0.265 sb=0.265 sd=0.28 area=0.063 perim=1.14
MI3 net117 S0 net116 VNB sky130_fd_pr__nfet_01v8 m=1 w=0.64u l=0.15u mult=1 sa=0.265
+ sb=0.265 sd=0.28 area=0.063 perim=1.14
MI7 net116 SET_B VGND VNB sky130_fd_pr__nfet_01v8 m=1 w=0.42u l=0.15u mult=1 sa=0.265
+ sb=0.265 sd=0.28 area=0.063 perim=1.14
MI639 sceb SCE VGND VNB sky130_fd_pr__nfet_01v8 m=1 w=0.42u l=0.15u mult=1 sa=0.265
+ sb=0.265 sd=0.28 area=0.063 perim=1.14
MI107 p0 SCE net59 VNB sky130_fd_pr__pfet_01v8_hvt m=1 w=0.42u l=0.15u mult=1 sa=0.265
+ sb=0.265 sd=0.28 area=0.063 perim=1.14
MI94 net105 D p0 VNB sky130_fd_pr__pfet_01v8_hvt m=1 w=0.42u l=0.15u mult=1 sa=0.265
+ sb=0.265 sd=0.28 area=0.063 perim=1.14
MI101 net105 sceb p1 VNB sky130_fd_pr__pfet_01v8_hvt m=1 w=0.64u l=0.15u mult=1
+ sa=0.265 sb=0.265 sd=0.28 area=0.063 perim=1.14
MI108 p1 SCD net59 VNB sky130_fd_pr__pfet_01v8_hvt m=1 w=0.64u l=0.15u mult=1 sa=0.265
+ sb=0.265 sd=0.28 area=0.063 perim=1.14
MI679 M1 SET_B net59 VNB sky130_fd_pr__pfet_01v8_hvt m=1 w=0.42u l=0.15u mult=1
+ sa=0.265 sb=0.265 sd=0.28 area=0.063 perim=1.14
MI669 S0 clkneg net265 VNB sky130_fd_pr__pfet_01v8_hvt m=1 w=0.42u l=0.15u mult=1
+ sa=0.265 sb=0.265 sd=0.28 area=0.063 perim=1.14
MI660 Q net213 net59 VNB sky130_fd_pr__pfet_01v8_hvt m=2 w=1.0u l=0.15u mult=1 sa=0.265
+ sb=0.265 sd=0.28 area=0.063 perim=1.14
MI9 net117 S0 net268 VNB sky130_fd_pr__pfet_01v8_hvt m=1 w=0.84u l=0.15u mult=1
+ sa=0.265 sb=0.265 sd=0.28 area=0.063 perim=1.14
MI670 net265 M1 net59 VNB sky130_fd_pr__pfet_01v8_hvt m=1 w=0.84u l=0.15u mult=1
+ sa=0.265 sb=0.265 sd=0.28 area=0.063 perim=1.14
MI678 net216 RESET net59 VNB sky130_fd_pr__pfet_01v8_hvt m=1 w=0.84u l=0.15u mult=1
+ sa=0.265 sb=0.265 sd=0.28 area=0.063 perim=1.14
MI662 net257 net117 net59 VNB sky130_fd_pr__pfet_01v8_hvt m=1 w=0.42u l=0.15u mult=1
+ sa=0.265 sb=0.265 sd=0.28 area=0.063 perim=1.14
MI664 S0 clkpos net257 VNB sky130_fd_pr__pfet_01v8_hvt m=1 w=0.42u l=0.15u mult=1
+ sa=0.265 sb=0.265 sd=0.28 area=0.063 perim=1.14
MI10 net117 SET_B net59 VNB sky130_fd_pr__pfet_01v8_hvt m=1 w=0.42u l=0.15u mult=1
+ sa=0.265 sb=0.265 sd=0.28 area=0.063 perim=1.14
MI11 net268 RESET net59 VNB sky130_fd_pr__pfet_01v8_hvt m=1 w=0.84u l=0.15u mult=1
+ sa=0.265 sb=0.265 sd=0.28 area=0.063 perim=1.14
MI650 net241 M1 net59 VNB sky130_fd_pr__pfet_01v8_hvt m=1 w=0.42u l=0.15u mult=1
+ sa=0.265 sb=0.265 sd=0.28 area=0.063 perim=1.14
MI43 net105 clkpos M0 VNB sky130_fd_pr__pfet_01v8_hvt m=1 w=0.42u l=0.15u mult=1
+ sa=0.265 sb=0.265 sd=0.28 area=0.063 perim=1.14
MI656 M0 clkneg net241 VNB sky130_fd_pr__pfet_01v8_hvt m=1 w=0.42u l=0.15u mult=1
+ sa=0.265 sb=0.265 sd=0.28 area=0.063 perim=1.14
MI643 RESET RESET_B net59 VNB sky130_fd_pr__pfet_01v8_hvt m=1 w=0.64u l=0.15u mult=1
+ sa=0.265 sb=0.265 sd=0.28 area=0.063 perim=1.14
MI47 clkneg clkpos net59 VNB sky130_fd_pr__pfet_01v8_hvt m=1 w=0.64u l=0.15u mult=1
+ sa=0.265 sb=0.265 sd=0.28 area=0.063 perim=1.14
MI45 clkpos CLK_N net59 VNB sky130_fd_pr__pfet_01v8_hvt m=1 w=0.64u l=0.15u mult=1
+ sa=0.265 sb=0.265 sd=0.28 area=0.063 perim=1.14
MI680 M1 M0 net216 VNB sky130_fd_pr__pfet_01v8_hvt m=1 w=0.84u l=0.15u mult=1 sa=0.265
+ sb=0.265 sd=0.28 area=0.063 perim=1.14
MI663 net213 net117 net59 VNB sky130_fd_pr__pfet_01v8_hvt m=1 w=0.64u l=0.15u mult=1
+ sa=0.265 sb=0.265 sd=0.28 area=0.063 perim=1.14
MI661 Q_N net117 net59 VNB sky130_fd_pr__pfet_01v8_hvt m=2 w=1.0u l=0.15u mult=1
+ sa=0.265 sb=0.265 sd=0.28 area=0.063 perim=1.14
MI640 sceb SCE net59 VNB sky130_fd_pr__pfet_01v8_hvt m=1 w=0.42u l=0.15u mult=1
+ sa=0.265 sb=0.265 sd=0.28 area=0.063 perim=1.14
.ENDS sky130_fd_sc_hd__sdfbbn_2
* Copyright 2020 The SkyWater PDK Authors
*
* Licensed under the Apache License, Version 2.0 (the "License");
* you may not use this file except in compliance with the License.
* You may obtain a copy of the License at
*
*     https:  www.apache.org licenses LICENSE-2.0
*
* Unless required by applicable law or agreed to in writing, software
* distributed under the License is distributed on an "AS IS" BASIS,
* WITHOUT WARRANTIES OR CONDITIONS OF ANY KIND, either express or implied.
* See the License for the specific language governing permissions and
* limitations under the License.
*
* SPDX-License-Identifier: Apache-2.0

.SUBCKT sky130_fd_sc_hd__sdfbbp_1 CLK D RESET_B SCD SCE SET_B VGND VNB VNB net59 Q Q_N
*.PININFO CLK:I D:I RESET_B:I SCD:I SCE:I SET_B:I VGND:I VNB:I VNB:I
*.PININFO net59:I Q:O Q_N:O
MI98 net105 D n0 VNB sky130_fd_pr__nfet_01v8 m=1 w=0.42u l=0.15u mult=1 sa=0.265
+ sb=0.265 sd=0.28 area=0.525 perim=3.1
MI103 n1 SCD VGND VNB sky130_fd_pr__nfet_01v8 m=1 w=0.42u l=0.15u mult=1 sa=0.265
+ sb=0.265 sd=0.28 area=0.525 perim=3.1
MI104 n0 sceb VGND VNB sky130_fd_pr__nfet_01v8 m=1 w=0.42u l=0.15u mult=1 sa=0.265
+ sb=0.265 sd=0.28 area=0.525 perim=3.1
MI120 net105 SCE n1 VNB sky130_fd_pr__nfet_01v8 m=1 w=0.42u l=0.15u mult=1 sa=0.265
+ sb=0.265 sd=0.28 area=0.525 perim=3.1
MI46 clkpos clkneg VGND VNB sky130_fd_pr__nfet_01v8 m=1 w=0.42u l=0.15u mult=1
+ sa=0.265 sb=0.265 sd=0.28 area=0.063 perim=1.14
MI642 RESET RESET_B VGND VNB sky130_fd_pr__nfet_01v8 m=1 w=0.42u l=0.15u mult=1
+ sa=0.265 sb=0.265 sd=0.28 area=0.063 perim=1.14
MI676 M1 M0 net176 VNB sky130_fd_pr__nfet_01v8 m=1 w=0.64u l=0.15u mult=1 sa=0.265
+ sb=0.265 sd=0.28 area=0.063 perim=1.14
MI675 net176 SET_B VGND VNB sky130_fd_pr__nfet_01v8 m=1 w=0.42u l=0.15u mult=1
+ sa=0.265 sb=0.265 sd=0.28 area=0.063 perim=1.14
MI653 Q net213 VGND VNB sky130_fd_pr__nfet_01v8 m=1 w=0.65u l=0.15u mult=1 sa=0.265
+ sb=0.265 sd=0.28 area=0.063 perim=1.14
MI677 M1 RESET net176 VNB sky130_fd_pr__nfet_01v8 m=1 w=0.64u l=0.15u mult=1 sa=0.265
+ sb=0.265 sd=0.28 area=0.063 perim=1.14
MI648 M0 clkpos net160 VNB sky130_fd_pr__nfet_01v8 m=1 w=0.36u l=0.15u mult=1 sa=0.265
+ sb=0.265 sd=0.28 area=0.063 perim=1.14
MI44 clkneg CLK VGND VNB sky130_fd_pr__nfet_01v8 m=1 w=0.42u l=0.15u mult=1 sa=0.265
+ sb=0.265 sd=0.28 area=0.063 perim=1.14
MI649 net160 M1 VGND VNB sky130_fd_pr__nfet_01v8 m=1 w=0.42u l=0.15u mult=1 sa=0.265
+ sb=0.265 sd=0.28 area=0.063 perim=1.14
MI655 S0 clkneg net145 VNB sky130_fd_pr__nfet_01v8 m=1 w=0.36u l=0.15u mult=1 sa=0.265
+ sb=0.265 sd=0.28 area=0.063 perim=1.14
MI654 net145 net117 VGND VNB sky130_fd_pr__nfet_01v8 m=1 w=0.42u l=0.15u mult=1
+ sa=0.265 sb=0.265 sd=0.28 area=0.063 perim=1.14
MI651 Q_N net117 VGND VNB sky130_fd_pr__nfet_01v8 m=1 w=0.65u l=0.15u mult=1 sa=0.265
+ sb=0.265 sd=0.28 area=0.063 perim=1.14
MI652 net213 net117 VGND VNB sky130_fd_pr__nfet_01v8 m=1 w=0.42u l=0.15u mult=1
+ sa=0.265 sb=0.265 sd=0.28 area=0.063 perim=1.14
MI42 net105 clkneg M0 VNB sky130_fd_pr__nfet_01v8 m=1 w=0.36u l=0.15u mult=1 sa=0.265
+ sb=0.265 sd=0.28 area=0.063 perim=1.14
MI668 S0 clkpos net125 VNB sky130_fd_pr__nfet_01v8 m=1 w=0.36u l=0.15u mult=1 sa=0.265
+ sb=0.265 sd=0.28 area=0.063 perim=1.14
MI667 net125 M1 VGND VNB sky130_fd_pr__nfet_01v8 m=1 w=0.64u l=0.15u mult=1 sa=0.265
+ sb=0.265 sd=0.28 area=0.063 perim=1.14
MI630 net117 RESET net116 VNB sky130_fd_pr__nfet_01v8 m=1 w=0.64u l=0.15u mult=1
+ sa=0.265 sb=0.265 sd=0.28 area=0.063 perim=1.14
MI3 net117 S0 net116 VNB sky130_fd_pr__nfet_01v8 m=1 w=0.64u l=0.15u mult=1 sa=0.265
+ sb=0.265 sd=0.28 area=0.063 perim=1.14
MI7 net116 SET_B VGND VNB sky130_fd_pr__nfet_01v8 m=1 w=0.42u l=0.15u mult=1 sa=0.265
+ sb=0.265 sd=0.28 area=0.063 perim=1.14
MI639 sceb SCE VGND VNB sky130_fd_pr__nfet_01v8 m=1 w=0.42u l=0.15u mult=1 sa=0.265
+ sb=0.265 sd=0.28 area=0.063 perim=1.14
MI107 p0 SCE net59 VNB sky130_fd_pr__pfet_01v8_hvt m=1 w=0.42u l=0.15u mult=1 sa=0.265
+ sb=0.265 sd=0.28 area=0.063 perim=1.14
MI94 net105 D p0 VNB sky130_fd_pr__pfet_01v8_hvt m=1 w=0.42u l=0.15u mult=1 sa=0.265
+ sb=0.265 sd=0.28 area=0.063 perim=1.14
MI101 net105 sceb p1 VNB sky130_fd_pr__pfet_01v8_hvt m=1 w=0.64u l=0.15u mult=1
+ sa=0.265 sb=0.265 sd=0.28 area=0.063 perim=1.14
MI108 p1 SCD net59 VNB sky130_fd_pr__pfet_01v8_hvt m=1 w=0.64u l=0.15u mult=1 sa=0.265
+ sb=0.265 sd=0.28 area=0.063 perim=1.14
MI679 M1 SET_B net59 VNB sky130_fd_pr__pfet_01v8_hvt m=1 w=0.42u l=0.15u mult=1
+ sa=0.265 sb=0.265 sd=0.28 area=0.063 perim=1.14
MI669 S0 clkneg net265 VNB sky130_fd_pr__pfet_01v8_hvt m=1 w=0.42u l=0.15u mult=1
+ sa=0.265 sb=0.265 sd=0.28 area=0.063 perim=1.14
MI660 Q net213 net59 VNB sky130_fd_pr__pfet_01v8_hvt m=1 w=1.0u l=0.15u mult=1 sa=0.265
+ sb=0.265 sd=0.28 area=0.063 perim=1.14
MI9 net117 S0 net268 VNB sky130_fd_pr__pfet_01v8_hvt m=1 w=0.84u l=0.15u mult=1
+ sa=0.265 sb=0.265 sd=0.28 area=0.063 perim=1.14
MI670 net265 M1 net59 VNB sky130_fd_pr__pfet_01v8_hvt m=1 w=0.84u l=0.15u mult=1
+ sa=0.265 sb=0.265 sd=0.28 area=0.063 perim=1.14
MI678 net216 RESET net59 VNB sky130_fd_pr__pfet_01v8_hvt m=1 w=0.84u l=0.15u mult=1
+ sa=0.265 sb=0.265 sd=0.28 area=0.063 perim=1.14
MI662 net257 net117 net59 VNB sky130_fd_pr__pfet_01v8_hvt m=1 w=0.42u l=0.15u mult=1
+ sa=0.265 sb=0.265 sd=0.28 area=0.063 perim=1.14
MI664 S0 clkpos net257 VNB sky130_fd_pr__pfet_01v8_hvt m=1 w=0.42u l=0.15u mult=1
+ sa=0.265 sb=0.265 sd=0.28 area=0.063 perim=1.14
MI10 net117 SET_B net59 VNB sky130_fd_pr__pfet_01v8_hvt m=1 w=0.42u l=0.15u mult=1
+ sa=0.265 sb=0.265 sd=0.28 area=0.063 perim=1.14
MI11 net268 RESET net59 VNB sky130_fd_pr__pfet_01v8_hvt m=1 w=0.84u l=0.15u mult=1
+ sa=0.265 sb=0.265 sd=0.28 area=0.063 perim=1.14
MI650 net241 M1 net59 VNB sky130_fd_pr__pfet_01v8_hvt m=1 w=0.42u l=0.15u mult=1
+ sa=0.265 sb=0.265 sd=0.28 area=0.063 perim=1.14
MI43 net105 clkpos M0 VNB sky130_fd_pr__pfet_01v8_hvt m=1 w=0.42u l=0.15u mult=1
+ sa=0.265 sb=0.265 sd=0.28 area=0.063 perim=1.14
MI656 M0 clkneg net241 VNB sky130_fd_pr__pfet_01v8_hvt m=1 w=0.42u l=0.15u mult=1
+ sa=0.265 sb=0.265 sd=0.28 area=0.063 perim=1.14
MI643 RESET RESET_B net59 VNB sky130_fd_pr__pfet_01v8_hvt m=1 w=0.64u l=0.15u mult=1
+ sa=0.265 sb=0.265 sd=0.28 area=0.063 perim=1.14
MI47 clkpos clkneg net59 VNB sky130_fd_pr__pfet_01v8_hvt m=1 w=0.64u l=0.15u mult=1
+ sa=0.265 sb=0.265 sd=0.28 area=0.063 perim=1.14
MI45 clkneg CLK net59 VNB sky130_fd_pr__pfet_01v8_hvt m=1 w=0.64u l=0.15u mult=1
+ sa=0.265 sb=0.265 sd=0.28 area=0.063 perim=1.14
MI680 M1 M0 net216 VNB sky130_fd_pr__pfet_01v8_hvt m=1 w=0.84u l=0.15u mult=1 sa=0.265
+ sb=0.265 sd=0.28 area=0.063 perim=1.14
MI663 net213 net117 net59 VNB sky130_fd_pr__pfet_01v8_hvt m=1 w=0.64u l=0.15u mult=1
+ sa=0.265 sb=0.265 sd=0.28 area=0.063 perim=1.14
MI661 Q_N net117 net59 VNB sky130_fd_pr__pfet_01v8_hvt m=1 w=1.0u l=0.15u mult=1
+ sa=0.265 sb=0.265 sd=0.28 area=0.063 perim=1.14
MI640 sceb SCE net59 VNB sky130_fd_pr__pfet_01v8_hvt m=1 w=0.42u l=0.15u mult=1
+ sa=0.265 sb=0.265 sd=0.28 area=0.063 perim=1.14
.ENDS sky130_fd_sc_hd__sdfbbp_1
* Copyright 2020 The SkyWater PDK Authors
*
* Licensed under the Apache License, Version 2.0 (the "License");
* you may not use this file except in compliance with the License.
* You may obtain a copy of the License at
*
*     https:  www.apache.org licenses LICENSE-2.0
*
* Unless required by applicable law or agreed to in writing, software
* distributed under the License is distributed on an "AS IS" BASIS,
* WITHOUT WARRANTIES OR CONDITIONS OF ANY KIND, either express or implied.
* See the License for the specific language governing permissions and
* limitations under the License.
*
* SPDX-License-Identifier: Apache-2.0

.SUBCKT sky130_fd_sc_hd__sdfrbp_1 CLK D RESET_B SCD SCE VGND VNB VNB net59 Q Q_N
*.PININFO CLK:I D:I RESET_B:I SCD:I SCE:I VGND:I VNB:I VNB:I net59:I
*.PININFO Q:O Q_N:O
MI642 clkneg CLK VGND VNB sky130_fd_pr__nfet_01v8 m=1 w=0.65u l=0.15u mult=1 sa=0.265
+ sb=0.265 sd=0.28 area=0.063 perim=1.14
MI636 clkpos clkneg VGND VNB sky130_fd_pr__nfet_01v8 m=1 w=0.65u l=0.15u mult=1
+ sa=0.265 sb=0.265 sd=0.28 area=0.063 perim=1.14
MI42 db clkneg M0 VNB sky130_fd_pr__nfet_01v8 m=1 w=0.36u l=0.15u mult=1 sa=0.265
+ sb=0.265 sd=0.28 area=0.063 perim=1.14
MI656 net92 S0 net134 VNB sky130_fd_pr__nfet_01v8 m=1 w=0.42u l=0.15u mult=1 sa=0.265
+ sb=0.265 sd=0.28 area=0.063 perim=1.14
MI657 net134 RESET_B VGND VNB sky130_fd_pr__nfet_01v8 m=1 w=0.42u l=0.15u mult=1
+ sa=0.265 sb=0.265 sd=0.28 area=0.063 perim=1.14
MI33 net127 RESET_B VGND VNB sky130_fd_pr__nfet_01v8 m=1 w=0.42u l=0.15u mult=1
+ sa=0.265 sb=0.265 sd=0.28 area=0.063 perim=1.14
MI634 sceb SCE VGND VNB sky130_fd_pr__nfet_01v8 m=1 w=0.42u l=0.15u mult=1 sa=0.265
+ sb=0.265 sd=0.28 area=0.063 perim=1.14
MI4 M0 clkpos net115 VNB sky130_fd_pr__nfet_01v8 m=1 w=0.36u l=0.15u mult=1 sa=0.265
+ sb=0.265 sd=0.28 area=0.063 perim=1.14
MI34 net115 M1 net127 VNB sky130_fd_pr__nfet_01v8 m=1 w=0.42u l=0.15u mult=1 sa=0.265
+ sb=0.265 sd=0.28 area=0.063 perim=1.14
MI655 S0 clkneg net103 VNB sky130_fd_pr__nfet_01v8 m=1 w=0.36u l=0.15u mult=1 sa=0.265
+ sb=0.265 sd=0.28 area=0.063 perim=1.14
MI652 Q net92 VGND VNB sky130_fd_pr__nfet_01v8 m=1 w=0.65u l=0.15u mult=1 sa=0.265
+ sb=0.265 sd=0.28 area=0.063 perim=1.14
MI654 net103 net92 VGND VNB sky130_fd_pr__nfet_01v8 m=1 w=0.42u l=0.15u mult=1
+ sa=0.265 sb=0.265 sd=0.28 area=0.063 perim=1.14
MI647 M1 M0 VGND VNB sky130_fd_pr__nfet_01v8 m=1 w=0.64u l=0.15u mult=1 sa=0.265
+ sb=0.265 sd=0.28 area=0.063 perim=1.14
MI649 M1 clkpos S0 VNB sky130_fd_pr__nfet_01v8 m=1 w=0.36u l=0.15u mult=1 sa=0.265
+ sb=0.265 sd=0.28 area=0.063 perim=1.14
MI672 net171 net92 VGND VNB sky130_fd_pr__nfet_01v8 m=1 w=0.52u l=0.15u mult=1
+ sa=0.265 sb=0.265 sd=0.28 area=0.063 perim=1.14
MI670 Q_N net171 VGND VNB sky130_fd_pr__nfet_01v8 m=1 w=0.52u l=0.15u mult=1 sa=0.265
+ sb=0.265 sd=0.28 area=0.063 perim=1.14
MI98 db D n0 VNB sky130_fd_pr__nfet_01v8 m=1 w=0.42u l=0.15u mult=1 sa=0.265 sb=0.265
+ sd=0.28 area=0.525 perim=3.1
MI103 n1 SCD VGND VNB sky130_fd_pr__nfet_01v8 m=1 w=0.42u l=0.18u mult=1 sa=0.265
+ sb=0.265 sd=0.28 area=0.525 perim=3.1
MI120 db SCE n1 VNB sky130_fd_pr__nfet_01v8 m=1 w=0.42u l=0.5u mult=1 sa=0.265
+ sb=0.265 sd=0.28 area=0.525 perim=3.1
MI104 n0 sceb VGND VNB sky130_fd_pr__nfet_01v8 m=1 w=0.42u l=0.15u mult=1 sa=0.265
+ sb=0.265 sd=0.28 area=0.525 perim=3.1
MI643 clkneg CLK net59 VNB sky130_fd_pr__pfet_01v8_hvt m=1 w=1.0u l=0.15u mult=1
+ sa=0.265 sb=0.265 sd=0.28 area=0.063 perim=1.14
MI635 clkpos clkneg net59 VNB sky130_fd_pr__pfet_01v8_hvt m=1 w=1.0u l=0.15u mult=1
+ sa=0.265 sb=0.265 sd=0.28 area=0.063 perim=1.14
MI43 db clkpos M0 VNB sky130_fd_pr__pfet_01v8_hvt m=1 w=0.42u l=0.15u mult=1 sa=0.265
+ sb=0.265 sd=0.28 area=0.063 perim=1.14
MI662 net215 net92 net59 VNB sky130_fd_pr__pfet_01v8_hvt m=1 w=0.42u l=0.15u mult=1
+ sa=0.265 sb=0.265 sd=0.28 area=0.063 perim=1.14
MI659 net92 RESET_B net59 VNB sky130_fd_pr__pfet_01v8_hvt m=1 w=0.42u l=0.15u mult=1
+ sa=0.265 sb=0.265 sd=0.28 area=0.063 perim=1.14
MI664 S0 clkpos net215 VNB sky130_fd_pr__pfet_01v8_hvt m=1 w=0.42u l=0.15u mult=1
+ sa=0.265 sb=0.265 sd=0.28 area=0.063 perim=1.14
MI658 net92 S0 net59 VNB sky130_fd_pr__pfet_01v8_hvt m=1 w=0.42u l=0.15u mult=1
+ sa=0.265 sb=0.265 sd=0.28 area=0.063 perim=1.14
MI30 net194 M1 net59 VNB sky130_fd_pr__pfet_01v8_hvt m=1 w=0.42u l=0.15u mult=1
+ sa=0.265 sb=0.265 sd=0.28 area=0.063 perim=1.14
MI31 M0 clkneg net194 VNB sky130_fd_pr__pfet_01v8_hvt m=1 w=0.42u l=0.15u mult=1
+ sa=0.265 sb=0.265 sd=0.28 area=0.063 perim=1.14
MI32 net194 RESET_B net59 VNB sky130_fd_pr__pfet_01v8_hvt m=1 w=0.42u l=0.15u mult=1
+ sa=0.265 sb=0.265 sd=0.28 area=0.063 perim=1.14
MI663 Q net92 net59 VNB sky130_fd_pr__pfet_01v8_hvt m=1 w=1.0u l=0.15u mult=1 sa=0.265
+ sb=0.265 sd=0.28 area=0.063 perim=1.14
MI648 M1 M0 net59 VNB sky130_fd_pr__pfet_01v8_hvt m=1 w=0.84u l=0.15u mult=1 sa=0.265
+ sb=0.265 sd=0.28 area=0.063 perim=1.14
MI650 M1 clkneg S0 VNB sky130_fd_pr__pfet_01v8_hvt m=1 w=0.42u l=0.15u mult=1 sa=0.265
+ sb=0.265 sd=0.28 area=0.063 perim=1.14
MI633 sceb SCE net59 VNB sky130_fd_pr__pfet_01v8_hvt m=1 w=0.54u l=0.15u mult=1
+ sa=0.265 sb=0.265 sd=0.28 area=0.063 perim=1.14
MI673 net171 net92 net59 VNB sky130_fd_pr__pfet_01v8_hvt m=1 w=0.79u l=0.15u mult=1
+ sa=0.265 sb=0.265 sd=0.28 area=0.063 perim=1.14
MI671 Q_N net171 net59 VNB sky130_fd_pr__pfet_01v8_hvt m=1 w=0.79u l=0.15u mult=1
+ sa=0.265 sb=0.265 sd=0.28 area=0.063 perim=1.14
MI101 db sceb p1 VNB sky130_fd_pr__pfet_01v8_hvt m=1 w=0.54u l=0.15u mult=1 sa=0.265
+ sb=0.265 sd=0.28 area=0.063 perim=1.14
MI107 p0 SCE net59 VNB sky130_fd_pr__pfet_01v8_hvt m=1 w=0.54u l=0.15u mult=1 sa=0.265
+ sb=0.265 sd=0.28 area=0.063 perim=1.14
MI94 db D p0 VNB sky130_fd_pr__pfet_01v8_hvt m=1 w=0.54u l=0.15u mult=1 sa=0.265
+ sb=0.265 sd=0.28 area=0.063 perim=1.14
MI108 p1 SCD net59 VNB sky130_fd_pr__pfet_01v8_hvt m=1 w=0.54u l=0.15u mult=1 sa=0.265
+ sb=0.265 sd=0.28 area=0.063 perim=1.14
.ENDS sky130_fd_sc_hd__sdfrbp_1
* Copyright 2020 The SkyWater PDK Authors
*
* Licensed under the Apache License, Version 2.0 (the "License");
* you may not use this file except in compliance with the License.
* You may obtain a copy of the License at
*
*     https:  www.apache.org licenses LICENSE-2.0
*
* Unless required by applicable law or agreed to in writing, software
* distributed under the License is distributed on an "AS IS" BASIS,
* WITHOUT WARRANTIES OR CONDITIONS OF ANY KIND, either express or implied.
* See the License for the specific language governing permissions and
* limitations under the License.
*
* SPDX-License-Identifier: Apache-2.0

.SUBCKT sky130_fd_sc_hd__sdfrbp_2 CLK D RESET_B SCD SCE VGND VNB VNB net59 Q Q_N
*.PININFO CLK:I D:I RESET_B:I SCD:I SCE:I VGND:I VNB:I VNB:I net59:I
*.PININFO Q:O Q_N:O
MI642 clkneg CLK VGND VNB sky130_fd_pr__nfet_01v8 m=1 w=0.65u l=0.15u mult=1 sa=0.265
+ sb=0.265 sd=0.28 area=0.063 perim=1.14
MI636 clkpos clkneg VGND VNB sky130_fd_pr__nfet_01v8 m=1 w=0.65u l=0.15u mult=1
+ sa=0.265 sb=0.265 sd=0.28 area=0.063 perim=1.14
MI42 db clkneg M0 VNB sky130_fd_pr__nfet_01v8 m=1 w=0.36u l=0.15u mult=1 sa=0.265
+ sb=0.265 sd=0.28 area=0.063 perim=1.14
MI656 net92 S0 net134 VNB sky130_fd_pr__nfet_01v8 m=1 w=0.42u l=0.15u mult=1 sa=0.265
+ sb=0.265 sd=0.28 area=0.063 perim=1.14
MI657 net134 RESET_B VGND VNB sky130_fd_pr__nfet_01v8 m=1 w=0.42u l=0.15u mult=1
+ sa=0.265 sb=0.265 sd=0.28 area=0.063 perim=1.14
MI33 net127 RESET_B VGND VNB sky130_fd_pr__nfet_01v8 m=1 w=0.42u l=0.15u mult=1
+ sa=0.265 sb=0.265 sd=0.28 area=0.063 perim=1.14
MI634 sceb SCE VGND VNB sky130_fd_pr__nfet_01v8 m=1 w=0.42u l=0.15u mult=1 sa=0.265
+ sb=0.265 sd=0.28 area=0.063 perim=1.14
MI4 M0 clkpos net115 VNB sky130_fd_pr__nfet_01v8 m=1 w=0.36u l=0.15u mult=1 sa=0.265
+ sb=0.265 sd=0.28 area=0.063 perim=1.14
MI34 net115 M1 net127 VNB sky130_fd_pr__nfet_01v8 m=1 w=0.42u l=0.15u mult=1 sa=0.265
+ sb=0.265 sd=0.28 area=0.063 perim=1.14
MI655 S0 clkneg net110 VNB sky130_fd_pr__nfet_01v8 m=1 w=0.36u l=0.15u mult=1 sa=0.265
+ sb=0.265 sd=0.28 area=0.063 perim=1.14
MI652 Q net92 VGND VNB sky130_fd_pr__nfet_01v8 m=2 w=0.65u l=0.15u mult=1 sa=0.265
+ sb=0.265 sd=0.28 area=0.063 perim=1.14
MI654 net110 net92 VGND VNB sky130_fd_pr__nfet_01v8 m=1 w=0.42u l=0.15u mult=1
+ sa=0.265 sb=0.265 sd=0.28 area=0.063 perim=1.14
MI647 M1 M0 VGND VNB sky130_fd_pr__nfet_01v8 m=1 w=0.64u l=0.15u mult=1 sa=0.265
+ sb=0.265 sd=0.28 area=0.063 perim=1.14
MI649 M1 clkpos S0 VNB sky130_fd_pr__nfet_01v8 m=1 w=0.36u l=0.15u mult=1 sa=0.265
+ sb=0.265 sd=0.28 area=0.063 perim=1.14
MI672 net171 net92 VGND VNB sky130_fd_pr__nfet_01v8 m=1 w=0.42u l=0.15u mult=1
+ sa=0.265 sb=0.265 sd=0.28 area=0.063 perim=1.14
MI670 Q_N net171 VGND VNB sky130_fd_pr__nfet_01v8 m=2 w=0.65u l=0.15u mult=1 sa=0.265
+ sb=0.265 sd=0.28 area=0.063 perim=1.14
MI98 db D n0 VNB sky130_fd_pr__nfet_01v8 m=1 w=0.42u l=0.15u mult=1 sa=0.265 sb=0.265
+ sd=0.28 area=0.525 perim=3.1
MI103 n1 SCD VGND VNB sky130_fd_pr__nfet_01v8 m=1 w=0.42u l=0.18u mult=1 sa=0.265
+ sb=0.265 sd=0.28 area=0.525 perim=3.1
MI120 db SCE n1 VNB sky130_fd_pr__nfet_01v8 m=1 w=0.42u l=0.5u mult=1 sa=0.265
+ sb=0.265 sd=0.28 area=0.525 perim=3.1
MI104 n0 sceb VGND VNB sky130_fd_pr__nfet_01v8 m=1 w=0.42u l=0.15u mult=1 sa=0.265
+ sb=0.265 sd=0.28 area=0.525 perim=3.1
MI643 clkneg CLK net59 VNB sky130_fd_pr__pfet_01v8_hvt m=1 w=1.0u l=0.15u mult=1
+ sa=0.265 sb=0.265 sd=0.28 area=0.063 perim=1.14
MI635 clkpos clkneg net59 VNB sky130_fd_pr__pfet_01v8_hvt m=1 w=1.0u l=0.15u mult=1
+ sa=0.265 sb=0.265 sd=0.28 area=0.063 perim=1.14
MI43 db clkpos M0 VNB sky130_fd_pr__pfet_01v8_hvt m=1 w=0.42u l=0.15u mult=1 sa=0.265
+ sb=0.265 sd=0.28 area=0.063 perim=1.14
MI662 net215 net92 net59 VNB sky130_fd_pr__pfet_01v8_hvt m=1 w=0.42u l=0.15u mult=1
+ sa=0.265 sb=0.265 sd=0.28 area=0.063 perim=1.14
MI659 net92 RESET_B net59 VNB sky130_fd_pr__pfet_01v8_hvt m=1 w=0.42u l=0.15u mult=1
+ sa=0.265 sb=0.265 sd=0.28 area=0.063 perim=1.14
MI664 S0 clkpos net215 VNB sky130_fd_pr__pfet_01v8_hvt m=1 w=0.42u l=0.15u mult=1
+ sa=0.265 sb=0.265 sd=0.28 area=0.063 perim=1.14
MI658 net92 S0 net59 VNB sky130_fd_pr__pfet_01v8_hvt m=1 w=0.42u l=0.15u mult=1
+ sa=0.265 sb=0.265 sd=0.28 area=0.063 perim=1.14
MI30 net194 M1 net59 VNB sky130_fd_pr__pfet_01v8_hvt m=1 w=0.42u l=0.15u mult=1
+ sa=0.265 sb=0.265 sd=0.28 area=0.063 perim=1.14
MI31 M0 clkneg net194 VNB sky130_fd_pr__pfet_01v8_hvt m=1 w=0.42u l=0.15u mult=1
+ sa=0.265 sb=0.265 sd=0.28 area=0.063 perim=1.14
MI32 net194 RESET_B net59 VNB sky130_fd_pr__pfet_01v8_hvt m=1 w=0.42u l=0.15u mult=1
+ sa=0.265 sb=0.265 sd=0.28 area=0.063 perim=1.14
MI663 Q net92 net59 VNB sky130_fd_pr__pfet_01v8_hvt m=2 w=1.0u l=0.15u mult=1 sa=0.265
+ sb=0.265 sd=0.28 area=0.063 perim=1.14
MI648 M1 M0 net59 VNB sky130_fd_pr__pfet_01v8_hvt m=1 w=0.84u l=0.15u mult=1 sa=0.265
+ sb=0.265 sd=0.28 area=0.063 perim=1.14
MI650 M1 clkneg S0 VNB sky130_fd_pr__pfet_01v8_hvt m=1 w=0.42u l=0.15u mult=1 sa=0.265
+ sb=0.265 sd=0.28 area=0.063 perim=1.14
MI633 sceb SCE net59 VNB sky130_fd_pr__pfet_01v8_hvt m=1 w=0.54u l=0.15u mult=1
+ sa=0.265 sb=0.265 sd=0.28 area=0.063 perim=1.14
MI673 net171 net92 net59 VNB sky130_fd_pr__pfet_01v8_hvt m=1 w=0.64u l=0.15u mult=1
+ sa=0.265 sb=0.265 sd=0.28 area=0.063 perim=1.14
MI671 Q_N net171 net59 VNB sky130_fd_pr__pfet_01v8_hvt m=2 w=1.0u l=0.15u mult=1
+ sa=0.265 sb=0.265 sd=0.28 area=0.063 perim=1.14
MI101 db sceb p1 VNB sky130_fd_pr__pfet_01v8_hvt m=1 w=0.54u l=0.15u mult=1 sa=0.265
+ sb=0.265 sd=0.28 area=0.063 perim=1.14
MI107 p0 SCE net59 VNB sky130_fd_pr__pfet_01v8_hvt m=1 w=0.54u l=0.15u mult=1 sa=0.265
+ sb=0.265 sd=0.28 area=0.063 perim=1.14
MI94 db D p0 VNB sky130_fd_pr__pfet_01v8_hvt m=1 w=0.54u l=0.15u mult=1 sa=0.265
+ sb=0.265 sd=0.28 area=0.063 perim=1.14
MI108 p1 SCD net59 VNB sky130_fd_pr__pfet_01v8_hvt m=1 w=0.54u l=0.15u mult=1 sa=0.265
+ sb=0.265 sd=0.28 area=0.063 perim=1.14
.ENDS sky130_fd_sc_hd__sdfrbp_2
* Copyright 2020 The SkyWater PDK Authors
*
* Licensed under the Apache License, Version 2.0 (the "License");
* you may not use this file except in compliance with the License.
* You may obtain a copy of the License at
*
*     https:  www.apache.org licenses LICENSE-2.0
*
* Unless required by applicable law or agreed to in writing, software
* distributed under the License is distributed on an "AS IS" BASIS,
* WITHOUT WARRANTIES OR CONDITIONS OF ANY KIND, either express or implied.
* See the License for the specific language governing permissions and
* limitations under the License.
*
* SPDX-License-Identifier: Apache-2.0

.SUBCKT sky130_fd_sc_hd__sdfrtn_1 CLK_N D RESET_B SCD SCE VGND VNB VNB net59 Q
*.PININFO CLK_N:I D:I RESET_B:I SCD:I SCE:I VGND:I VNB:I VNB:I net59:I
*.PININFO Q:O
MI642 clkpos CLK_N VGND VNB sky130_fd_pr__nfet_01v8 m=1 w=0.65u l=0.15u mult=1
+ sa=0.265 sb=0.265 sd=0.28 area=0.063 perim=1.14
MI636 clkneg clkpos VGND VNB sky130_fd_pr__nfet_01v8 m=1 w=0.65u l=0.15u mult=1
+ sa=0.265 sb=0.265 sd=0.28 area=0.063 perim=1.14
MI42 db clkneg M0 VNB sky130_fd_pr__nfet_01v8 m=1 w=0.36u l=0.15u mult=1 sa=0.265
+ sb=0.265 sd=0.28 area=0.063 perim=1.14
MI656 net87 net153 net117 VNB sky130_fd_pr__nfet_01v8 m=1 w=0.42u l=0.15u mult=1
+ sa=0.265 sb=0.265 sd=0.28 area=0.063 perim=1.14
MI657 net117 RESET_B VGND VNB sky130_fd_pr__nfet_01v8 m=1 w=0.42u l=0.15u mult=1
+ sa=0.265 sb=0.265 sd=0.28 area=0.063 perim=1.14
MI33 net110 RESET_B VGND VNB sky130_fd_pr__nfet_01v8 m=1 w=0.42u l=0.15u mult=1
+ sa=0.265 sb=0.265 sd=0.28 area=0.063 perim=1.14
MI634 sceb SCE VGND VNB sky130_fd_pr__nfet_01v8 m=1 w=0.42u l=0.15u mult=1 sa=0.265
+ sb=0.265 sd=0.28 area=0.063 perim=1.14
MI4 M0 clkpos net98 VNB sky130_fd_pr__nfet_01v8 m=1 w=0.36u l=0.15u mult=1 sa=0.265
+ sb=0.265 sd=0.28 area=0.063 perim=1.14
MI34 net98 M1 net110 VNB sky130_fd_pr__nfet_01v8 m=1 w=0.42u l=0.15u mult=1 sa=0.265
+ sb=0.265 sd=0.28 area=0.063 perim=1.14
MI655 net153 clkneg net93 VNB sky130_fd_pr__nfet_01v8 m=1 w=0.36u l=0.15u mult=1
+ sa=0.265 sb=0.265 sd=0.28 area=0.063 perim=1.14
MI653 Q net87 VGND VNB sky130_fd_pr__nfet_01v8 m=1 w=0.65u l=0.15u mult=1 sa=0.265
+ sb=0.265 sd=0.28 area=0.063 perim=1.14
MI654 net93 net87 VGND VNB sky130_fd_pr__nfet_01v8 m=1 w=0.42u l=0.15u mult=1 sa=0.265
+ sb=0.265 sd=0.28 area=0.063 perim=1.14
MI647 M1 M0 VGND VNB sky130_fd_pr__nfet_01v8 m=1 w=0.64u l=0.15u mult=1 sa=0.265
+ sb=0.265 sd=0.28 area=0.063 perim=1.14
MI649 M1 clkpos net153 VNB sky130_fd_pr__nfet_01v8 m=1 w=0.36u l=0.15u mult=1 sa=0.265
+ sb=0.265 sd=0.28 area=0.063 perim=1.14
MI98 db D n0 VNB sky130_fd_pr__nfet_01v8 m=1 w=0.42u l=0.15u mult=1 sa=0.265 sb=0.265
+ sd=0.28 area=0.525 perim=3.1
MI103 n1 SCD VGND VNB sky130_fd_pr__nfet_01v8 m=1 w=0.42u l=0.18u mult=1 sa=0.265
+ sb=0.265 sd=0.28 area=0.525 perim=3.1
MI120 db SCE n1 VNB sky130_fd_pr__nfet_01v8 m=1 w=0.42u l=0.5u mult=1 sa=0.265
+ sb=0.265 sd=0.28 area=0.525 perim=3.1
MI104 n0 sceb VGND VNB sky130_fd_pr__nfet_01v8 m=1 w=0.42u l=0.15u mult=1 sa=0.265
+ sb=0.265 sd=0.28 area=0.525 perim=3.1
MI643 clkpos CLK_N net59 VNB sky130_fd_pr__pfet_01v8_hvt m=1 w=1.0u l=0.15u mult=1
+ sa=0.265 sb=0.265 sd=0.28 area=0.063 perim=1.14
MI635 clkneg clkpos net59 VNB sky130_fd_pr__pfet_01v8_hvt m=1 w=1.0u l=0.15u mult=1
+ sa=0.265 sb=0.265 sd=0.28 area=0.063 perim=1.14
MI43 db clkpos M0 VNB sky130_fd_pr__pfet_01v8_hvt m=1 w=0.42u l=0.15u mult=1 sa=0.265
+ sb=0.265 sd=0.28 area=0.063 perim=1.14
MI662 net190 net87 net59 VNB sky130_fd_pr__pfet_01v8_hvt m=1 w=0.42u l=0.15u mult=1
+ sa=0.265 sb=0.265 sd=0.28 area=0.063 perim=1.14
MI659 net87 RESET_B net59 VNB sky130_fd_pr__pfet_01v8_hvt m=1 w=0.42u l=0.15u mult=1
+ sa=0.265 sb=0.265 sd=0.28 area=0.063 perim=1.14
MI664 net153 clkpos net190 VNB sky130_fd_pr__pfet_01v8_hvt m=1 w=0.42u l=0.15u mult=1
+ sa=0.265 sb=0.265 sd=0.28 area=0.063 perim=1.14
MI658 net87 net153 net59 VNB sky130_fd_pr__pfet_01v8_hvt m=1 w=0.42u l=0.15u mult=1
+ sa=0.265 sb=0.265 sd=0.28 area=0.063 perim=1.14
MI30 net169 M1 net59 VNB sky130_fd_pr__pfet_01v8_hvt m=1 w=0.42u l=0.15u mult=1
+ sa=0.265 sb=0.265 sd=0.28 area=0.063 perim=1.14
MI31 M0 clkneg net169 VNB sky130_fd_pr__pfet_01v8_hvt m=1 w=0.42u l=0.15u mult=1
+ sa=0.265 sb=0.265 sd=0.28 area=0.063 perim=1.14
MI32 net169 RESET_B net59 VNB sky130_fd_pr__pfet_01v8_hvt m=1 w=0.42u l=0.15u mult=1
+ sa=0.265 sb=0.265 sd=0.28 area=0.063 perim=1.14
MI660 Q net87 net59 VNB sky130_fd_pr__pfet_01v8_hvt m=1 w=1.0u l=0.15u mult=1 sa=0.265
+ sb=0.265 sd=0.28 area=0.063 perim=1.14
MI648 M1 M0 net59 VNB sky130_fd_pr__pfet_01v8_hvt m=1 w=0.84u l=0.15u mult=1 sa=0.265
+ sb=0.265 sd=0.28 area=0.063 perim=1.14
MI650 M1 clkneg net153 VNB sky130_fd_pr__pfet_01v8_hvt m=1 w=0.42u l=0.15u mult=1
+ sa=0.265 sb=0.265 sd=0.28 area=0.063 perim=1.14
MI633 sceb SCE net59 VNB sky130_fd_pr__pfet_01v8_hvt m=1 w=0.54u l=0.15u mult=1
+ sa=0.265 sb=0.265 sd=0.28 area=0.063 perim=1.14
MI101 db sceb p1 VNB sky130_fd_pr__pfet_01v8_hvt m=1 w=0.54u l=0.15u mult=1 sa=0.265
+ sb=0.265 sd=0.28 area=0.063 perim=1.14
MI107 p0 SCE net59 VNB sky130_fd_pr__pfet_01v8_hvt m=1 w=0.54u l=0.15u mult=1 sa=0.265
+ sb=0.265 sd=0.28 area=0.063 perim=1.14
MI94 db D p0 VNB sky130_fd_pr__pfet_01v8_hvt m=1 w=0.54u l=0.15u mult=1 sa=0.265
+ sb=0.265 sd=0.28 area=0.063 perim=1.14
MI108 p1 SCD net59 VNB sky130_fd_pr__pfet_01v8_hvt m=1 w=0.54u l=0.15u mult=1 sa=0.265
+ sb=0.265 sd=0.28 area=0.063 perim=1.14
.ENDS sky130_fd_sc_hd__sdfrtn_1
* Copyright 2020 The SkyWater PDK Authors
*
* Licensed under the Apache License, Version 2.0 (the "License");
* you may not use this file except in compliance with the License.
* You may obtain a copy of the License at
*
*     https:  www.apache.org licenses LICENSE-2.0
*
* Unless required by applicable law or agreed to in writing, software
* distributed under the License is distributed on an "AS IS" BASIS,
* WITHOUT WARRANTIES OR CONDITIONS OF ANY KIND, either express or implied.
* See the License for the specific language governing permissions and
* limitations under the License.
*
* SPDX-License-Identifier: Apache-2.0

.SUBCKT sky130_fd_sc_hd__sdfrtp_1 CLK D RESET_B SCD SCE VGND VNB VNB net59 Q
*.PININFO CLK:I D:I RESET_B:I SCD:I SCE:I VGND:I VNB:I VNB:I net59:I
*.PININFO Q:O
MI642 clkneg CLK VGND VNB sky130_fd_pr__nfet_01v8 m=1 w=0.65u l=0.15u mult=1 sa=0.265
+ sb=0.265 sd=0.28 area=0.063 perim=1.14
MI636 clkpos clkneg VGND VNB sky130_fd_pr__nfet_01v8 m=1 w=0.65u l=0.15u mult=1
+ sa=0.265 sb=0.265 sd=0.28 area=0.063 perim=1.14
MI42 db clkneg M0 VNB sky130_fd_pr__nfet_01v8 m=1 w=0.36u l=0.15u mult=1 sa=0.265
+ sb=0.265 sd=0.28 area=0.063 perim=1.14
MI656 net84 S0 net114 VNB sky130_fd_pr__nfet_01v8 m=1 w=0.42u l=0.15u mult=1 sa=0.265
+ sb=0.265 sd=0.28 area=0.063 perim=1.14
MI657 net114 RESET_B VGND VNB sky130_fd_pr__nfet_01v8 m=1 w=0.42u l=0.15u mult=1
+ sa=0.265 sb=0.265 sd=0.28 area=0.063 perim=1.14
MI33 net107 RESET_B VGND VNB sky130_fd_pr__nfet_01v8 m=1 w=0.42u l=0.15u mult=1
+ sa=0.265 sb=0.265 sd=0.28 area=0.063 perim=1.14
MI634 sceb SCE VGND VNB sky130_fd_pr__nfet_01v8 m=1 w=0.42u l=0.15u mult=1 sa=0.265
+ sb=0.265 sd=0.28 area=0.063 perim=1.14
MI4 M0 clkpos net95 VNB sky130_fd_pr__nfet_01v8 m=1 w=0.36u l=0.15u mult=1 sa=0.265
+ sb=0.265 sd=0.28 area=0.063 perim=1.14
MI34 net95 M1 net107 VNB sky130_fd_pr__nfet_01v8 m=1 w=0.42u l=0.15u mult=1 sa=0.265
+ sb=0.265 sd=0.28 area=0.063 perim=1.14
MI655 S0 clkneg net83 VNB sky130_fd_pr__nfet_01v8 m=1 w=0.36u l=0.15u mult=1 sa=0.265
+ sb=0.265 sd=0.28 area=0.063 perim=1.14
MI652 Q net84 VGND VNB sky130_fd_pr__nfet_01v8 m=1 w=0.65u l=0.15u mult=1 sa=0.265
+ sb=0.265 sd=0.28 area=0.063 perim=1.14
MI654 net83 net84 VGND VNB sky130_fd_pr__nfet_01v8 m=1 w=0.42u l=0.15u mult=1 sa=0.265
+ sb=0.265 sd=0.28 area=0.063 perim=1.14
MI647 M1 M0 VGND VNB sky130_fd_pr__nfet_01v8 m=1 w=0.64u l=0.15u mult=1 sa=0.265
+ sb=0.265 sd=0.28 area=0.063 perim=1.14
MI649 M1 clkpos S0 VNB sky130_fd_pr__nfet_01v8 m=1 w=0.36u l=0.15u mult=1 sa=0.265
+ sb=0.265 sd=0.28 area=0.063 perim=1.14
MI98 db D n0 VNB sky130_fd_pr__nfet_01v8 m=1 w=0.42u l=0.15u mult=1 sa=0.265 sb=0.265
+ sd=0.28 area=0.525 perim=3.1
MI103 n1 SCD VGND VNB sky130_fd_pr__nfet_01v8 m=1 w=0.42u l=0.18u mult=1 sa=0.265
+ sb=0.265 sd=0.28 area=0.525 perim=3.1
MI120 db SCE n1 VNB sky130_fd_pr__nfet_01v8 m=1 w=0.42u l=0.5u mult=1 sa=0.265
+ sb=0.265 sd=0.28 area=0.525 perim=3.1
MI104 n0 sceb VGND VNB sky130_fd_pr__nfet_01v8 m=1 w=0.42u l=0.15u mult=1 sa=0.265
+ sb=0.265 sd=0.28 area=0.525 perim=3.1
MI643 clkneg CLK net59 VNB sky130_fd_pr__pfet_01v8_hvt m=1 w=1.0u l=0.15u mult=1
+ sa=0.265 sb=0.265 sd=0.28 area=0.063 perim=1.14
MI635 clkpos clkneg net59 VNB sky130_fd_pr__pfet_01v8_hvt m=1 w=1.0u l=0.15u mult=1
+ sa=0.265 sb=0.265 sd=0.28 area=0.063 perim=1.14
MI43 db clkpos M0 VNB sky130_fd_pr__pfet_01v8_hvt m=1 w=0.42u l=0.15u mult=1 sa=0.265
+ sb=0.265 sd=0.28 area=0.063 perim=1.14
MI662 net187 net84 net59 VNB sky130_fd_pr__pfet_01v8_hvt m=1 w=0.42u l=0.15u mult=1
+ sa=0.265 sb=0.265 sd=0.28 area=0.063 perim=1.14
MI659 net84 RESET_B net59 VNB sky130_fd_pr__pfet_01v8_hvt m=1 w=0.42u l=0.15u mult=1
+ sa=0.265 sb=0.265 sd=0.28 area=0.063 perim=1.14
MI664 S0 clkpos net187 VNB sky130_fd_pr__pfet_01v8_hvt m=1 w=0.42u l=0.15u mult=1
+ sa=0.265 sb=0.265 sd=0.28 area=0.063 perim=1.14
MI658 net84 S0 net59 VNB sky130_fd_pr__pfet_01v8_hvt m=1 w=0.42u l=0.15u mult=1
+ sa=0.265 sb=0.265 sd=0.28 area=0.063 perim=1.14
MI30 net166 M1 net59 VNB sky130_fd_pr__pfet_01v8_hvt m=1 w=0.42u l=0.15u mult=1
+ sa=0.265 sb=0.265 sd=0.28 area=0.063 perim=1.14
MI31 M0 clkneg net166 VNB sky130_fd_pr__pfet_01v8_hvt m=1 w=0.42u l=0.15u mult=1
+ sa=0.265 sb=0.265 sd=0.28 area=0.063 perim=1.14
MI32 net166 RESET_B net59 VNB sky130_fd_pr__pfet_01v8_hvt m=1 w=0.42u l=0.15u mult=1
+ sa=0.265 sb=0.265 sd=0.28 area=0.063 perim=1.14
MI663 Q net84 net59 VNB sky130_fd_pr__pfet_01v8_hvt m=1 w=1.0u l=0.15u mult=1 sa=0.265
+ sb=0.265 sd=0.28 area=0.063 perim=1.14
MI648 M1 M0 net59 VNB sky130_fd_pr__pfet_01v8_hvt m=1 w=0.84u l=0.15u mult=1 sa=0.265
+ sb=0.265 sd=0.28 area=0.063 perim=1.14
MI650 M1 clkneg S0 VNB sky130_fd_pr__pfet_01v8_hvt m=1 w=0.42u l=0.15u mult=1 sa=0.265
+ sb=0.265 sd=0.28 area=0.063 perim=1.14
MI633 sceb SCE net59 VNB sky130_fd_pr__pfet_01v8_hvt m=1 w=0.54u l=0.15u mult=1
+ sa=0.265 sb=0.265 sd=0.28 area=0.063 perim=1.14
MI101 db sceb p1 VNB sky130_fd_pr__pfet_01v8_hvt m=1 w=0.54u l=0.15u mult=1 sa=0.265
+ sb=0.265 sd=0.28 area=0.063 perim=1.14
MI107 p0 SCE net59 VNB sky130_fd_pr__pfet_01v8_hvt m=1 w=0.54u l=0.15u mult=1 sa=0.265
+ sb=0.265 sd=0.28 area=0.063 perim=1.14
MI94 db D p0 VNB sky130_fd_pr__pfet_01v8_hvt m=1 w=0.54u l=0.15u mult=1 sa=0.265
+ sb=0.265 sd=0.28 area=0.063 perim=1.14
MI108 p1 SCD net59 VNB sky130_fd_pr__pfet_01v8_hvt m=1 w=0.54u l=0.15u mult=1 sa=0.265
+ sb=0.265 sd=0.28 area=0.063 perim=1.14
.ENDS sky130_fd_sc_hd__sdfrtp_1
* Copyright 2020 The SkyWater PDK Authors
*
* Licensed under the Apache License, Version 2.0 (the "License");
* you may not use this file except in compliance with the License.
* You may obtain a copy of the License at
*
*     https:  www.apache.org licenses LICENSE-2.0
*
* Unless required by applicable law or agreed to in writing, software
* distributed under the License is distributed on an "AS IS" BASIS,
* WITHOUT WARRANTIES OR CONDITIONS OF ANY KIND, either express or implied.
* See the License for the specific language governing permissions and
* limitations under the License.
*
* SPDX-License-Identifier: Apache-2.0

.SUBCKT sky130_fd_sc_hd__sdfrtp_2 CLK D RESET_B SCD SCE VGND VNB VNB net59 Q
*.PININFO CLK:I D:I RESET_B:I SCD:I SCE:I VGND:I VNB:I VNB:I net59:I
*.PININFO Q:O
MI642 clkneg CLK VGND VNB sky130_fd_pr__nfet_01v8 m=1 w=0.65u l=0.15u mult=1 sa=0.265
+ sb=0.265 sd=0.28 area=0.063 perim=1.14
MI636 clkpos clkneg VGND VNB sky130_fd_pr__nfet_01v8 m=1 w=0.65u l=0.15u mult=1
+ sa=0.265 sb=0.265 sd=0.28 area=0.063 perim=1.14
MI42 db clkneg M0 VNB sky130_fd_pr__nfet_01v8 m=1 w=0.36u l=0.15u mult=1 sa=0.265
+ sb=0.265 sd=0.28 area=0.063 perim=1.14
MI656 net84 S0 net114 VNB sky130_fd_pr__nfet_01v8 m=1 w=0.42u l=0.15u mult=1 sa=0.265
+ sb=0.265 sd=0.28 area=0.063 perim=1.14
MI657 net114 RESET_B VGND VNB sky130_fd_pr__nfet_01v8 m=1 w=0.42u l=0.15u mult=1
+ sa=0.265 sb=0.265 sd=0.28 area=0.063 perim=1.14
MI33 net107 RESET_B VGND VNB sky130_fd_pr__nfet_01v8 m=1 w=0.42u l=0.15u mult=1
+ sa=0.265 sb=0.265 sd=0.28 area=0.063 perim=1.14
MI634 sceb SCE VGND VNB sky130_fd_pr__nfet_01v8 m=1 w=0.42u l=0.15u mult=1 sa=0.265
+ sb=0.265 sd=0.28 area=0.063 perim=1.14
MI4 M0 clkpos net95 VNB sky130_fd_pr__nfet_01v8 m=1 w=0.36u l=0.15u mult=1 sa=0.265
+ sb=0.265 sd=0.28 area=0.063 perim=1.14
MI34 net95 M1 net107 VNB sky130_fd_pr__nfet_01v8 m=1 w=0.42u l=0.15u mult=1 sa=0.265
+ sb=0.265 sd=0.28 area=0.063 perim=1.14
MI655 S0 clkneg net90 VNB sky130_fd_pr__nfet_01v8 m=1 w=0.36u l=0.15u mult=1 sa=0.265
+ sb=0.265 sd=0.28 area=0.063 perim=1.14
MI652 Q net84 VGND VNB sky130_fd_pr__nfet_01v8 m=2 w=0.65u l=0.15u mult=1 sa=0.265
+ sb=0.265 sd=0.28 area=0.063 perim=1.14
MI654 net90 net84 VGND VNB sky130_fd_pr__nfet_01v8 m=1 w=0.42u l=0.15u mult=1 sa=0.265
+ sb=0.265 sd=0.28 area=0.063 perim=1.14
MI647 M1 M0 VGND VNB sky130_fd_pr__nfet_01v8 m=1 w=0.64u l=0.15u mult=1 sa=0.265
+ sb=0.265 sd=0.28 area=0.063 perim=1.14
MI649 M1 clkpos S0 VNB sky130_fd_pr__nfet_01v8 m=1 w=0.36u l=0.15u mult=1 sa=0.265
+ sb=0.265 sd=0.28 area=0.063 perim=1.14
MI98 db D n0 VNB sky130_fd_pr__nfet_01v8 m=1 w=0.42u l=0.15u mult=1 sa=0.265 sb=0.265
+ sd=0.28 area=0.525 perim=3.1
MI103 n1 SCD VGND VNB sky130_fd_pr__nfet_01v8 m=1 w=0.42u l=0.18u mult=1 sa=0.265
+ sb=0.265 sd=0.28 area=0.525 perim=3.1
MI120 db SCE n1 VNB sky130_fd_pr__nfet_01v8 m=1 w=0.42u l=0.5u mult=1 sa=0.265
+ sb=0.265 sd=0.28 area=0.525 perim=3.1
MI104 n0 sceb VGND VNB sky130_fd_pr__nfet_01v8 m=1 w=0.42u l=0.15u mult=1 sa=0.265
+ sb=0.265 sd=0.28 area=0.525 perim=3.1
MI643 clkneg CLK net59 VNB sky130_fd_pr__pfet_01v8_hvt m=1 w=1.0u l=0.15u mult=1
+ sa=0.265 sb=0.265 sd=0.28 area=0.063 perim=1.14
MI635 clkpos clkneg net59 VNB sky130_fd_pr__pfet_01v8_hvt m=1 w=1.0u l=0.15u mult=1
+ sa=0.265 sb=0.265 sd=0.28 area=0.063 perim=1.14
MI43 db clkpos M0 VNB sky130_fd_pr__pfet_01v8_hvt m=1 w=0.42u l=0.15u mult=1 sa=0.265
+ sb=0.265 sd=0.28 area=0.063 perim=1.14
MI662 net187 net84 net59 VNB sky130_fd_pr__pfet_01v8_hvt m=1 w=0.42u l=0.15u mult=1
+ sa=0.265 sb=0.265 sd=0.28 area=0.063 perim=1.14
MI659 net84 RESET_B net59 VNB sky130_fd_pr__pfet_01v8_hvt m=1 w=0.42u l=0.15u mult=1
+ sa=0.265 sb=0.265 sd=0.28 area=0.063 perim=1.14
MI664 S0 clkpos net187 VNB sky130_fd_pr__pfet_01v8_hvt m=1 w=0.42u l=0.15u mult=1
+ sa=0.265 sb=0.265 sd=0.28 area=0.063 perim=1.14
MI658 net84 S0 net59 VNB sky130_fd_pr__pfet_01v8_hvt m=1 w=0.42u l=0.15u mult=1
+ sa=0.265 sb=0.265 sd=0.28 area=0.063 perim=1.14
MI30 net166 M1 net59 VNB sky130_fd_pr__pfet_01v8_hvt m=1 w=0.42u l=0.15u mult=1
+ sa=0.265 sb=0.265 sd=0.28 area=0.063 perim=1.14
MI31 M0 clkneg net166 VNB sky130_fd_pr__pfet_01v8_hvt m=1 w=0.42u l=0.15u mult=1
+ sa=0.265 sb=0.265 sd=0.28 area=0.063 perim=1.14
MI32 net166 RESET_B net59 VNB sky130_fd_pr__pfet_01v8_hvt m=1 w=0.42u l=0.15u mult=1
+ sa=0.265 sb=0.265 sd=0.28 area=0.063 perim=1.14
MI663 Q net84 net59 VNB sky130_fd_pr__pfet_01v8_hvt m=2 w=1.0u l=0.15u mult=1 sa=0.265
+ sb=0.265 sd=0.28 area=0.063 perim=1.14
MI648 M1 M0 net59 VNB sky130_fd_pr__pfet_01v8_hvt m=1 w=0.84u l=0.15u mult=1 sa=0.265
+ sb=0.265 sd=0.28 area=0.063 perim=1.14
MI650 M1 clkneg S0 VNB sky130_fd_pr__pfet_01v8_hvt m=1 w=0.42u l=0.15u mult=1 sa=0.265
+ sb=0.265 sd=0.28 area=0.063 perim=1.14
MI633 sceb SCE net59 VNB sky130_fd_pr__pfet_01v8_hvt m=1 w=0.54u l=0.15u mult=1
+ sa=0.265 sb=0.265 sd=0.28 area=0.063 perim=1.14
MI101 db sceb p1 VNB sky130_fd_pr__pfet_01v8_hvt m=1 w=0.54u l=0.15u mult=1 sa=0.265
+ sb=0.265 sd=0.28 area=0.063 perim=1.14
MI107 p0 SCE net59 VNB sky130_fd_pr__pfet_01v8_hvt m=1 w=0.54u l=0.15u mult=1 sa=0.265
+ sb=0.265 sd=0.28 area=0.063 perim=1.14
MI94 db D p0 VNB sky130_fd_pr__pfet_01v8_hvt m=1 w=0.54u l=0.15u mult=1 sa=0.265
+ sb=0.265 sd=0.28 area=0.063 perim=1.14
MI108 p1 SCD net59 VNB sky130_fd_pr__pfet_01v8_hvt m=1 w=0.54u l=0.15u mult=1 sa=0.265
+ sb=0.265 sd=0.28 area=0.063 perim=1.14
.ENDS sky130_fd_sc_hd__sdfrtp_2
* Copyright 2020 The SkyWater PDK Authors
*
* Licensed under the Apache License, Version 2.0 (the "License");
* you may not use this file except in compliance with the License.
* You may obtain a copy of the License at
*
*     https:  www.apache.org licenses LICENSE-2.0
*
* Unless required by applicable law or agreed to in writing, software
* distributed under the License is distributed on an "AS IS" BASIS,
* WITHOUT WARRANTIES OR CONDITIONS OF ANY KIND, either express or implied.
* See the License for the specific language governing permissions and
* limitations under the License.
*
* SPDX-License-Identifier: Apache-2.0

.SUBCKT sky130_fd_sc_hd__sdfrtp_4 CLK D RESET_B SCD SCE VGND VNB VNB net59 Q
*.PININFO CLK:I D:I RESET_B:I SCD:I SCE:I VGND:I VNB:I VNB:I net59:I
*.PININFO Q:O
MI642 clkneg CLK VGND VNB sky130_fd_pr__nfet_01v8 m=1 w=0.65u l=0.15u mult=1 sa=0.265
+ sb=0.265 sd=0.28 area=0.063 perim=1.14
MI636 clkpos clkneg VGND VNB sky130_fd_pr__nfet_01v8 m=1 w=0.65u l=0.15u mult=1
+ sa=0.265 sb=0.265 sd=0.28 area=0.063 perim=1.14
MI42 db clkneg M0 VNB sky130_fd_pr__nfet_01v8 m=1 w=0.36u l=0.15u mult=1 sa=0.265
+ sb=0.265 sd=0.28 area=0.063 perim=1.14
MI656 net84 S0 net114 VNB sky130_fd_pr__nfet_01v8 m=1 w=0.42u l=0.15u mult=1 sa=0.265
+ sb=0.265 sd=0.28 area=0.063 perim=1.14
MI657 net114 RESET_B VGND VNB sky130_fd_pr__nfet_01v8 m=1 w=0.42u l=0.15u mult=1
+ sa=0.265 sb=0.265 sd=0.28 area=0.063 perim=1.14
MI33 net107 RESET_B VGND VNB sky130_fd_pr__nfet_01v8 m=1 w=0.42u l=0.15u mult=1
+ sa=0.265 sb=0.265 sd=0.28 area=0.063 perim=1.14
MI634 sceb SCE VGND VNB sky130_fd_pr__nfet_01v8 m=1 w=0.42u l=0.15u mult=1 sa=0.265
+ sb=0.265 sd=0.28 area=0.063 perim=1.14
MI4 M0 clkpos net95 VNB sky130_fd_pr__nfet_01v8 m=1 w=0.36u l=0.15u mult=1 sa=0.265
+ sb=0.265 sd=0.28 area=0.063 perim=1.14
MI34 net95 M1 net107 VNB sky130_fd_pr__nfet_01v8 m=1 w=0.42u l=0.15u mult=1 sa=0.265
+ sb=0.265 sd=0.28 area=0.063 perim=1.14
MI655 S0 clkneg net90 VNB sky130_fd_pr__nfet_01v8 m=1 w=0.36u l=0.15u mult=1 sa=0.265
+ sb=0.265 sd=0.28 area=0.063 perim=1.14
MI652 Q net84 VGND VNB sky130_fd_pr__nfet_01v8 m=4 w=0.65u l=0.15u mult=1 sa=0.265
+ sb=0.265 sd=0.28 area=0.063 perim=1.14
MI654 net90 net84 VGND VNB sky130_fd_pr__nfet_01v8 m=1 w=0.42u l=0.15u mult=1 sa=0.265
+ sb=0.265 sd=0.28 area=0.063 perim=1.14
MI647 M1 M0 VGND VNB sky130_fd_pr__nfet_01v8 m=1 w=0.64u l=0.15u mult=1 sa=0.265
+ sb=0.265 sd=0.28 area=0.063 perim=1.14
MI649 M1 clkpos S0 VNB sky130_fd_pr__nfet_01v8 m=1 w=0.36u l=0.15u mult=1 sa=0.265
+ sb=0.265 sd=0.28 area=0.063 perim=1.14
MI98 db D n0 VNB sky130_fd_pr__nfet_01v8 m=1 w=0.42u l=0.15u mult=1 sa=0.265 sb=0.265
+ sd=0.28 area=0.525 perim=3.1
MI103 n1 SCD VGND VNB sky130_fd_pr__nfet_01v8 m=1 w=0.42u l=0.18u mult=1 sa=0.265
+ sb=0.265 sd=0.28 area=0.525 perim=3.1
MI120 db SCE n1 VNB sky130_fd_pr__nfet_01v8 m=1 w=0.42u l=0.5u mult=1 sa=0.265
+ sb=0.265 sd=0.28 area=0.525 perim=3.1
MI104 n0 sceb VGND VNB sky130_fd_pr__nfet_01v8 m=1 w=0.42u l=0.15u mult=1 sa=0.265
+ sb=0.265 sd=0.28 area=0.525 perim=3.1
MI643 clkneg CLK net59 VNB sky130_fd_pr__pfet_01v8_hvt m=1 w=1.0u l=0.15u mult=1
+ sa=0.265 sb=0.265 sd=0.28 area=0.063 perim=1.14
MI635 clkpos clkneg net59 VNB sky130_fd_pr__pfet_01v8_hvt m=1 w=1.0u l=0.15u mult=1
+ sa=0.265 sb=0.265 sd=0.28 area=0.063 perim=1.14
MI43 db clkpos M0 VNB sky130_fd_pr__pfet_01v8_hvt m=1 w=0.42u l=0.15u mult=1 sa=0.265
+ sb=0.265 sd=0.28 area=0.063 perim=1.14
MI662 net187 net84 net59 VNB sky130_fd_pr__pfet_01v8_hvt m=1 w=0.42u l=0.15u mult=1
+ sa=0.265 sb=0.265 sd=0.28 area=0.063 perim=1.14
MI659 net84 RESET_B net59 VNB sky130_fd_pr__pfet_01v8_hvt m=1 w=0.42u l=0.15u mult=1
+ sa=0.265 sb=0.265 sd=0.28 area=0.063 perim=1.14
MI664 S0 clkpos net187 VNB sky130_fd_pr__pfet_01v8_hvt m=1 w=0.42u l=0.15u mult=1
+ sa=0.265 sb=0.265 sd=0.28 area=0.063 perim=1.14
MI658 net84 S0 net59 VNB sky130_fd_pr__pfet_01v8_hvt m=1 w=0.42u l=0.15u mult=1
+ sa=0.265 sb=0.265 sd=0.28 area=0.063 perim=1.14
MI30 net166 M1 net59 VNB sky130_fd_pr__pfet_01v8_hvt m=1 w=0.42u l=0.15u mult=1
+ sa=0.265 sb=0.265 sd=0.28 area=0.063 perim=1.14
MI31 M0 clkneg net166 VNB sky130_fd_pr__pfet_01v8_hvt m=1 w=0.42u l=0.15u mult=1
+ sa=0.265 sb=0.265 sd=0.28 area=0.063 perim=1.14
MI32 net166 RESET_B net59 VNB sky130_fd_pr__pfet_01v8_hvt m=1 w=0.42u l=0.15u mult=1
+ sa=0.265 sb=0.265 sd=0.28 area=0.063 perim=1.14
MI663 Q net84 net59 VNB sky130_fd_pr__pfet_01v8_hvt m=4 w=1.0u l=0.15u mult=1 sa=0.265
+ sb=0.265 sd=0.28 area=0.063 perim=1.14
MI648 M1 M0 net59 VNB sky130_fd_pr__pfet_01v8_hvt m=1 w=0.84u l=0.15u mult=1 sa=0.265
+ sb=0.265 sd=0.28 area=0.063 perim=1.14
MI650 M1 clkneg S0 VNB sky130_fd_pr__pfet_01v8_hvt m=1 w=0.42u l=0.15u mult=1 sa=0.265
+ sb=0.265 sd=0.28 area=0.063 perim=1.14
MI633 sceb SCE net59 VNB sky130_fd_pr__pfet_01v8_hvt m=1 w=0.54u l=0.15u mult=1
+ sa=0.265 sb=0.265 sd=0.28 area=0.063 perim=1.14
MI101 db sceb p1 VNB sky130_fd_pr__pfet_01v8_hvt m=1 w=0.54u l=0.15u mult=1 sa=0.265
+ sb=0.265 sd=0.28 area=0.063 perim=1.14
MI107 p0 SCE net59 VNB sky130_fd_pr__pfet_01v8_hvt m=1 w=0.54u l=0.15u mult=1 sa=0.265
+ sb=0.265 sd=0.28 area=0.063 perim=1.14
MI94 db D p0 VNB sky130_fd_pr__pfet_01v8_hvt m=1 w=0.54u l=0.15u mult=1 sa=0.265
+ sb=0.265 sd=0.28 area=0.063 perim=1.14
MI108 p1 SCD net59 VNB sky130_fd_pr__pfet_01v8_hvt m=1 w=0.54u l=0.15u mult=1 sa=0.265
+ sb=0.265 sd=0.28 area=0.063 perim=1.14
.ENDS sky130_fd_sc_hd__sdfrtp_4
* Copyright 2020 The SkyWater PDK Authors
*
* Licensed under the Apache License, Version 2.0 (the "License");
* you may not use this file except in compliance with the License.
* You may obtain a copy of the License at
*
*     https:  www.apache.org licenses LICENSE-2.0
*
* Unless required by applicable law or agreed to in writing, software
* distributed under the License is distributed on an "AS IS" BASIS,
* WITHOUT WARRANTIES OR CONDITIONS OF ANY KIND, either express or implied.
* See the License for the specific language governing permissions and
* limitations under the License.
*
* SPDX-License-Identifier: Apache-2.0

.SUBCKT sky130_fd_sc_hd__sdfsbp_1 CLK D SCD SCE SET_B VGND VNB VNB net59 Q Q_N
*.PININFO CLK:I D:I SCD:I SCE:I SET_B:I VGND:I VNB:I VNB:I net59:I Q:O
*.PININFO Q_N:O
MI107 p0 SCE net59 VNB sky130_fd_pr__pfet_01v8_hvt m=1 w=0.64u l=0.15u mult=1 sa=0.265
+ sb=0.265 sd=0.28 area=0.063 perim=1.14
MI94 db D p0 VNB sky130_fd_pr__pfet_01v8_hvt m=1 w=0.64u l=0.15u mult=1 sa=0.265
+ sb=0.265 sd=0.28 area=0.063 perim=1.14
MI101 db sceb p1 VNB sky130_fd_pr__pfet_01v8_hvt m=1 w=0.64u l=0.15u mult=1 sa=0.265
+ sb=0.265 sd=0.28 area=0.063 perim=1.14
MI108 p1 SCD net59 VNB sky130_fd_pr__pfet_01v8_hvt m=1 w=0.64u l=0.15u mult=1 sa=0.265
+ sb=0.265 sd=0.28 area=0.063 perim=1.14
MI662 net159 M1 net59 VNB sky130_fd_pr__pfet_01v8_hvt m=1 w=0.42u l=0.15u mult=1
+ sa=0.265 sb=0.265 sd=0.28 area=0.063 perim=1.14
MI664 M0 clkneg net159 VNB sky130_fd_pr__pfet_01v8_hvt m=1 w=0.42u l=0.15u mult=1
+ sa=0.265 sb=0.265 sd=0.28 area=0.063 perim=1.14
MI6 net138 S1 net59 VNB sky130_fd_pr__pfet_01v8_hvt m=1 w=0.42u l=0.15u mult=1 sa=0.265
+ sb=0.265 sd=0.28 area=0.063 perim=1.14
MI43 db clkpos M0 VNB sky130_fd_pr__pfet_01v8_hvt m=1 w=0.42u l=0.15u mult=1 sa=0.265
+ sb=0.265 sd=0.28 area=0.063 perim=1.14
MI45 clkneg CLK net59 VNB sky130_fd_pr__pfet_01v8_hvt m=1 w=0.64u l=0.15u mult=1
+ sa=0.265 sb=0.265 sd=0.28 area=0.063 perim=1.14
MI669 S0 clkpos net138 VNB sky130_fd_pr__pfet_01v8_hvt m=1 w=0.42u l=0.15u mult=1
+ sa=0.265 sb=0.265 sd=0.28 area=0.063 perim=1.14
MI658 M1 M0 net59 VNB sky130_fd_pr__pfet_01v8_hvt m=1 w=0.42u l=0.15u mult=1 sa=0.265
+ sb=0.265 sd=0.28 area=0.063 perim=1.14
MI661 Q_N S0 net59 VNB sky130_fd_pr__pfet_01v8_hvt m=1 w=1.0u l=0.15u mult=1 sa=0.265
+ sb=0.265 sd=0.28 area=0.063 perim=1.14
MI659 M1 SET_B net59 VNB sky130_fd_pr__pfet_01v8_hvt m=1 w=0.42u l=0.15u mult=1
+ sa=0.265 sb=0.265 sd=0.28 area=0.063 perim=1.14
MI645 sceb SCE net59 VNB sky130_fd_pr__pfet_01v8_hvt m=1 w=0.64u l=0.15u mult=1
+ sa=0.265 sb=0.265 sd=0.28 area=0.063 perim=1.14
MI663 net199 S0 net59 VNB sky130_fd_pr__pfet_01v8_hvt m=1 w=0.64u l=0.15u mult=1
+ sa=0.265 sb=0.265 sd=0.28 area=0.063 perim=1.14
MI47 clkpos clkneg net59 VNB sky130_fd_pr__pfet_01v8_hvt m=1 w=0.64u l=0.15u mult=1
+ sa=0.265 sb=0.265 sd=0.28 area=0.063 perim=1.14
MI660 Q net199 net59 VNB sky130_fd_pr__pfet_01v8_hvt m=1 w=1.0u l=0.15u mult=1 sa=0.265
+ sb=0.265 sd=0.28 area=0.063 perim=1.14
MI24 S0 SET_B net59 VNB sky130_fd_pr__pfet_01v8_hvt m=1 w=0.42u l=0.15u mult=1 sa=0.265
+ sb=0.265 sd=0.28 area=0.063 perim=1.14
MI648 S1 S0 net59 VNB sky130_fd_pr__pfet_01v8_hvt m=1 w=0.42u l=0.15u mult=1 sa=0.265
+ sb=0.265 sd=0.28 area=0.063 perim=1.14
MI38 S0 clkneg net98 VNB sky130_fd_pr__pfet_01v8_hvt m=1 w=0.84u l=0.15u mult=1
+ sa=0.265 sb=0.265 sd=0.28 area=0.063 perim=1.14
MI37 net98 M0 net59 VNB sky130_fd_pr__pfet_01v8_hvt m=1 w=0.84u l=0.15u mult=1 sa=0.265
+ sb=0.265 sd=0.28 area=0.063 perim=1.14
MI120 db SCE n1 VNB sky130_fd_pr__nfet_01v8 m=1 w=0.42u l=0.15u mult=1 sa=0.265
+ sb=0.265 sd=0.28 area=0.525 perim=3.1
MI104 n0 sceb VGND VNB sky130_fd_pr__nfet_01v8 m=1 w=0.42u l=0.15u mult=1 sa=0.265
+ sb=0.265 sd=0.28 area=0.525 perim=3.1
MI103 n1 SCD VGND VNB sky130_fd_pr__nfet_01v8 m=1 w=0.42u l=0.15u mult=1 sa=0.265
+ sb=0.265 sd=0.28 area=0.525 perim=3.1
MI98 db D n0 VNB sky130_fd_pr__nfet_01v8 m=1 w=0.42u l=0.15u mult=1 sa=0.265 sb=0.265
+ sd=0.28 area=0.525 perim=3.1
MI27 net243 S1 net215 VNB sky130_fd_pr__nfet_01v8 m=1 w=0.42u l=0.15u mult=1 sa=0.265
+ sb=0.265 sd=0.28 area=0.063 perim=1.14
MI647 S1 S0 VGND VNB sky130_fd_pr__nfet_01v8 m=1 w=0.42u l=0.15u mult=1 sa=0.265
+ sb=0.265 sd=0.28 area=0.063 perim=1.14
MI46 clkpos clkneg VGND VNB sky130_fd_pr__nfet_01v8 m=1 w=0.42u l=0.15u mult=1
+ sa=0.265 sb=0.265 sd=0.28 area=0.063 perim=1.14
MI34 S0 clkpos net230 VNB sky130_fd_pr__nfet_01v8 m=1 w=0.64u l=0.15u mult=1 sa=0.265
+ sb=0.265 sd=0.28 area=0.063 perim=1.14
MI657 net227 SET_B VGND VNB sky130_fd_pr__nfet_01v8 m=1 w=0.42u l=0.15u mult=1
+ sa=0.265 sb=0.265 sd=0.28 area=0.063 perim=1.14
MI653 Q net199 VGND VNB sky130_fd_pr__nfet_01v8 m=1 w=0.65u l=0.15u mult=1 sa=0.265
+ sb=0.265 sd=0.28 area=0.063 perim=1.14
MI644 sceb SCE VGND VNB sky130_fd_pr__nfet_01v8 m=1 w=0.42u l=0.15u mult=1 sa=0.265
+ sb=0.265 sd=0.28 area=0.063 perim=1.14
MI25 net215 SET_B VGND VNB sky130_fd_pr__nfet_01v8 m=1 w=0.42u l=0.15u mult=1 sa=0.265
+ sb=0.265 sd=0.28 area=0.063 perim=1.14
MI651 Q_N S0 VGND VNB sky130_fd_pr__nfet_01v8 m=1 w=0.65u l=0.15u mult=1 sa=0.265
+ sb=0.265 sd=0.28 area=0.063 perim=1.14
MI655 M0 clkpos net206 VNB sky130_fd_pr__nfet_01v8 m=1 w=0.42u l=0.15u mult=1 sa=0.265
+ sb=0.265 sd=0.28 area=0.063 perim=1.14
MI44 clkneg CLK VGND VNB sky130_fd_pr__nfet_01v8 m=1 w=0.42u l=0.15u mult=1 sa=0.265
+ sb=0.265 sd=0.28 area=0.063 perim=1.14
MI652 net199 S0 VGND VNB sky130_fd_pr__nfet_01v8 m=1 w=0.42u l=0.15u mult=1 sa=0.265
+ sb=0.265 sd=0.28 area=0.063 perim=1.14
MI656 M1 M0 net227 VNB sky130_fd_pr__nfet_01v8 m=1 w=0.42u l=0.15u mult=1 sa=0.265
+ sb=0.265 sd=0.28 area=0.063 perim=1.14
MI654 net206 M1 VGND VNB sky130_fd_pr__nfet_01v8 m=1 w=0.42u l=0.15u mult=1 sa=0.265
+ sb=0.265 sd=0.28 area=0.063 perim=1.14
MI36 net230 M0 VGND VNB sky130_fd_pr__nfet_01v8 m=1 w=0.64u l=0.15u mult=1 sa=0.265
+ sb=0.265 sd=0.28 area=0.063 perim=1.14
MI26 S0 clkneg net243 VNB sky130_fd_pr__nfet_01v8 m=1 w=0.42u l=0.15u mult=1 sa=0.265
+ sb=0.265 sd=0.28 area=0.063 perim=1.14
MI42 db clkneg M0 VNB sky130_fd_pr__nfet_01v8 m=1 w=0.42u l=0.15u mult=1 sa=0.265
+ sb=0.265 sd=0.28 area=0.063 perim=1.14
.ENDS sky130_fd_sc_hd__sdfsbp_1
* Copyright 2020 The SkyWater PDK Authors
*
* Licensed under the Apache License, Version 2.0 (the "License");
* you may not use this file except in compliance with the License.
* You may obtain a copy of the License at
*
*     https:  www.apache.org licenses LICENSE-2.0
*
* Unless required by applicable law or agreed to in writing, software
* distributed under the License is distributed on an "AS IS" BASIS,
* WITHOUT WARRANTIES OR CONDITIONS OF ANY KIND, either express or implied.
* See the License for the specific language governing permissions and
* limitations under the License.
*
* SPDX-License-Identifier: Apache-2.0

.SUBCKT sky130_fd_sc_hd__sdfsbp_2 CLK D SCD SCE SET_B VGND VNB VNB net59 Q Q_N
*.PININFO CLK:I D:I SCD:I SCE:I SET_B:I VGND:I VNB:I VNB:I net59:I Q:O
*.PININFO Q_N:O
MI101 db sceb p1 VNB sky130_fd_pr__pfet_01v8_hvt m=1 w=0.64u l=0.15u mult=1 sa=0.265
+ sb=0.265 sd=0.28 area=0.063 perim=1.14
MI107 p0 SCE net59 VNB sky130_fd_pr__pfet_01v8_hvt m=1 w=0.64u l=0.15u mult=1 sa=0.265
+ sb=0.265 sd=0.28 area=0.063 perim=1.14
MI94 db D p0 VNB sky130_fd_pr__pfet_01v8_hvt m=1 w=0.64u l=0.15u mult=1 sa=0.265
+ sb=0.265 sd=0.28 area=0.063 perim=1.14
MI108 p1 SCD net59 VNB sky130_fd_pr__pfet_01v8_hvt m=1 w=0.64u l=0.15u mult=1 sa=0.265
+ sb=0.265 sd=0.28 area=0.063 perim=1.14
MI645 sceb SCE net59 VNB sky130_fd_pr__pfet_01v8_hvt m=1 w=0.64u l=0.15u mult=1
+ sa=0.265 sb=0.265 sd=0.28 area=0.063 perim=1.14
MI658 M1 M0 net59 VNB sky130_fd_pr__pfet_01v8_hvt m=1 w=0.42u l=0.15u mult=1 sa=0.265
+ sb=0.265 sd=0.28 area=0.063 perim=1.14
MI47 clkpos clkneg net59 VNB sky130_fd_pr__pfet_01v8_hvt m=1 w=0.64u l=0.15u mult=1
+ sa=0.265 sb=0.265 sd=0.28 area=0.063 perim=1.14
MI663 net195 S0 net59 VNB sky130_fd_pr__pfet_01v8_hvt m=1 w=0.64u l=0.15u mult=1
+ sa=0.265 sb=0.265 sd=0.28 area=0.063 perim=1.14
MI660 Q net195 net59 VNB sky130_fd_pr__pfet_01v8_hvt m=2 w=1.0u l=0.15u mult=1 sa=0.265
+ sb=0.265 sd=0.28 area=0.063 perim=1.14
MI659 M1 SET_B net59 VNB sky130_fd_pr__pfet_01v8_hvt m=1 w=0.42u l=0.15u mult=1
+ sa=0.265 sb=0.265 sd=0.28 area=0.063 perim=1.14
MI662 net130 M1 net59 VNB sky130_fd_pr__pfet_01v8_hvt m=1 w=0.42u l=0.15u mult=1
+ sa=0.265 sb=0.265 sd=0.28 area=0.063 perim=1.14
MI664 M0 clkneg net130 VNB sky130_fd_pr__pfet_01v8_hvt m=1 w=0.42u l=0.15u mult=1
+ sa=0.265 sb=0.265 sd=0.28 area=0.063 perim=1.14
MI6 net122 S1 net59 VNB sky130_fd_pr__pfet_01v8_hvt m=1 w=0.42u l=0.15u mult=1 sa=0.265
+ sb=0.265 sd=0.28 area=0.063 perim=1.14
MI669 S0 clkpos net122 VNB sky130_fd_pr__pfet_01v8_hvt m=1 w=0.42u l=0.15u mult=1
+ sa=0.265 sb=0.265 sd=0.28 area=0.063 perim=1.14
MI24 S0 SET_B net59 VNB sky130_fd_pr__pfet_01v8_hvt m=1 w=0.42u l=0.15u mult=1 sa=0.265
+ sb=0.265 sd=0.28 area=0.063 perim=1.14
MI648 S1 S0 net59 VNB sky130_fd_pr__pfet_01v8_hvt m=1 w=0.42u l=0.15u mult=1 sa=0.265
+ sb=0.265 sd=0.28 area=0.063 perim=1.14
MI38 S0 clkneg net107 VNB sky130_fd_pr__pfet_01v8_hvt m=1 w=0.84u l=0.15u mult=1
+ sa=0.265 sb=0.265 sd=0.28 area=0.063 perim=1.14
MI37 net107 M0 net59 VNB sky130_fd_pr__pfet_01v8_hvt m=1 w=0.84u l=0.15u mult=1
+ sa=0.265 sb=0.265 sd=0.28 area=0.063 perim=1.14
MI43 db clkpos M0 VNB sky130_fd_pr__pfet_01v8_hvt m=1 w=0.42u l=0.15u mult=1 sa=0.265
+ sb=0.265 sd=0.28 area=0.063 perim=1.14
MI45 clkneg CLK net59 VNB sky130_fd_pr__pfet_01v8_hvt m=1 w=0.64u l=0.15u mult=1
+ sa=0.265 sb=0.265 sd=0.28 area=0.063 perim=1.14
MI661 Q_N S0 net59 VNB sky130_fd_pr__pfet_01v8_hvt m=2 w=1.0u l=0.15u mult=1 sa=0.265
+ sb=0.265 sd=0.28 area=0.063 perim=1.14
MI98 db D n0 VNB sky130_fd_pr__nfet_01v8 m=1 w=0.42u l=0.15u mult=1 sa=0.265 sb=0.265
+ sd=0.28 area=0.525 perim=3.1
MI103 n1 SCD VGND VNB sky130_fd_pr__nfet_01v8 m=1 w=0.42u l=0.15u mult=1 sa=0.265
+ sb=0.265 sd=0.28 area=0.525 perim=3.1
MI120 db SCE n1 VNB sky130_fd_pr__nfet_01v8 m=1 w=0.42u l=0.15u mult=1 sa=0.265
+ sb=0.265 sd=0.28 area=0.525 perim=3.1
MI104 n0 sceb VGND VNB sky130_fd_pr__nfet_01v8 m=1 w=0.42u l=0.15u mult=1 sa=0.265
+ sb=0.265 sd=0.28 area=0.525 perim=3.1
MI34 S0 clkpos net219 VNB sky130_fd_pr__nfet_01v8 m=1 w=0.64u l=0.15u mult=1 sa=0.265
+ sb=0.265 sd=0.28 area=0.063 perim=1.14
MI27 net239 S1 net187 VNB sky130_fd_pr__nfet_01v8 m=1 w=0.42u l=0.15u mult=1 sa=0.265
+ sb=0.265 sd=0.28 area=0.063 perim=1.14
MI647 S1 S0 VGND VNB sky130_fd_pr__nfet_01v8 m=1 w=0.42u l=0.15u mult=1 sa=0.265
+ sb=0.265 sd=0.28 area=0.063 perim=1.14
MI655 M0 clkpos net230 VNB sky130_fd_pr__nfet_01v8 m=1 w=0.42u l=0.15u mult=1 sa=0.265
+ sb=0.265 sd=0.28 area=0.063 perim=1.14
MI656 M1 M0 net199 VNB sky130_fd_pr__nfet_01v8 m=1 w=0.42u l=0.15u mult=1 sa=0.265
+ sb=0.265 sd=0.28 area=0.063 perim=1.14
MI654 net230 M1 VGND VNB sky130_fd_pr__nfet_01v8 m=1 w=0.42u l=0.15u mult=1 sa=0.265
+ sb=0.265 sd=0.28 area=0.063 perim=1.14
MI36 net219 M0 VGND VNB sky130_fd_pr__nfet_01v8 m=1 w=0.64u l=0.15u mult=1 sa=0.265
+ sb=0.265 sd=0.28 area=0.063 perim=1.14
MI26 S0 clkneg net239 VNB sky130_fd_pr__nfet_01v8 m=1 w=0.42u l=0.15u mult=1 sa=0.265
+ sb=0.265 sd=0.28 area=0.063 perim=1.14
MI42 db clkneg M0 VNB sky130_fd_pr__nfet_01v8 m=1 w=0.42u l=0.15u mult=1 sa=0.265
+ sb=0.265 sd=0.28 area=0.063 perim=1.14
MI46 clkpos clkneg VGND VNB sky130_fd_pr__nfet_01v8 m=1 w=0.42u l=0.15u mult=1
+ sa=0.265 sb=0.265 sd=0.28 area=0.063 perim=1.14
MI44 clkneg CLK VGND VNB sky130_fd_pr__nfet_01v8 m=1 w=0.42u l=0.15u mult=1 sa=0.265
+ sb=0.265 sd=0.28 area=0.063 perim=1.14
MI657 net199 SET_B VGND VNB sky130_fd_pr__nfet_01v8 m=1 w=0.42u l=0.15u mult=1
+ sa=0.265 sb=0.265 sd=0.28 area=0.063 perim=1.14
MI652 net195 S0 VGND VNB sky130_fd_pr__nfet_01v8 m=1 w=0.42u l=0.15u mult=1 sa=0.265
+ sb=0.265 sd=0.28 area=0.063 perim=1.14
MI644 sceb SCE VGND VNB sky130_fd_pr__nfet_01v8 m=1 w=0.42u l=0.15u mult=1 sa=0.265
+ sb=0.265 sd=0.28 area=0.063 perim=1.14
MI25 net187 SET_B VGND VNB sky130_fd_pr__nfet_01v8 m=1 w=0.42u l=0.15u mult=1 sa=0.265
+ sb=0.265 sd=0.28 area=0.063 perim=1.14
MI653 Q net195 VGND VNB sky130_fd_pr__nfet_01v8 m=2 w=0.65u l=0.15u mult=1 sa=0.265
+ sb=0.265 sd=0.28 area=0.063 perim=1.14
MI651 Q_N S0 VGND VNB sky130_fd_pr__nfet_01v8 m=2 w=0.65u l=0.15u mult=1 sa=0.265
+ sb=0.265 sd=0.28 area=0.063 perim=1.14
.ENDS sky130_fd_sc_hd__sdfsbp_2
* Copyright 2020 The SkyWater PDK Authors
*
* Licensed under the Apache License, Version 2.0 (the "License");
* you may not use this file except in compliance with the License.
* You may obtain a copy of the License at
*
*     https:  www.apache.org licenses LICENSE-2.0
*
* Unless required by applicable law or agreed to in writing, software
* distributed under the License is distributed on an "AS IS" BASIS,
* WITHOUT WARRANTIES OR CONDITIONS OF ANY KIND, either express or implied.
* See the License for the specific language governing permissions and
* limitations under the License.
*
* SPDX-License-Identifier: Apache-2.0

.SUBCKT sky130_fd_sc_hd__sdfstp_1 CLK D SCD SCE SET_B VGND VNB VNB net59 Q
*.PININFO CLK:I D:I SCD:I SCE:I SET_B:I VGND:I VNB:I VNB:I net59:I Q:O
MI645 sceb SCE net59 VNB sky130_fd_pr__pfet_01v8_hvt m=1 w=0.64u l=0.15u mult=1
+ sa=0.265 sb=0.265 sd=0.28 area=0.063 perim=1.14
MI658 M1 M0 net59 VNB sky130_fd_pr__pfet_01v8_hvt m=1 w=0.42u l=0.15u mult=1 sa=0.265
+ sb=0.265 sd=0.28 area=0.063 perim=1.14
MI47 clkpos clkneg net59 VNB sky130_fd_pr__pfet_01v8_hvt m=1 w=0.64u l=0.15u mult=1
+ sa=0.265 sb=0.265 sd=0.28 area=0.063 perim=1.14
MI663 net165 S0 net59 VNB sky130_fd_pr__pfet_01v8_hvt m=1 w=0.64u l=0.15u mult=1
+ sa=0.265 sb=0.265 sd=0.28 area=0.063 perim=1.14
MI660 Q net165 net59 VNB sky130_fd_pr__pfet_01v8_hvt m=1 w=1.0u l=0.15u mult=1 sa=0.265
+ sb=0.265 sd=0.28 area=0.063 perim=1.14
MI659 M1 SET_B net59 VNB sky130_fd_pr__pfet_01v8_hvt m=1 w=0.42u l=0.15u mult=1
+ sa=0.265 sb=0.265 sd=0.28 area=0.063 perim=1.14
MI662 net109 M1 net59 VNB sky130_fd_pr__pfet_01v8_hvt m=1 w=0.42u l=0.15u mult=1
+ sa=0.265 sb=0.265 sd=0.28 area=0.063 perim=1.14
MI664 M0 clkneg net109 VNB sky130_fd_pr__pfet_01v8_hvt m=1 w=0.42u l=0.15u mult=1
+ sa=0.265 sb=0.265 sd=0.28 area=0.063 perim=1.14
MI6 net96 S1 net59 VNB sky130_fd_pr__pfet_01v8_hvt m=1 w=0.42u l=0.15u mult=1 sa=0.265
+ sb=0.265 sd=0.28 area=0.063 perim=1.14
MI669 S0 clkpos net96 VNB sky130_fd_pr__pfet_01v8_hvt m=1 w=0.42u l=0.15u mult=1
+ sa=0.265 sb=0.265 sd=0.28 area=0.063 perim=1.14
MI24 S0 SET_B net59 VNB sky130_fd_pr__pfet_01v8_hvt m=1 w=0.42u l=0.15u mult=1 sa=0.265
+ sb=0.265 sd=0.28 area=0.063 perim=1.14
MI648 S1 S0 net59 VNB sky130_fd_pr__pfet_01v8_hvt m=1 w=0.42u l=0.15u mult=1 sa=0.265
+ sb=0.265 sd=0.28 area=0.063 perim=1.14
MI38 S0 clkneg net84 VNB sky130_fd_pr__pfet_01v8_hvt m=1 w=0.84u l=0.15u mult=1
+ sa=0.265 sb=0.265 sd=0.28 area=0.063 perim=1.14
MI37 net84 M0 net59 VNB sky130_fd_pr__pfet_01v8_hvt m=1 w=0.84u l=0.15u mult=1 sa=0.265
+ sb=0.265 sd=0.28 area=0.063 perim=1.14
MI43 db clkpos M0 VNB sky130_fd_pr__pfet_01v8_hvt m=1 w=0.42u l=0.15u mult=1 sa=0.265
+ sb=0.265 sd=0.28 area=0.063 perim=1.14
MI45 clkneg CLK net59 VNB sky130_fd_pr__pfet_01v8_hvt m=1 w=0.64u l=0.15u mult=1
+ sa=0.265 sb=0.265 sd=0.28 area=0.063 perim=1.14
MI101 db sceb p1 VNB sky130_fd_pr__pfet_01v8_hvt m=1 w=0.64u l=0.15u mult=1 sa=0.265
+ sb=0.265 sd=0.28 area=0.063 perim=1.14
MI107 p0 SCE net59 VNB sky130_fd_pr__pfet_01v8_hvt m=1 w=0.64u l=0.15u mult=1 sa=0.265
+ sb=0.265 sd=0.28 area=0.063 perim=1.14
MI94 db D p0 VNB sky130_fd_pr__pfet_01v8_hvt m=1 w=0.64u l=0.15u mult=1 sa=0.265
+ sb=0.265 sd=0.28 area=0.063 perim=1.14
MI108 p1 SCD net59 VNB sky130_fd_pr__pfet_01v8_hvt m=1 w=0.64u l=0.15u mult=1 sa=0.265
+ sb=0.265 sd=0.28 area=0.063 perim=1.14
MI34 S0 clkpos net189 VNB sky130_fd_pr__nfet_01v8 m=1 w=0.64u l=0.15u mult=1 sa=0.265
+ sb=0.265 sd=0.28 area=0.063 perim=1.14
MI27 net209 S1 net157 VNB sky130_fd_pr__nfet_01v8 m=1 w=0.42u l=0.15u mult=1 sa=0.265
+ sb=0.265 sd=0.28 area=0.063 perim=1.14
MI647 S1 S0 VGND VNB sky130_fd_pr__nfet_01v8 m=1 w=0.42u l=0.15u mult=1 sa=0.265
+ sb=0.265 sd=0.28 area=0.063 perim=1.14
MI655 M0 clkpos net200 VNB sky130_fd_pr__nfet_01v8 m=1 w=0.42u l=0.15u mult=1 sa=0.265
+ sb=0.265 sd=0.28 area=0.063 perim=1.14
MI656 M1 M0 net169 VNB sky130_fd_pr__nfet_01v8 m=1 w=0.42u l=0.15u mult=1 sa=0.265
+ sb=0.265 sd=0.28 area=0.063 perim=1.14
MI654 net200 M1 VGND VNB sky130_fd_pr__nfet_01v8 m=1 w=0.42u l=0.15u mult=1 sa=0.265
+ sb=0.265 sd=0.28 area=0.063 perim=1.14
MI36 net189 M0 VGND VNB sky130_fd_pr__nfet_01v8 m=1 w=0.64u l=0.15u mult=1 sa=0.265
+ sb=0.265 sd=0.28 area=0.063 perim=1.14
MI26 S0 clkneg net209 VNB sky130_fd_pr__nfet_01v8 m=1 w=0.42u l=0.15u mult=1 sa=0.265
+ sb=0.265 sd=0.28 area=0.063 perim=1.14
MI42 db clkneg M0 VNB sky130_fd_pr__nfet_01v8 m=1 w=0.42u l=0.15u mult=1 sa=0.265
+ sb=0.265 sd=0.28 area=0.063 perim=1.14
MI46 clkpos clkneg VGND VNB sky130_fd_pr__nfet_01v8 m=1 w=0.42u l=0.15u mult=1
+ sa=0.265 sb=0.265 sd=0.28 area=0.063 perim=1.14
MI44 clkneg CLK VGND VNB sky130_fd_pr__nfet_01v8 m=1 w=0.42u l=0.15u mult=1 sa=0.265
+ sb=0.265 sd=0.28 area=0.063 perim=1.14
MI657 net169 SET_B VGND VNB sky130_fd_pr__nfet_01v8 m=1 w=0.42u l=0.15u mult=1
+ sa=0.265 sb=0.265 sd=0.28 area=0.063 perim=1.14
MI652 net165 S0 VGND VNB sky130_fd_pr__nfet_01v8 m=1 w=0.42u l=0.15u mult=1 sa=0.265
+ sb=0.265 sd=0.28 area=0.063 perim=1.14
MI644 sceb SCE VGND VNB sky130_fd_pr__nfet_01v8 m=1 w=0.42u l=0.15u mult=1 sa=0.265
+ sb=0.265 sd=0.28 area=0.063 perim=1.14
MI25 net157 SET_B VGND VNB sky130_fd_pr__nfet_01v8 m=1 w=0.42u l=0.15u mult=1 sa=0.265
+ sb=0.265 sd=0.28 area=0.063 perim=1.14
MI653 Q net165 VGND VNB sky130_fd_pr__nfet_01v8 m=1 w=0.65u l=0.15u mult=1 sa=0.265
+ sb=0.265 sd=0.28 area=0.063 perim=1.14
MI98 db D n0 VNB sky130_fd_pr__nfet_01v8 m=1 w=0.42u l=0.15u mult=1 sa=0.265 sb=0.265
+ sd=0.28 area=0.525 perim=3.1
MI103 n1 SCD VGND VNB sky130_fd_pr__nfet_01v8 m=1 w=0.42u l=0.15u mult=1 sa=0.265
+ sb=0.265 sd=0.28 area=0.525 perim=3.1
MI120 db SCE n1 VNB sky130_fd_pr__nfet_01v8 m=1 w=0.42u l=0.15u mult=1 sa=0.265
+ sb=0.265 sd=0.28 area=0.525 perim=3.1
MI104 n0 sceb VGND VNB sky130_fd_pr__nfet_01v8 m=1 w=0.42u l=0.15u mult=1 sa=0.265
+ sb=0.265 sd=0.28 area=0.525 perim=3.1
.ENDS sky130_fd_sc_hd__sdfstp_1
* Copyright 2020 The SkyWater PDK Authors
*
* Licensed under the Apache License, Version 2.0 (the "License");
* you may not use this file except in compliance with the License.
* You may obtain a copy of the License at
*
*     https:  www.apache.org licenses LICENSE-2.0
*
* Unless required by applicable law or agreed to in writing, software
* distributed under the License is distributed on an "AS IS" BASIS,
* WITHOUT WARRANTIES OR CONDITIONS OF ANY KIND, either express or implied.
* See the License for the specific language governing permissions and
* limitations under the License.
*
* SPDX-License-Identifier: Apache-2.0

.SUBCKT sky130_fd_sc_hd__sdfstp_2 CLK D SCD SCE SET_B VGND VNB VNB net59 Q
*.PININFO CLK:I D:I SCD:I SCE:I SET_B:I VGND:I VNB:I VNB:I net59:I Q:O
MI645 sceb SCE net59 VNB sky130_fd_pr__pfet_01v8_hvt m=1 w=0.64u l=0.15u mult=1
+ sa=0.265 sb=0.265 sd=0.28 area=0.063 perim=1.14
MI658 M1 M0 net59 VNB sky130_fd_pr__pfet_01v8_hvt m=1 w=0.42u l=0.15u mult=1 sa=0.265
+ sb=0.265 sd=0.28 area=0.063 perim=1.14
MI47 clkpos clkneg net59 VNB sky130_fd_pr__pfet_01v8_hvt m=1 w=0.64u l=0.15u mult=1
+ sa=0.265 sb=0.265 sd=0.28 area=0.063 perim=1.14
MI663 net165 S0 net59 VNB sky130_fd_pr__pfet_01v8_hvt m=1 w=0.64u l=0.15u mult=1
+ sa=0.265 sb=0.265 sd=0.28 area=0.063 perim=1.14
MI660 Q net165 net59 VNB sky130_fd_pr__pfet_01v8_hvt m=2 w=1.0u l=0.15u mult=1 sa=0.265
+ sb=0.265 sd=0.28 area=0.063 perim=1.14
MI659 M1 SET_B net59 VNB sky130_fd_pr__pfet_01v8_hvt m=1 w=0.42u l=0.15u mult=1
+ sa=0.265 sb=0.265 sd=0.28 area=0.063 perim=1.14
MI662 net109 M1 net59 VNB sky130_fd_pr__pfet_01v8_hvt m=1 w=0.42u l=0.15u mult=1
+ sa=0.265 sb=0.265 sd=0.28 area=0.063 perim=1.14
MI664 M0 clkneg net109 VNB sky130_fd_pr__pfet_01v8_hvt m=1 w=0.42u l=0.15u mult=1
+ sa=0.265 sb=0.265 sd=0.28 area=0.063 perim=1.14
MI6 net96 S1 net59 VNB sky130_fd_pr__pfet_01v8_hvt m=1 w=0.42u l=0.15u mult=1 sa=0.265
+ sb=0.265 sd=0.28 area=0.063 perim=1.14
MI669 S0 clkpos net96 VNB sky130_fd_pr__pfet_01v8_hvt m=1 w=0.42u l=0.15u mult=1
+ sa=0.265 sb=0.265 sd=0.28 area=0.063 perim=1.14
MI24 S0 SET_B net59 VNB sky130_fd_pr__pfet_01v8_hvt m=1 w=0.42u l=0.15u mult=1 sa=0.265
+ sb=0.265 sd=0.28 area=0.063 perim=1.14
MI648 S1 S0 net59 VNB sky130_fd_pr__pfet_01v8_hvt m=1 w=0.42u l=0.15u mult=1 sa=0.265
+ sb=0.265 sd=0.28 area=0.063 perim=1.14
MI38 S0 clkneg net84 VNB sky130_fd_pr__pfet_01v8_hvt m=1 w=0.84u l=0.15u mult=1
+ sa=0.265 sb=0.265 sd=0.28 area=0.063 perim=1.14
MI37 net84 M0 net59 VNB sky130_fd_pr__pfet_01v8_hvt m=1 w=0.84u l=0.15u mult=1 sa=0.265
+ sb=0.265 sd=0.28 area=0.063 perim=1.14
MI43 db clkpos M0 VNB sky130_fd_pr__pfet_01v8_hvt m=1 w=0.42u l=0.15u mult=1 sa=0.265
+ sb=0.265 sd=0.28 area=0.063 perim=1.14
MI45 clkneg CLK net59 VNB sky130_fd_pr__pfet_01v8_hvt m=1 w=0.64u l=0.15u mult=1
+ sa=0.265 sb=0.265 sd=0.28 area=0.063 perim=1.14
MI101 db sceb p1 VNB sky130_fd_pr__pfet_01v8_hvt m=1 w=0.64u l=0.15u mult=1 sa=0.265
+ sb=0.265 sd=0.28 area=0.063 perim=1.14
MI107 p0 SCE net59 VNB sky130_fd_pr__pfet_01v8_hvt m=1 w=0.64u l=0.15u mult=1 sa=0.265
+ sb=0.265 sd=0.28 area=0.063 perim=1.14
MI94 db D p0 VNB sky130_fd_pr__pfet_01v8_hvt m=1 w=0.64u l=0.15u mult=1 sa=0.265
+ sb=0.265 sd=0.28 area=0.063 perim=1.14
MI108 p1 SCD net59 VNB sky130_fd_pr__pfet_01v8_hvt m=1 w=0.64u l=0.15u mult=1 sa=0.265
+ sb=0.265 sd=0.28 area=0.063 perim=1.14
MI34 S0 clkpos net212 VNB sky130_fd_pr__nfet_01v8 m=1 w=0.64u l=0.15u mult=1 sa=0.265
+ sb=0.265 sd=0.28 area=0.063 perim=1.14
MI27 net209 S1 net157 VNB sky130_fd_pr__nfet_01v8 m=1 w=0.42u l=0.15u mult=1 sa=0.265
+ sb=0.265 sd=0.28 area=0.063 perim=1.14
MI647 S1 S0 VGND VNB sky130_fd_pr__nfet_01v8 m=1 w=0.42u l=0.15u mult=1 sa=0.265
+ sb=0.265 sd=0.28 area=0.063 perim=1.14
MI655 M0 clkpos net200 VNB sky130_fd_pr__nfet_01v8 m=1 w=0.42u l=0.15u mult=1 sa=0.265
+ sb=0.265 sd=0.28 area=0.063 perim=1.14
MI656 M1 M0 net196 VNB sky130_fd_pr__nfet_01v8 m=1 w=0.42u l=0.15u mult=1 sa=0.265
+ sb=0.265 sd=0.28 area=0.063 perim=1.14
MI654 net200 M1 VGND VNB sky130_fd_pr__nfet_01v8 m=1 w=0.42u l=0.15u mult=1 sa=0.265
+ sb=0.265 sd=0.28 area=0.063 perim=1.14
MI36 net212 M0 VGND VNB sky130_fd_pr__nfet_01v8 m=1 w=0.64u l=0.15u mult=1 sa=0.265
+ sb=0.265 sd=0.28 area=0.063 perim=1.14
MI26 S0 clkneg net209 VNB sky130_fd_pr__nfet_01v8 m=1 w=0.42u l=0.15u mult=1 sa=0.265
+ sb=0.265 sd=0.28 area=0.063 perim=1.14
MI42 db clkneg M0 VNB sky130_fd_pr__nfet_01v8 m=1 w=0.42u l=0.15u mult=1 sa=0.265
+ sb=0.265 sd=0.28 area=0.063 perim=1.14
MI46 clkpos clkneg VGND VNB sky130_fd_pr__nfet_01v8 m=1 w=0.42u l=0.15u mult=1
+ sa=0.265 sb=0.265 sd=0.28 area=0.063 perim=1.14
MI44 clkneg CLK VGND VNB sky130_fd_pr__nfet_01v8 m=1 w=0.42u l=0.15u mult=1 sa=0.265
+ sb=0.265 sd=0.28 area=0.063 perim=1.14
MI657 net196 SET_B VGND VNB sky130_fd_pr__nfet_01v8 m=1 w=0.42u l=0.15u mult=1
+ sa=0.265 sb=0.265 sd=0.28 area=0.063 perim=1.14
MI652 net165 S0 VGND VNB sky130_fd_pr__nfet_01v8 m=1 w=0.42u l=0.15u mult=1 sa=0.265
+ sb=0.265 sd=0.28 area=0.063 perim=1.14
MI644 sceb SCE VGND VNB sky130_fd_pr__nfet_01v8 m=1 w=0.42u l=0.15u mult=1 sa=0.265
+ sb=0.265 sd=0.28 area=0.063 perim=1.14
MI25 net157 SET_B VGND VNB sky130_fd_pr__nfet_01v8 m=1 w=0.42u l=0.15u mult=1 sa=0.265
+ sb=0.265 sd=0.28 area=0.063 perim=1.14
MI653 Q net165 VGND VNB sky130_fd_pr__nfet_01v8 m=2 w=0.65u l=0.15u mult=1 sa=0.265
+ sb=0.265 sd=0.28 area=0.063 perim=1.14
MI98 db D n0 VNB sky130_fd_pr__nfet_01v8 m=1 w=0.42u l=0.15u mult=1 sa=0.265 sb=0.265
+ sd=0.28 area=0.525 perim=3.1
MI103 n1 SCD VGND VNB sky130_fd_pr__nfet_01v8 m=1 w=0.42u l=0.15u mult=1 sa=0.265
+ sb=0.265 sd=0.28 area=0.525 perim=3.1
MI120 db SCE n1 VNB sky130_fd_pr__nfet_01v8 m=1 w=0.42u l=0.15u mult=1 sa=0.265
+ sb=0.265 sd=0.28 area=0.525 perim=3.1
MI104 n0 sceb VGND VNB sky130_fd_pr__nfet_01v8 m=1 w=0.42u l=0.15u mult=1 sa=0.265
+ sb=0.265 sd=0.28 area=0.525 perim=3.1
.ENDS sky130_fd_sc_hd__sdfstp_2
* Copyright 2020 The SkyWater PDK Authors
*
* Licensed under the Apache License, Version 2.0 (the "License");
* you may not use this file except in compliance with the License.
* You may obtain a copy of the License at
*
*     https:  www.apache.org licenses LICENSE-2.0
*
* Unless required by applicable law or agreed to in writing, software
* distributed under the License is distributed on an "AS IS" BASIS,
* WITHOUT WARRANTIES OR CONDITIONS OF ANY KIND, either express or implied.
* See the License for the specific language governing permissions and
* limitations under the License.
*
* SPDX-License-Identifier: Apache-2.0

.SUBCKT sky130_fd_sc_hd__sdfstp_4 CLK D SCD SCE SET_B VGND VNB VNB net59 Q
*.PININFO CLK:I D:I SCD:I SCE:I SET_B:I VGND:I VNB:I VNB:I net59:I Q:O
MI645 sceb SCE net59 VNB sky130_fd_pr__pfet_01v8_hvt m=1 w=0.64u l=0.15u mult=1
+ sa=0.265 sb=0.265 sd=0.28 area=0.063 perim=1.14
MI658 M1 M0 net59 VNB sky130_fd_pr__pfet_01v8_hvt m=1 w=0.42u l=0.15u mult=1 sa=0.265
+ sb=0.265 sd=0.28 area=0.063 perim=1.14
MI47 clkpos clkneg net59 VNB sky130_fd_pr__pfet_01v8_hvt m=1 w=0.64u l=0.15u mult=1
+ sa=0.265 sb=0.265 sd=0.28 area=0.063 perim=1.14
MI663 net165 S0 net59 VNB sky130_fd_pr__pfet_01v8_hvt m=1 w=1.0u l=0.15u mult=1
+ sa=0.265 sb=0.265 sd=0.28 area=0.063 perim=1.14
MI660 Q net165 net59 VNB sky130_fd_pr__pfet_01v8_hvt m=4 w=1.0u l=0.15u mult=1 sa=0.265
+ sb=0.265 sd=0.28 area=0.063 perim=1.14
MI659 M1 SET_B net59 VNB sky130_fd_pr__pfet_01v8_hvt m=1 w=0.42u l=0.15u mult=1
+ sa=0.265 sb=0.265 sd=0.28 area=0.063 perim=1.14
MI662 net104 M1 net59 VNB sky130_fd_pr__pfet_01v8_hvt m=1 w=0.42u l=0.15u mult=1
+ sa=0.265 sb=0.265 sd=0.28 area=0.063 perim=1.14
MI664 M0 clkneg net104 VNB sky130_fd_pr__pfet_01v8_hvt m=1 w=0.42u l=0.15u mult=1
+ sa=0.265 sb=0.265 sd=0.28 area=0.063 perim=1.14
MI6 net96 S1 net59 VNB sky130_fd_pr__pfet_01v8_hvt m=1 w=0.42u l=0.15u mult=1 sa=0.265
+ sb=0.265 sd=0.28 area=0.063 perim=1.14
MI669 S0 clkpos net96 VNB sky130_fd_pr__pfet_01v8_hvt m=1 w=0.42u l=0.15u mult=1
+ sa=0.265 sb=0.265 sd=0.28 area=0.063 perim=1.14
MI24 S0 SET_B net59 VNB sky130_fd_pr__pfet_01v8_hvt m=1 w=0.42u l=0.15u mult=1 sa=0.265
+ sb=0.265 sd=0.28 area=0.063 perim=1.14
MI648 S1 S0 net59 VNB sky130_fd_pr__pfet_01v8_hvt m=1 w=0.42u l=0.15u mult=1 sa=0.265
+ sb=0.265 sd=0.28 area=0.063 perim=1.14
MI38 S0 clkneg net84 VNB sky130_fd_pr__pfet_01v8_hvt m=1 w=0.84u l=0.15u mult=1
+ sa=0.265 sb=0.265 sd=0.28 area=0.063 perim=1.14
MI37 net84 M0 net59 VNB sky130_fd_pr__pfet_01v8_hvt m=1 w=0.84u l=0.15u mult=1 sa=0.265
+ sb=0.265 sd=0.28 area=0.063 perim=1.14
MI43 db clkpos M0 VNB sky130_fd_pr__pfet_01v8_hvt m=1 w=0.42u l=0.15u mult=1 sa=0.265
+ sb=0.265 sd=0.28 area=0.063 perim=1.14
MI45 clkneg CLK net59 VNB sky130_fd_pr__pfet_01v8_hvt m=1 w=0.64u l=0.15u mult=1
+ sa=0.265 sb=0.265 sd=0.28 area=0.063 perim=1.14
MI101 db sceb p1 VNB sky130_fd_pr__pfet_01v8_hvt m=1 w=0.64u l=0.15u mult=1 sa=0.265
+ sb=0.265 sd=0.28 area=0.063 perim=1.14
MI107 p0 SCE net59 VNB sky130_fd_pr__pfet_01v8_hvt m=1 w=0.64u l=0.15u mult=1 sa=0.265
+ sb=0.265 sd=0.28 area=0.063 perim=1.14
MI94 db D p0 VNB sky130_fd_pr__pfet_01v8_hvt m=1 w=0.64u l=0.15u mult=1 sa=0.265
+ sb=0.265 sd=0.28 area=0.063 perim=1.14
MI108 p1 SCD net59 VNB sky130_fd_pr__pfet_01v8_hvt m=1 w=0.64u l=0.15u mult=1 sa=0.265
+ sb=0.265 sd=0.28 area=0.063 perim=1.14
MI34 S0 clkpos net189 VNB sky130_fd_pr__nfet_01v8 m=1 w=0.64u l=0.15u mult=1 sa=0.265
+ sb=0.265 sd=0.28 area=0.063 perim=1.14
MI27 net209 S1 net157 VNB sky130_fd_pr__nfet_01v8 m=1 w=0.42u l=0.15u mult=1 sa=0.265
+ sb=0.265 sd=0.28 area=0.063 perim=1.14
MI647 S1 S0 VGND VNB sky130_fd_pr__nfet_01v8 m=1 w=0.42u l=0.15u mult=1 sa=0.265
+ sb=0.265 sd=0.28 area=0.063 perim=1.14
MI655 M0 clkpos net200 VNB sky130_fd_pr__nfet_01v8 m=1 w=0.42u l=0.15u mult=1 sa=0.265
+ sb=0.265 sd=0.28 area=0.063 perim=1.14
MI656 M1 M0 net169 VNB sky130_fd_pr__nfet_01v8 m=1 w=0.42u l=0.15u mult=1 sa=0.265
+ sb=0.265 sd=0.28 area=0.063 perim=1.14
MI654 net200 M1 VGND VNB sky130_fd_pr__nfet_01v8 m=1 w=0.42u l=0.15u mult=1 sa=0.265
+ sb=0.265 sd=0.28 area=0.063 perim=1.14
MI36 net189 M0 VGND VNB sky130_fd_pr__nfet_01v8 m=1 w=0.64u l=0.15u mult=1 sa=0.265
+ sb=0.265 sd=0.28 area=0.063 perim=1.14
MI26 S0 clkneg net209 VNB sky130_fd_pr__nfet_01v8 m=1 w=0.42u l=0.15u mult=1 sa=0.265
+ sb=0.265 sd=0.28 area=0.063 perim=1.14
MI42 db clkneg M0 VNB sky130_fd_pr__nfet_01v8 m=1 w=0.42u l=0.15u mult=1 sa=0.265
+ sb=0.265 sd=0.28 area=0.063 perim=1.14
MI46 clkpos clkneg VGND VNB sky130_fd_pr__nfet_01v8 m=1 w=0.42u l=0.15u mult=1
+ sa=0.265 sb=0.265 sd=0.28 area=0.063 perim=1.14
MI44 clkneg CLK VGND VNB sky130_fd_pr__nfet_01v8 m=1 w=0.42u l=0.15u mult=1 sa=0.265
+ sb=0.265 sd=0.28 area=0.063 perim=1.14
MI657 net169 SET_B VGND VNB sky130_fd_pr__nfet_01v8 m=1 w=0.42u l=0.15u mult=1
+ sa=0.265 sb=0.265 sd=0.28 area=0.063 perim=1.14
MI652 net165 S0 VGND VNB sky130_fd_pr__nfet_01v8 m=1 w=0.65u l=0.15u mult=1 sa=0.265
+ sb=0.265 sd=0.28 area=0.063 perim=1.14
MI644 sceb SCE VGND VNB sky130_fd_pr__nfet_01v8 m=1 w=0.42u l=0.15u mult=1 sa=0.265
+ sb=0.265 sd=0.28 area=0.063 perim=1.14
MI25 net157 SET_B VGND VNB sky130_fd_pr__nfet_01v8 m=1 w=0.42u l=0.15u mult=1 sa=0.265
+ sb=0.265 sd=0.28 area=0.063 perim=1.14
MI653 Q net165 VGND VNB sky130_fd_pr__nfet_01v8 m=4 w=0.65u l=0.15u mult=1 sa=0.265
+ sb=0.265 sd=0.28 area=0.063 perim=1.14
MI98 db D n0 VNB sky130_fd_pr__nfet_01v8 m=1 w=0.42u l=0.15u mult=1 sa=0.265 sb=0.265
+ sd=0.28 area=0.525 perim=3.1
MI103 n1 SCD VGND VNB sky130_fd_pr__nfet_01v8 m=1 w=0.42u l=0.15u mult=1 sa=0.265
+ sb=0.265 sd=0.28 area=0.525 perim=3.1
MI120 db SCE n1 VNB sky130_fd_pr__nfet_01v8 m=1 w=0.42u l=0.15u mult=1 sa=0.265
+ sb=0.265 sd=0.28 area=0.525 perim=3.1
MI104 n0 sceb VGND VNB sky130_fd_pr__nfet_01v8 m=1 w=0.42u l=0.15u mult=1 sa=0.265
+ sb=0.265 sd=0.28 area=0.525 perim=3.1
.ENDS sky130_fd_sc_hd__sdfstp_4
* Copyright 2020 The SkyWater PDK Authors
*
* Licensed under the Apache License, Version 2.0 (the "License");
* you may not use this file except in compliance with the License.
* You may obtain a copy of the License at
*
*     https:  www.apache.org licenses LICENSE-2.0
*
* Unless required by applicable law or agreed to in writing, software
* distributed under the License is distributed on an "AS IS" BASIS,
* WITHOUT WARRANTIES OR CONDITIONS OF ANY KIND, either express or implied.
* See the License for the specific language governing permissions and
* limitations under the License.
*
* SPDX-License-Identifier: Apache-2.0

.SUBCKT sky130_fd_sc_hd__sdfxbp_1 CLK D SCD SCE VGND VNB VNB net59 Q Q_N
*.PININFO CLK:I D:I SCD:I SCE:I VGND:I VNB:I VNB:I net59:I Q:O Q_N:O
MI98 db D n0 VNB sky130_fd_pr__nfet_01v8 m=1 w=0.42u l=0.15u mult=1 sa=0.265 sb=0.265
+ sd=0.28 area=0.525 perim=3.1
MI103 n1 SCD VGND VNB sky130_fd_pr__nfet_01v8 m=1 w=0.42u l=0.15u mult=1 sa=0.265
+ sb=0.265 sd=0.28 area=0.525 perim=3.1
MI120 db SCE n1 VNB sky130_fd_pr__nfet_01v8 m=1 w=0.42u l=0.15u mult=1 sa=0.265
+ sb=0.265 sd=0.28 area=0.525 perim=3.1
MI104 n0 sceb VGND VNB sky130_fd_pr__nfet_01v8 m=1 w=0.42u l=0.15u mult=1 sa=0.265
+ sb=0.265 sd=0.28 area=0.525 perim=3.1
MI657 M0 clkpos net129 VNB sky130_fd_pr__nfet_01v8 m=1 w=0.36u l=0.15u mult=1 sa=0.265
+ sb=0.265 sd=0.28 area=0.063 perim=1.14
MI656 net129 M1 VGND VNB sky130_fd_pr__nfet_01v8 m=1 w=0.42u l=0.15u mult=1 sa=0.265
+ sb=0.265 sd=0.28 area=0.063 perim=1.14
MI641 net120 S1 VGND VNB sky130_fd_pr__nfet_01v8 m=1 w=0.42u l=0.15u mult=1 sa=0.265
+ sb=0.265 sd=0.28 area=0.063 perim=1.14
MI642 S0 clkneg net120 VNB sky130_fd_pr__nfet_01v8 m=1 w=0.36u l=0.15u mult=1 sa=0.265
+ sb=0.265 sd=0.28 area=0.063 perim=1.14
MI646 Q S1 VGND VNB sky130_fd_pr__nfet_01v8 m=1 w=0.65u l=0.15u mult=1 sa=0.265
+ sb=0.265 sd=0.28 area=0.063 perim=1.14
MI648 db clkneg M0 VNB sky130_fd_pr__nfet_01v8 m=1 w=0.36u l=0.15u mult=1 sa=0.265
+ sb=0.265 sd=0.28 area=0.063 perim=1.14
MI635 clkneg CLK VGND VNB sky130_fd_pr__nfet_01v8 m=1 w=0.42u l=0.15u mult=1 sa=0.265
+ sb=0.265 sd=0.28 area=0.063 perim=1.14
MI639 sceb SCE VGND VNB sky130_fd_pr__nfet_01v8 m=1 w=0.42u l=0.15u mult=1 sa=0.265
+ sb=0.265 sd=0.28 area=0.063 perim=1.14
MI652 M1 clkpos S0 VNB sky130_fd_pr__nfet_01v8 m=1 w=0.36u l=0.15u mult=1 sa=0.265
+ sb=0.265 sd=0.28 area=0.063 perim=1.14
MI661 Q_N net153 VGND VNB sky130_fd_pr__nfet_01v8 m=1 w=0.65u l=0.15u mult=1 sa=0.265
+ sb=0.265 sd=0.28 area=0.063 perim=1.14
MI662 net153 S1 VGND VNB sky130_fd_pr__nfet_01v8 m=1 w=0.42u l=0.15u mult=1 sa=0.265
+ sb=0.265 sd=0.28 area=0.063 perim=1.14
MI649 S1 S0 VGND VNB sky130_fd_pr__nfet_01v8 m=1 w=0.65u l=0.15u mult=1 sa=0.265
+ sb=0.265 sd=0.28 area=0.063 perim=1.14
MI634 M1 M0 VGND VNB sky130_fd_pr__nfet_01v8 m=1 w=0.64u l=0.15u mult=1 sa=0.265
+ sb=0.265 sd=0.28 area=0.063 perim=1.14
MI636 clkpos clkneg VGND VNB sky130_fd_pr__nfet_01v8 m=1 w=0.42u l=0.15u mult=1
+ sa=0.265 sb=0.265 sd=0.28 area=0.063 perim=1.14
MI107 p0 SCE net59 VNB sky130_fd_pr__pfet_01v8_hvt m=1 w=0.64u l=0.15u mult=1 sa=0.265
+ sb=0.265 sd=0.28 area=0.063 perim=1.14
MI94 db D p0 VNB sky130_fd_pr__pfet_01v8_hvt m=1 w=0.64u l=0.15u mult=1 sa=0.265
+ sb=0.265 sd=0.28 area=0.063 perim=1.14
MI101 db sceb p1 VNB sky130_fd_pr__pfet_01v8_hvt m=1 w=0.64u l=0.15u mult=1 sa=0.265
+ sb=0.265 sd=0.28 area=0.063 perim=1.14
MI108 p1 SCD net59 VNB sky130_fd_pr__pfet_01v8_hvt m=1 w=0.64u l=0.15u mult=1 sa=0.265
+ sb=0.265 sd=0.28 area=0.063 perim=1.14
MI637 clkpos clkneg net59 VNB sky130_fd_pr__pfet_01v8_hvt m=1 w=0.64u l=0.15u mult=1
+ sa=0.265 sb=0.265 sd=0.28 area=0.063 perim=1.14
MI650 S1 S0 net59 VNB sky130_fd_pr__pfet_01v8_hvt m=1 w=1.0u l=0.15u mult=1 sa=0.265
+ sb=0.265 sd=0.28 area=0.063 perim=1.14
MI644 S0 clkpos net177 VNB sky130_fd_pr__pfet_01v8_hvt m=1 w=0.42u l=0.15u mult=1
+ sa=0.265 sb=0.265 sd=0.28 area=0.063 perim=1.14
MI664 M1 M0 net59 VNB sky130_fd_pr__pfet_01v8_hvt m=1 w=0.75u l=0.15u mult=1 sa=0.265
+ sb=0.265 sd=0.28 area=0.063 perim=1.14
MI658 net160 M1 net59 VNB sky130_fd_pr__pfet_01v8_hvt m=1 w=0.42u l=0.15u mult=1
+ sa=0.265 sb=0.265 sd=0.28 area=0.063 perim=1.14
MI645 Q S1 net59 VNB sky130_fd_pr__pfet_01v8_hvt m=1 w=1.0u l=0.15u mult=1 sa=0.265
+ sb=0.265 sd=0.28 area=0.063 perim=1.14
MI660 Q_N net153 net59 VNB sky130_fd_pr__pfet_01v8_hvt m=1 w=1.0u l=0.15u mult=1
+ sa=0.265 sb=0.265 sd=0.28 area=0.063 perim=1.14
MI643 net177 S1 net59 VNB sky130_fd_pr__pfet_01v8_hvt m=1 w=0.42u l=0.15u mult=1
+ sa=0.265 sb=0.265 sd=0.28 area=0.063 perim=1.14
MI651 db clkpos M0 VNB sky130_fd_pr__pfet_01v8_hvt m=1 w=0.42u l=0.15u mult=1 sa=0.265
+ sb=0.265 sd=0.28 area=0.063 perim=1.14
MI653 M1 clkneg S0 VNB sky130_fd_pr__pfet_01v8_hvt m=1 w=0.42u l=0.15u mult=1 sa=0.265
+ sb=0.265 sd=0.28 area=0.063 perim=1.14
MI640 sceb SCE net59 VNB sky130_fd_pr__pfet_01v8_hvt m=1 w=0.64u l=0.15u mult=1
+ sa=0.265 sb=0.265 sd=0.28 area=0.063 perim=1.14
MI659 M0 clkneg net160 VNB sky130_fd_pr__pfet_01v8_hvt m=1 w=0.42u l=0.15u mult=1
+ sa=0.265 sb=0.265 sd=0.28 area=0.063 perim=1.14
MI638 clkneg CLK net59 VNB sky130_fd_pr__pfet_01v8_hvt m=1 w=0.64u l=0.15u mult=1
+ sa=0.265 sb=0.265 sd=0.28 area=0.063 perim=1.14
MI647 net153 S1 net59 VNB sky130_fd_pr__pfet_01v8_hvt m=1 w=0.64u l=0.15u mult=1
+ sa=0.265 sb=0.265 sd=0.28 area=0.063 perim=1.14
.ENDS sky130_fd_sc_hd__sdfxbp_1
* Copyright 2020 The SkyWater PDK Authors
*
* Licensed under the Apache License, Version 2.0 (the "License");
* you may not use this file except in compliance with the License.
* You may obtain a copy of the License at
*
*     https:  www.apache.org licenses LICENSE-2.0
*
* Unless required by applicable law or agreed to in writing, software
* distributed under the License is distributed on an "AS IS" BASIS,
* WITHOUT WARRANTIES OR CONDITIONS OF ANY KIND, either express or implied.
* See the License for the specific language governing permissions and
* limitations under the License.
*
* SPDX-License-Identifier: Apache-2.0

.SUBCKT sky130_fd_sc_hd__sdfxbp_2 CLK D SCD SCE VGND VNB VNB net59 Q Q_N
*.PININFO CLK:I D:I SCD:I SCE:I VGND:I VNB:I VNB:I net59:I Q:O Q_N:O
MI98 db D n0 VNB sky130_fd_pr__nfet_01v8 m=1 w=0.42u l=0.15u mult=1 sa=0.265 sb=0.265
+ sd=0.28 area=0.525 perim=3.1
MI103 n1 SCD VGND VNB sky130_fd_pr__nfet_01v8 m=1 w=0.42u l=0.15u mult=1 sa=0.265
+ sb=0.265 sd=0.28 area=0.525 perim=3.1
MI120 db SCE n1 VNB sky130_fd_pr__nfet_01v8 m=1 w=0.42u l=0.15u mult=1 sa=0.265
+ sb=0.265 sd=0.28 area=0.525 perim=3.1
MI104 n0 sceb VGND VNB sky130_fd_pr__nfet_01v8 m=1 w=0.42u l=0.15u mult=1 sa=0.265
+ sb=0.265 sd=0.28 area=0.525 perim=3.1
MI657 M0 clkpos net129 VNB sky130_fd_pr__nfet_01v8 m=1 w=0.36u l=0.15u mult=1 sa=0.265
+ sb=0.265 sd=0.28 area=0.063 perim=1.14
MI656 net129 M1 VGND VNB sky130_fd_pr__nfet_01v8 m=1 w=0.42u l=0.15u mult=1 sa=0.265
+ sb=0.265 sd=0.28 area=0.063 perim=1.14
MI641 net120 S1 VGND VNB sky130_fd_pr__nfet_01v8 m=1 w=0.42u l=0.15u mult=1 sa=0.265
+ sb=0.265 sd=0.28 area=0.063 perim=1.14
MI642 S0 clkneg net120 VNB sky130_fd_pr__nfet_01v8 m=1 w=0.36u l=0.15u mult=1 sa=0.265
+ sb=0.265 sd=0.28 area=0.063 perim=1.14
MI646 Q S1 VGND VNB sky130_fd_pr__nfet_01v8 m=2 w=0.65u l=0.15u mult=1 sa=0.265
+ sb=0.265 sd=0.28 area=0.063 perim=1.14
MI648 db clkneg M0 VNB sky130_fd_pr__nfet_01v8 m=1 w=0.36u l=0.15u mult=1 sa=0.265
+ sb=0.265 sd=0.28 area=0.063 perim=1.14
MI635 clkneg CLK VGND VNB sky130_fd_pr__nfet_01v8 m=1 w=0.42u l=0.15u mult=1 sa=0.265
+ sb=0.265 sd=0.28 area=0.063 perim=1.14
MI639 sceb SCE VGND VNB sky130_fd_pr__nfet_01v8 m=1 w=0.42u l=0.15u mult=1 sa=0.265
+ sb=0.265 sd=0.28 area=0.063 perim=1.14
MI652 M1 clkpos S0 VNB sky130_fd_pr__nfet_01v8 m=1 w=0.36u l=0.15u mult=1 sa=0.265
+ sb=0.265 sd=0.28 area=0.063 perim=1.14
MI661 Q_N net153 VGND VNB sky130_fd_pr__nfet_01v8 m=2 w=0.65u l=0.15u mult=1 sa=0.265
+ sb=0.265 sd=0.28 area=0.063 perim=1.14
MI662 net153 S1 VGND VNB sky130_fd_pr__nfet_01v8 m=1 w=0.42u l=0.15u mult=1 sa=0.265
+ sb=0.265 sd=0.28 area=0.063 perim=1.14
MI649 S1 S0 VGND VNB sky130_fd_pr__nfet_01v8 m=1 w=0.65u l=0.15u mult=1 sa=0.265
+ sb=0.265 sd=0.28 area=0.063 perim=1.14
MI634 M1 M0 VGND VNB sky130_fd_pr__nfet_01v8 m=1 w=0.64u l=0.15u mult=1 sa=0.265
+ sb=0.265 sd=0.28 area=0.063 perim=1.14
MI636 clkpos clkneg VGND VNB sky130_fd_pr__nfet_01v8 m=1 w=0.42u l=0.15u mult=1
+ sa=0.265 sb=0.265 sd=0.28 area=0.063 perim=1.14
MI107 p0 SCE net59 VNB sky130_fd_pr__pfet_01v8_hvt m=1 w=0.64u l=0.15u mult=1 sa=0.265
+ sb=0.265 sd=0.28 area=0.063 perim=1.14
MI94 db D p0 VNB sky130_fd_pr__pfet_01v8_hvt m=1 w=0.64u l=0.15u mult=1 sa=0.265
+ sb=0.265 sd=0.28 area=0.063 perim=1.14
MI101 db sceb p1 VNB sky130_fd_pr__pfet_01v8_hvt m=1 w=0.64u l=0.15u mult=1 sa=0.265
+ sb=0.265 sd=0.28 area=0.063 perim=1.14
MI108 p1 SCD net59 VNB sky130_fd_pr__pfet_01v8_hvt m=1 w=0.64u l=0.15u mult=1 sa=0.265
+ sb=0.265 sd=0.28 area=0.063 perim=1.14
MI637 clkpos clkneg net59 VNB sky130_fd_pr__pfet_01v8_hvt m=1 w=0.64u l=0.15u mult=1
+ sa=0.265 sb=0.265 sd=0.28 area=0.063 perim=1.14
MI650 S1 S0 net59 VNB sky130_fd_pr__pfet_01v8_hvt m=1 w=1.0u l=0.15u mult=1 sa=0.265
+ sb=0.265 sd=0.28 area=0.063 perim=1.14
MI644 S0 clkpos net196 VNB sky130_fd_pr__pfet_01v8_hvt m=1 w=0.42u l=0.15u mult=1
+ sa=0.265 sb=0.265 sd=0.28 area=0.063 perim=1.14
MI664 M1 M0 net59 VNB sky130_fd_pr__pfet_01v8_hvt m=1 w=0.75u l=0.15u mult=1 sa=0.265
+ sb=0.265 sd=0.28 area=0.063 perim=1.14
MI658 net189 M1 net59 VNB sky130_fd_pr__pfet_01v8_hvt m=1 w=0.42u l=0.15u mult=1
+ sa=0.265 sb=0.265 sd=0.28 area=0.063 perim=1.14
MI645 Q S1 net59 VNB sky130_fd_pr__pfet_01v8_hvt m=2 w=1.0u l=0.15u mult=1 sa=0.265
+ sb=0.265 sd=0.28 area=0.063 perim=1.14
MI660 Q_N net153 net59 VNB sky130_fd_pr__pfet_01v8_hvt m=2 w=1.0u l=0.15u mult=1
+ sa=0.265 sb=0.265 sd=0.28 area=0.063 perim=1.14
MI643 net196 S1 net59 VNB sky130_fd_pr__pfet_01v8_hvt m=1 w=0.42u l=0.15u mult=1
+ sa=0.265 sb=0.265 sd=0.28 area=0.063 perim=1.14
MI651 db clkpos M0 VNB sky130_fd_pr__pfet_01v8_hvt m=1 w=0.42u l=0.15u mult=1 sa=0.265
+ sb=0.265 sd=0.28 area=0.063 perim=1.14
MI653 M1 clkneg S0 VNB sky130_fd_pr__pfet_01v8_hvt m=1 w=0.42u l=0.15u mult=1 sa=0.265
+ sb=0.265 sd=0.28 area=0.063 perim=1.14
MI640 sceb SCE net59 VNB sky130_fd_pr__pfet_01v8_hvt m=1 w=0.64u l=0.15u mult=1
+ sa=0.265 sb=0.265 sd=0.28 area=0.063 perim=1.14
MI659 M0 clkneg net189 VNB sky130_fd_pr__pfet_01v8_hvt m=1 w=0.42u l=0.15u mult=1
+ sa=0.265 sb=0.265 sd=0.28 area=0.063 perim=1.14
MI638 clkneg CLK net59 VNB sky130_fd_pr__pfet_01v8_hvt m=1 w=0.64u l=0.15u mult=1
+ sa=0.265 sb=0.265 sd=0.28 area=0.063 perim=1.14
MI647 net153 S1 net59 VNB sky130_fd_pr__pfet_01v8_hvt m=1 w=0.64u l=0.15u mult=1
+ sa=0.265 sb=0.265 sd=0.28 area=0.063 perim=1.14
.ENDS sky130_fd_sc_hd__sdfxbp_2
* Copyright 2020 The SkyWater PDK Authors
*
* Licensed under the Apache License, Version 2.0 (the "License");
* you may not use this file except in compliance with the License.
* You may obtain a copy of the License at
*
*     https:  www.apache.org licenses LICENSE-2.0
*
* Unless required by applicable law or agreed to in writing, software
* distributed under the License is distributed on an "AS IS" BASIS,
* WITHOUT WARRANTIES OR CONDITIONS OF ANY KIND, either express or implied.
* See the License for the specific language governing permissions and
* limitations under the License.
*
* SPDX-License-Identifier: Apache-2.0

.SUBCKT sky130_fd_sc_hd__sdfxtp_1 CLK D SCD SCE VGND VNB VNB net59 Q
*.PININFO CLK:I D:I SCD:I SCE:I VGND:I VNB:I VNB:I net59:I Q:O
MI652 M1 clkpos S0 VNB sky130_fd_pr__nfet_01v8 m=1 w=0.36u l=0.15u mult=1 sa=0.265
+ sb=0.265 sd=0.28 area=0.063 perim=1.14
MI649 S1 S0 VGND VNB sky130_fd_pr__nfet_01v8 m=1 w=0.65u l=0.15u mult=1 sa=0.265
+ sb=0.265 sd=0.28 area=0.063 perim=1.14
MI634 M1 M0 VGND VNB sky130_fd_pr__nfet_01v8 m=1 w=0.64u l=0.15u mult=1 sa=0.265
+ sb=0.265 sd=0.28 area=0.063 perim=1.14
MI636 clkpos clkneg VGND VNB sky130_fd_pr__nfet_01v8 m=1 w=0.42u l=0.15u mult=1
+ sa=0.265 sb=0.265 sd=0.28 area=0.063 perim=1.14
MI639 sceb SCE VGND VNB sky130_fd_pr__nfet_01v8 m=1 w=0.42u l=0.15u mult=1 sa=0.265
+ sb=0.265 sd=0.28 area=0.063 perim=1.14
MI657 M0 clkpos net78 VNB sky130_fd_pr__nfet_01v8 m=1 w=0.36u l=0.15u mult=1 sa=0.265
+ sb=0.265 sd=0.28 area=0.063 perim=1.14
MI656 net78 M1 VGND VNB sky130_fd_pr__nfet_01v8 m=1 w=0.42u l=0.15u mult=1 sa=0.265
+ sb=0.265 sd=0.28 area=0.063 perim=1.14
MI641 net54 S1 VGND VNB sky130_fd_pr__nfet_01v8 m=1 w=0.42u l=0.15u mult=1 sa=0.265
+ sb=0.265 sd=0.28 area=0.063 perim=1.14
MI646 Q S1 VGND VNB sky130_fd_pr__nfet_01v8 m=1 w=0.65u l=0.15u mult=1 sa=0.265
+ sb=0.265 sd=0.28 area=0.063 perim=1.14
MI648 db clkneg M0 VNB sky130_fd_pr__nfet_01v8 m=1 w=0.36u l=0.15u mult=1 sa=0.265
+ sb=0.265 sd=0.28 area=0.063 perim=1.14
MI635 clkneg CLK VGND VNB sky130_fd_pr__nfet_01v8 m=1 w=0.42u l=0.15u mult=1 sa=0.265
+ sb=0.265 sd=0.28 area=0.063 perim=1.14
MI642 S0 clkneg net54 VNB sky130_fd_pr__nfet_01v8 m=1 w=0.36u l=0.15u mult=1 sa=0.265
+ sb=0.265 sd=0.28 area=0.063 perim=1.14
MI98 db D n0 VNB sky130_fd_pr__nfet_01v8 m=1 w=0.42u l=0.15u mult=1 sa=0.265 sb=0.265
+ sd=0.28 area=0.525 perim=3.1
MI103 n1 SCD VGND VNB sky130_fd_pr__nfet_01v8 m=1 w=0.42u l=0.15u mult=1 sa=0.265
+ sb=0.265 sd=0.28 area=0.525 perim=3.1
MI120 db SCE n1 VNB sky130_fd_pr__nfet_01v8 m=1 w=0.42u l=0.15u mult=1 sa=0.265
+ sb=0.265 sd=0.28 area=0.525 perim=3.1
MI104 n0 sceb VGND VNB sky130_fd_pr__nfet_01v8 m=1 w=0.42u l=0.15u mult=1 sa=0.265
+ sb=0.265 sd=0.28 area=0.525 perim=3.1
MI643 net122 S1 net59 VNB sky130_fd_pr__pfet_01v8_hvt m=1 w=0.42u l=0.15u mult=1
+ sa=0.265 sb=0.265 sd=0.28 area=0.063 perim=1.14
MI640 sceb SCE net59 VNB sky130_fd_pr__pfet_01v8_hvt m=1 w=0.64u l=0.15u mult=1
+ sa=0.265 sb=0.265 sd=0.28 area=0.063 perim=1.14
MI658 net155 M1 net59 VNB sky130_fd_pr__pfet_01v8_hvt m=1 w=0.42u l=0.15u mult=1
+ sa=0.265 sb=0.265 sd=0.28 area=0.063 perim=1.14
MI645 Q S1 net59 VNB sky130_fd_pr__pfet_01v8_hvt m=1 w=1.0u l=0.15u mult=1 sa=0.265
+ sb=0.265 sd=0.28 area=0.063 perim=1.14
MI651 db clkpos M0 VNB sky130_fd_pr__pfet_01v8_hvt m=1 w=0.42u l=0.15u mult=1 sa=0.265
+ sb=0.265 sd=0.28 area=0.063 perim=1.14
MI653 M1 clkneg S0 VNB sky130_fd_pr__pfet_01v8_hvt m=1 w=0.42u l=0.15u mult=1 sa=0.265
+ sb=0.265 sd=0.28 area=0.063 perim=1.14
MI659 M0 clkneg net155 VNB sky130_fd_pr__pfet_01v8_hvt m=1 w=0.42u l=0.15u mult=1
+ sa=0.265 sb=0.265 sd=0.28 area=0.063 perim=1.14
MI638 clkneg CLK net59 VNB sky130_fd_pr__pfet_01v8_hvt m=1 w=0.64u l=0.15u mult=1
+ sa=0.265 sb=0.265 sd=0.28 area=0.063 perim=1.14
MI637 clkpos clkneg net59 VNB sky130_fd_pr__pfet_01v8_hvt m=1 w=0.64u l=0.15u mult=1
+ sa=0.265 sb=0.265 sd=0.28 area=0.063 perim=1.14
MI650 S1 S0 net59 VNB sky130_fd_pr__pfet_01v8_hvt m=1 w=1.0u l=0.15u mult=1 sa=0.265
+ sb=0.265 sd=0.28 area=0.063 perim=1.14
MI644 S0 clkpos net122 VNB sky130_fd_pr__pfet_01v8_hvt m=1 w=0.42u l=0.15u mult=1
+ sa=0.265 sb=0.265 sd=0.28 area=0.063 perim=1.14
MI664 M1 M0 net59 VNB sky130_fd_pr__pfet_01v8_hvt m=1 w=0.75u l=0.15u mult=1 sa=0.265
+ sb=0.265 sd=0.28 area=0.063 perim=1.14
MI107 p0 SCE net59 VNB sky130_fd_pr__pfet_01v8_hvt m=1 w=0.64u l=0.15u mult=1 sa=0.265
+ sb=0.265 sd=0.28 area=0.063 perim=1.14
MI94 db D p0 VNB sky130_fd_pr__pfet_01v8_hvt m=1 w=0.64u l=0.15u mult=1 sa=0.265
+ sb=0.265 sd=0.28 area=0.063 perim=1.14
MI108 p1 SCD net59 VNB sky130_fd_pr__pfet_01v8_hvt m=1 w=0.64u l=0.15u mult=1 sa=0.265
+ sb=0.265 sd=0.28 area=0.063 perim=1.14
MI101 db sceb p1 VNB sky130_fd_pr__pfet_01v8_hvt m=1 w=0.64u l=0.15u mult=1 sa=0.265
+ sb=0.265 sd=0.28 area=0.063 perim=1.14
.ENDS sky130_fd_sc_hd__sdfxtp_1
* Copyright 2020 The SkyWater PDK Authors
*
* Licensed under the Apache License, Version 2.0 (the "License");
* you may not use this file except in compliance with the License.
* You may obtain a copy of the License at
*
*     https:  www.apache.org licenses LICENSE-2.0
*
* Unless required by applicable law or agreed to in writing, software
* distributed under the License is distributed on an "AS IS" BASIS,
* WITHOUT WARRANTIES OR CONDITIONS OF ANY KIND, either express or implied.
* See the License for the specific language governing permissions and
* limitations under the License.
*
* SPDX-License-Identifier: Apache-2.0

.SUBCKT sky130_fd_sc_hd__sdfxtp_2 CLK D SCD SCE VGND VNB VNB net59 Q
*.PININFO CLK:I D:I SCD:I SCE:I VGND:I VNB:I VNB:I net59:I Q:O
MI652 M1 clkpos S0 VNB sky130_fd_pr__nfet_01v8 m=1 w=0.36u l=0.15u mult=1 sa=0.265
+ sb=0.265 sd=0.28 area=0.063 perim=1.14
MI649 S1 S0 VGND VNB sky130_fd_pr__nfet_01v8 m=1 w=0.65u l=0.15u mult=1 sa=0.265
+ sb=0.265 sd=0.28 area=0.063 perim=1.14
MI634 M1 M0 VGND VNB sky130_fd_pr__nfet_01v8 m=1 w=0.64u l=0.15u mult=1 sa=0.265
+ sb=0.265 sd=0.28 area=0.063 perim=1.14
MI636 clkpos clkneg VGND VNB sky130_fd_pr__nfet_01v8 m=1 w=0.42u l=0.15u mult=1
+ sa=0.265 sb=0.265 sd=0.28 area=0.063 perim=1.14
MI639 sceb SCE VGND VNB sky130_fd_pr__nfet_01v8 m=1 w=0.42u l=0.15u mult=1 sa=0.265
+ sb=0.265 sd=0.28 area=0.063 perim=1.14
MI657 M0 clkpos net78 VNB sky130_fd_pr__nfet_01v8 m=1 w=0.36u l=0.15u mult=1 sa=0.265
+ sb=0.265 sd=0.28 area=0.063 perim=1.14
MI656 net78 M1 VGND VNB sky130_fd_pr__nfet_01v8 m=1 w=0.42u l=0.15u mult=1 sa=0.265
+ sb=0.265 sd=0.28 area=0.063 perim=1.14
MI641 net54 S1 VGND VNB sky130_fd_pr__nfet_01v8 m=1 w=0.42u l=0.15u mult=1 sa=0.265
+ sb=0.265 sd=0.28 area=0.063 perim=1.14
MI646 Q S1 VGND VNB sky130_fd_pr__nfet_01v8 m=2 w=0.65u l=0.15u mult=1 sa=0.265
+ sb=0.265 sd=0.28 area=0.063 perim=1.14
MI648 db clkneg M0 VNB sky130_fd_pr__nfet_01v8 m=1 w=0.36u l=0.15u mult=1 sa=0.265
+ sb=0.265 sd=0.28 area=0.063 perim=1.14
MI635 clkneg CLK VGND VNB sky130_fd_pr__nfet_01v8 m=1 w=0.42u l=0.15u mult=1 sa=0.265
+ sb=0.265 sd=0.28 area=0.063 perim=1.14
MI642 S0 clkneg net54 VNB sky130_fd_pr__nfet_01v8 m=1 w=0.36u l=0.15u mult=1 sa=0.265
+ sb=0.265 sd=0.28 area=0.063 perim=1.14
MI98 db D n0 VNB sky130_fd_pr__nfet_01v8 m=1 w=0.42u l=0.15u mult=1 sa=0.265 sb=0.265
+ sd=0.28 area=0.525 perim=3.1
MI103 n1 SCD VGND VNB sky130_fd_pr__nfet_01v8 m=1 w=0.42u l=0.15u mult=1 sa=0.265
+ sb=0.265 sd=0.28 area=0.525 perim=3.1
MI120 db SCE n1 VNB sky130_fd_pr__nfet_01v8 m=1 w=0.42u l=0.15u mult=1 sa=0.265
+ sb=0.265 sd=0.28 area=0.525 perim=3.1
MI104 n0 sceb VGND VNB sky130_fd_pr__nfet_01v8 m=1 w=0.42u l=0.15u mult=1 sa=0.265
+ sb=0.265 sd=0.28 area=0.525 perim=3.1
MI643 net163 S1 net59 VNB sky130_fd_pr__pfet_01v8_hvt m=1 w=0.42u l=0.15u mult=1
+ sa=0.265 sb=0.265 sd=0.28 area=0.063 perim=1.14
MI640 sceb SCE net59 VNB sky130_fd_pr__pfet_01v8_hvt m=1 w=0.64u l=0.15u mult=1
+ sa=0.265 sb=0.265 sd=0.28 area=0.063 perim=1.14
MI658 net138 M1 net59 VNB sky130_fd_pr__pfet_01v8_hvt m=1 w=0.42u l=0.15u mult=1
+ sa=0.265 sb=0.265 sd=0.28 area=0.063 perim=1.14
MI645 Q S1 net59 VNB sky130_fd_pr__pfet_01v8_hvt m=2 w=1.0u l=0.15u mult=1 sa=0.265
+ sb=0.265 sd=0.28 area=0.063 perim=1.14
MI651 db clkpos M0 VNB sky130_fd_pr__pfet_01v8_hvt m=1 w=0.42u l=0.15u mult=1 sa=0.265
+ sb=0.265 sd=0.28 area=0.063 perim=1.14
MI653 M1 clkneg S0 VNB sky130_fd_pr__pfet_01v8_hvt m=1 w=0.42u l=0.15u mult=1 sa=0.265
+ sb=0.265 sd=0.28 area=0.063 perim=1.14
MI659 M0 clkneg net138 VNB sky130_fd_pr__pfet_01v8_hvt m=1 w=0.42u l=0.15u mult=1
+ sa=0.265 sb=0.265 sd=0.28 area=0.063 perim=1.14
MI638 clkneg CLK net59 VNB sky130_fd_pr__pfet_01v8_hvt m=1 w=0.64u l=0.15u mult=1
+ sa=0.265 sb=0.265 sd=0.28 area=0.063 perim=1.14
MI637 clkpos clkneg net59 VNB sky130_fd_pr__pfet_01v8_hvt m=1 w=0.64u l=0.15u mult=1
+ sa=0.265 sb=0.265 sd=0.28 area=0.063 perim=1.14
MI650 S1 S0 net59 VNB sky130_fd_pr__pfet_01v8_hvt m=1 w=1.0u l=0.15u mult=1 sa=0.265
+ sb=0.265 sd=0.28 area=0.063 perim=1.14
MI644 S0 clkpos net163 VNB sky130_fd_pr__pfet_01v8_hvt m=1 w=0.42u l=0.15u mult=1
+ sa=0.265 sb=0.265 sd=0.28 area=0.063 perim=1.14
MI664 M1 M0 net59 VNB sky130_fd_pr__pfet_01v8_hvt m=1 w=0.75u l=0.15u mult=1 sa=0.265
+ sb=0.265 sd=0.28 area=0.063 perim=1.14
MI107 p0 SCE net59 VNB sky130_fd_pr__pfet_01v8_hvt m=1 w=0.64u l=0.15u mult=1 sa=0.265
+ sb=0.265 sd=0.28 area=0.063 perim=1.14
MI94 db D p0 VNB sky130_fd_pr__pfet_01v8_hvt m=1 w=0.64u l=0.15u mult=1 sa=0.265
+ sb=0.265 sd=0.28 area=0.063 perim=1.14
MI108 p1 SCD net59 VNB sky130_fd_pr__pfet_01v8_hvt m=1 w=0.64u l=0.15u mult=1 sa=0.265
+ sb=0.265 sd=0.28 area=0.063 perim=1.14
MI101 db sceb p1 VNB sky130_fd_pr__pfet_01v8_hvt m=1 w=0.64u l=0.15u mult=1 sa=0.265
+ sb=0.265 sd=0.28 area=0.063 perim=1.14
.ENDS sky130_fd_sc_hd__sdfxtp_2
* Copyright 2020 The SkyWater PDK Authors
*
* Licensed under the Apache License, Version 2.0 (the "License");
* you may not use this file except in compliance with the License.
* You may obtain a copy of the License at
*
*     https:  www.apache.org licenses LICENSE-2.0
*
* Unless required by applicable law or agreed to in writing, software
* distributed under the License is distributed on an "AS IS" BASIS,
* WITHOUT WARRANTIES OR CONDITIONS OF ANY KIND, either express or implied.
* See the License for the specific language governing permissions and
* limitations under the License.
*
* SPDX-License-Identifier: Apache-2.0

.SUBCKT sky130_fd_sc_hd__sdfxtp_4 CLK D SCD SCE VGND VNB VNB net59 Q
*.PININFO CLK:I D:I SCD:I SCE:I VGND:I VNB:I VNB:I net59:I Q:O
MI652 M1 clkpos S0 VNB sky130_fd_pr__nfet_01v8 m=1 w=0.36u l=0.15u mult=1 sa=0.265
+ sb=0.265 sd=0.28 area=0.063 perim=1.14
MI649 S1 S0 VGND VNB sky130_fd_pr__nfet_01v8 m=1 w=0.65u l=0.15u mult=1 sa=0.265
+ sb=0.265 sd=0.28 area=0.063 perim=1.14
MI634 M1 M0 VGND VNB sky130_fd_pr__nfet_01v8 m=1 w=0.64u l=0.15u mult=1 sa=0.265
+ sb=0.265 sd=0.28 area=0.063 perim=1.14
MI636 clkpos clkneg VGND VNB sky130_fd_pr__nfet_01v8 m=1 w=0.42u l=0.15u mult=1
+ sa=0.265 sb=0.265 sd=0.28 area=0.063 perim=1.14
MI639 sceb SCE VGND VNB sky130_fd_pr__nfet_01v8 m=1 w=0.42u l=0.15u mult=1 sa=0.265
+ sb=0.265 sd=0.28 area=0.063 perim=1.14
MI657 M0 clkpos net78 VNB sky130_fd_pr__nfet_01v8 m=1 w=0.36u l=0.15u mult=1 sa=0.265
+ sb=0.265 sd=0.28 area=0.063 perim=1.14
MI656 net78 M1 VGND VNB sky130_fd_pr__nfet_01v8 m=1 w=0.42u l=0.15u mult=1 sa=0.265
+ sb=0.265 sd=0.28 area=0.063 perim=1.14
MI641 net54 S1 VGND VNB sky130_fd_pr__nfet_01v8 m=1 w=0.42u l=0.15u mult=1 sa=0.265
+ sb=0.265 sd=0.28 area=0.063 perim=1.14
MI646 Q S1 VGND VNB sky130_fd_pr__nfet_01v8 m=4 w=0.65u l=0.15u mult=1 sa=0.265
+ sb=0.265 sd=0.28 area=0.063 perim=1.14
MI648 db clkneg M0 VNB sky130_fd_pr__nfet_01v8 m=1 w=0.36u l=0.15u mult=1 sa=0.265
+ sb=0.265 sd=0.28 area=0.063 perim=1.14
MI635 clkneg CLK VGND VNB sky130_fd_pr__nfet_01v8 m=1 w=0.42u l=0.15u mult=1 sa=0.265
+ sb=0.265 sd=0.28 area=0.063 perim=1.14
MI642 S0 clkneg net54 VNB sky130_fd_pr__nfet_01v8 m=1 w=0.36u l=0.15u mult=1 sa=0.265
+ sb=0.265 sd=0.28 area=0.063 perim=1.14
MI98 db D n0 VNB sky130_fd_pr__nfet_01v8 m=1 w=0.42u l=0.15u mult=1 sa=0.265 sb=0.265
+ sd=0.28 area=0.525 perim=3.1
MI103 n1 SCD VGND VNB sky130_fd_pr__nfet_01v8 m=1 w=0.42u l=0.15u mult=1 sa=0.265
+ sb=0.265 sd=0.28 area=0.525 perim=3.1
MI120 db SCE n1 VNB sky130_fd_pr__nfet_01v8 m=1 w=0.42u l=0.15u mult=1 sa=0.265
+ sb=0.265 sd=0.28 area=0.525 perim=3.1
MI104 n0 sceb VGND VNB sky130_fd_pr__nfet_01v8 m=1 w=0.42u l=0.15u mult=1 sa=0.265
+ sb=0.265 sd=0.28 area=0.525 perim=3.1
MI643 net163 S1 net59 VNB sky130_fd_pr__pfet_01v8_hvt m=1 w=0.42u l=0.15u mult=1
+ sa=0.265 sb=0.265 sd=0.28 area=0.063 perim=1.14
MI640 sceb SCE net59 VNB sky130_fd_pr__pfet_01v8_hvt m=1 w=0.64u l=0.15u mult=1
+ sa=0.265 sb=0.265 sd=0.28 area=0.063 perim=1.14
MI658 net155 M1 net59 VNB sky130_fd_pr__pfet_01v8_hvt m=1 w=0.42u l=0.15u mult=1
+ sa=0.265 sb=0.265 sd=0.28 area=0.063 perim=1.14
MI645 Q S1 net59 VNB sky130_fd_pr__pfet_01v8_hvt m=4 w=1.0u l=0.15u mult=1 sa=0.265
+ sb=0.265 sd=0.28 area=0.063 perim=1.14
MI651 db clkpos M0 VNB sky130_fd_pr__pfet_01v8_hvt m=1 w=0.42u l=0.15u mult=1 sa=0.265
+ sb=0.265 sd=0.28 area=0.063 perim=1.14
MI653 M1 clkneg S0 VNB sky130_fd_pr__pfet_01v8_hvt m=1 w=0.42u l=0.15u mult=1 sa=0.265
+ sb=0.265 sd=0.28 area=0.063 perim=1.14
MI659 M0 clkneg net155 VNB sky130_fd_pr__pfet_01v8_hvt m=1 w=0.42u l=0.15u mult=1
+ sa=0.265 sb=0.265 sd=0.28 area=0.063 perim=1.14
MI638 clkneg CLK net59 VNB sky130_fd_pr__pfet_01v8_hvt m=1 w=0.64u l=0.15u mult=1
+ sa=0.265 sb=0.265 sd=0.28 area=0.063 perim=1.14
MI637 clkpos clkneg net59 VNB sky130_fd_pr__pfet_01v8_hvt m=1 w=0.64u l=0.15u mult=1
+ sa=0.265 sb=0.265 sd=0.28 area=0.063 perim=1.14
MI650 S1 S0 net59 VNB sky130_fd_pr__pfet_01v8_hvt m=1 w=1.0u l=0.15u mult=1 sa=0.265
+ sb=0.265 sd=0.28 area=0.063 perim=1.14
MI644 S0 clkpos net163 VNB sky130_fd_pr__pfet_01v8_hvt m=1 w=0.42u l=0.15u mult=1
+ sa=0.265 sb=0.265 sd=0.28 area=0.063 perim=1.14
MI664 M1 M0 net59 VNB sky130_fd_pr__pfet_01v8_hvt m=1 w=0.75u l=0.15u mult=1 sa=0.265
+ sb=0.265 sd=0.28 area=0.063 perim=1.14
MI107 p0 SCE net59 VNB sky130_fd_pr__pfet_01v8_hvt m=1 w=0.64u l=0.15u mult=1 sa=0.265
+ sb=0.265 sd=0.28 area=0.063 perim=1.14
MI94 db D p0 VNB sky130_fd_pr__pfet_01v8_hvt m=1 w=0.64u l=0.15u mult=1 sa=0.265
+ sb=0.265 sd=0.28 area=0.063 perim=1.14
MI108 p1 SCD net59 VNB sky130_fd_pr__pfet_01v8_hvt m=1 w=0.64u l=0.15u mult=1 sa=0.265
+ sb=0.265 sd=0.28 area=0.063 perim=1.14
MI101 db sceb p1 VNB sky130_fd_pr__pfet_01v8_hvt m=1 w=0.64u l=0.15u mult=1 sa=0.265
+ sb=0.265 sd=0.28 area=0.063 perim=1.14
.ENDS sky130_fd_sc_hd__sdfxtp_4
* Copyright 2020 The SkyWater PDK Authors
*
* Licensed under the Apache License, Version 2.0 (the "License");
* you may not use this file except in compliance with the License.
* You may obtain a copy of the License at
*
*     https:  www.apache.org licenses LICENSE-2.0
*
* Unless required by applicable law or agreed to in writing, software
* distributed under the License is distributed on an "AS IS" BASIS,
* WITHOUT WARRANTIES OR CONDITIONS OF ANY KIND, either express or implied.
* See the License for the specific language governing permissions and
* limitations under the License.
*
* SPDX-License-Identifier: Apache-2.0

.SUBCKT sky130_fd_sc_hd__sdlclkp_1 CLK GATE SCE VGND VNB VNB net59 GCLK
*.PININFO CLK:I GATE:I SCE:I VGND:I VNB:I VNB:I net59:I GCLK:O
MI662 net88 m1 net59 VNB sky130_fd_pr__pfet_01v8_hvt m=1 w=0.42u l=0.15u mult=1
+ sa=0.265 sb=0.265 sd=0.28 area=0.063 perim=1.14
MI664 M0 clkpos net88 VNB sky130_fd_pr__pfet_01v8_hvt m=1 w=0.42u l=0.15u mult=1
+ sa=0.265 sb=0.265 sd=0.28 area=0.063 perim=1.14
MI659 net76 CLK net59 VNB sky130_fd_pr__pfet_01v8_hvt m=1 w=0.64u l=0.15u mult=1
+ sa=0.265 sb=0.265 sd=0.28 area=0.063 perim=1.14
MI658 net76 m1 net59 VNB sky130_fd_pr__pfet_01v8_hvt m=1 w=0.64u l=0.15u mult=1
+ sa=0.265 sb=0.265 sd=0.28 area=0.063 perim=1.14
MI19 m1 M0 net59 VNB sky130_fd_pr__pfet_01v8_hvt m=1 w=1.0u l=0.15u mult=1 sa=0.265
+ sb=0.265 sd=0.28 area=0.063 perim=1.14
MI22 net63 SCE net59 VNB sky130_fd_pr__pfet_01v8_hvt m=1 w=0.64u l=0.15u mult=1
+ sa=0.265 sb=0.265 sd=0.28 area=0.063 perim=1.14
MI21 net116 GATE net63 VNB sky130_fd_pr__pfet_01v8_hvt m=1 w=0.64u l=0.15u mult=1
+ sa=0.265 sb=0.265 sd=0.28 area=0.063 perim=1.14
MI47 clkneg clkpos net59 VNB sky130_fd_pr__pfet_01v8_hvt m=1 w=0.64u l=0.15u mult=1
+ sa=0.265 sb=0.265 sd=0.28 area=0.063 perim=1.14
MI45 clkpos CLK net59 VNB sky130_fd_pr__pfet_01v8_hvt m=1 w=0.64u l=0.15u mult=1
+ sa=0.265 sb=0.265 sd=0.28 area=0.063 perim=1.14
MI660 GCLK net76 net59 VNB sky130_fd_pr__pfet_01v8_hvt m=1 w=1.0u l=0.15u mult=1
+ sa=0.265 sb=0.265 sd=0.28 area=0.063 perim=1.14
MI43 net116 clkneg M0 VNB sky130_fd_pr__pfet_01v8_hvt m=1 w=0.42u l=0.15u mult=1
+ sa=0.265 sb=0.265 sd=0.28 area=0.063 perim=1.14
MI42 net116 clkpos M0 VNB sky130_fd_pr__nfet_01v8 m=1 w=0.36u l=0.15u mult=1 sa=0.265
+ sb=0.265 sd=0.28 area=0.063 perim=1.14
MI20 m1 M0 VGND VNB sky130_fd_pr__nfet_01v8 m=1 w=0.65u l=0.15u mult=1 sa=0.265
+ sb=0.265 sd=0.28 area=0.063 perim=1.14
MI655 M0 clkneg net123 VNB sky130_fd_pr__nfet_01v8 m=1 w=0.36u l=0.15u mult=1 sa=0.265
+ sb=0.265 sd=0.28 area=0.063 perim=1.14
MI654 net123 m1 VGND VNB sky130_fd_pr__nfet_01v8 m=1 w=0.42u l=0.15u mult=1 sa=0.265
+ sb=0.265 sd=0.28 area=0.063 perim=1.14
MI24 net116 SCE VGND VNB sky130_fd_pr__nfet_01v8 m=1 w=0.42u l=0.15u mult=1 sa=0.265
+ sb=0.265 sd=0.28 area=0.063 perim=1.14
MI657 net112 CLK VGND VNB sky130_fd_pr__nfet_01v8 m=1 w=0.42u l=0.15u mult=1 sa=0.265
+ sb=0.265 sd=0.28 area=0.063 perim=1.14
MI656 net76 m1 net112 VNB sky130_fd_pr__nfet_01v8 m=1 w=0.42u l=0.15u mult=1 sa=0.265
+ sb=0.265 sd=0.28 area=0.063 perim=1.14
MI23 net116 GATE VGND VNB sky130_fd_pr__nfet_01v8 m=1 w=0.42u l=0.15u mult=1 sa=0.265
+ sb=0.265 sd=0.28 area=0.063 perim=1.14
MI46 clkneg clkpos VGND VNB sky130_fd_pr__nfet_01v8 m=1 w=0.42u l=0.15u mult=1
+ sa=0.265 sb=0.265 sd=0.28 area=0.063 perim=1.14
MI44 clkpos CLK VGND VNB sky130_fd_pr__nfet_01v8 m=1 w=0.42u l=0.15u mult=1 sa=0.265
+ sb=0.265 sd=0.28 area=0.063 perim=1.14
MI653 GCLK net76 VGND VNB sky130_fd_pr__nfet_01v8 m=1 w=0.65u l=0.15u mult=1 sa=0.265
+ sb=0.265 sd=0.28 area=0.063 perim=1.14
.ENDS sky130_fd_sc_hd__sdlclkp_1
* Copyright 2020 The SkyWater PDK Authors
*
* Licensed under the Apache License, Version 2.0 (the "License");
* you may not use this file except in compliance with the License.
* You may obtain a copy of the License at
*
*     https:  www.apache.org licenses LICENSE-2.0
*
* Unless required by applicable law or agreed to in writing, software
* distributed under the License is distributed on an "AS IS" BASIS,
* WITHOUT WARRANTIES OR CONDITIONS OF ANY KIND, either express or implied.
* See the License for the specific language governing permissions and
* limitations under the License.
*
* SPDX-License-Identifier: Apache-2.0

.SUBCKT sky130_fd_sc_hd__sdlclkp_2 CLK GATE SCE VGND VNB VNB net59 GCLK
*.PININFO CLK:I GATE:I SCE:I VGND:I VNB:I VNB:I net59:I GCLK:O
MI662 net88 m1 net59 VNB sky130_fd_pr__pfet_01v8_hvt m=1 w=0.42u l=0.15u mult=1
+ sa=0.265 sb=0.265 sd=0.28 area=0.063 perim=1.14
MI664 M0 clkpos net88 VNB sky130_fd_pr__pfet_01v8_hvt m=1 w=0.42u l=0.15u mult=1
+ sa=0.265 sb=0.265 sd=0.28 area=0.063 perim=1.14
MI659 net76 CLK net59 VNB sky130_fd_pr__pfet_01v8_hvt m=1 w=0.64u l=0.15u mult=1
+ sa=0.265 sb=0.265 sd=0.28 area=0.063 perim=1.14
MI658 net76 m1 net59 VNB sky130_fd_pr__pfet_01v8_hvt m=1 w=0.64u l=0.15u mult=1
+ sa=0.265 sb=0.265 sd=0.28 area=0.063 perim=1.14
MI19 m1 M0 net59 VNB sky130_fd_pr__pfet_01v8_hvt m=1 w=1.0u l=0.15u mult=1 sa=0.265
+ sb=0.265 sd=0.28 area=0.063 perim=1.14
MI22 net63 SCE net59 VNB sky130_fd_pr__pfet_01v8_hvt m=1 w=0.64u l=0.15u mult=1
+ sa=0.265 sb=0.265 sd=0.28 area=0.063 perim=1.14
MI21 net116 GATE net63 VNB sky130_fd_pr__pfet_01v8_hvt m=1 w=0.64u l=0.15u mult=1
+ sa=0.265 sb=0.265 sd=0.28 area=0.063 perim=1.14
MI47 clkneg clkpos net59 VNB sky130_fd_pr__pfet_01v8_hvt m=1 w=0.64u l=0.15u mult=1
+ sa=0.265 sb=0.265 sd=0.28 area=0.063 perim=1.14
MI45 clkpos CLK net59 VNB sky130_fd_pr__pfet_01v8_hvt m=1 w=0.64u l=0.15u mult=1
+ sa=0.265 sb=0.265 sd=0.28 area=0.063 perim=1.14
MI660 GCLK net76 net59 VNB sky130_fd_pr__pfet_01v8_hvt m=2 w=1.0u l=0.15u mult=1
+ sa=0.265 sb=0.265 sd=0.28 area=0.063 perim=1.14
MI43 net116 clkneg M0 VNB sky130_fd_pr__pfet_01v8_hvt m=1 w=0.42u l=0.15u mult=1
+ sa=0.265 sb=0.265 sd=0.28 area=0.063 perim=1.14
MI42 net116 clkpos M0 VNB sky130_fd_pr__nfet_01v8 m=1 w=0.36u l=0.15u mult=1 sa=0.265
+ sb=0.265 sd=0.28 area=0.063 perim=1.14
MI20 m1 M0 VGND VNB sky130_fd_pr__nfet_01v8 m=1 w=0.65u l=0.15u mult=1 sa=0.265
+ sb=0.265 sd=0.28 area=0.063 perim=1.14
MI655 M0 clkneg net123 VNB sky130_fd_pr__nfet_01v8 m=1 w=0.36u l=0.15u mult=1 sa=0.265
+ sb=0.265 sd=0.28 area=0.063 perim=1.14
MI654 net123 m1 VGND VNB sky130_fd_pr__nfet_01v8 m=1 w=0.42u l=0.15u mult=1 sa=0.265
+ sb=0.265 sd=0.28 area=0.063 perim=1.14
MI24 net116 SCE VGND VNB sky130_fd_pr__nfet_01v8 m=1 w=0.42u l=0.15u mult=1 sa=0.265
+ sb=0.265 sd=0.28 area=0.063 perim=1.14
MI657 net112 CLK VGND VNB sky130_fd_pr__nfet_01v8 m=1 w=0.42u l=0.15u mult=1 sa=0.265
+ sb=0.265 sd=0.28 area=0.063 perim=1.14
MI656 net76 m1 net112 VNB sky130_fd_pr__nfet_01v8 m=1 w=0.42u l=0.15u mult=1 sa=0.265
+ sb=0.265 sd=0.28 area=0.063 perim=1.14
MI23 net116 GATE VGND VNB sky130_fd_pr__nfet_01v8 m=1 w=0.42u l=0.15u mult=1 sa=0.265
+ sb=0.265 sd=0.28 area=0.063 perim=1.14
MI46 clkneg clkpos VGND VNB sky130_fd_pr__nfet_01v8 m=1 w=0.42u l=0.15u mult=1
+ sa=0.265 sb=0.265 sd=0.28 area=0.063 perim=1.14
MI44 clkpos CLK VGND VNB sky130_fd_pr__nfet_01v8 m=1 w=0.42u l=0.15u mult=1 sa=0.265
+ sb=0.265 sd=0.28 area=0.063 perim=1.14
MI653 GCLK net76 VGND VNB sky130_fd_pr__nfet_01v8 m=2 w=0.65u l=0.15u mult=1 sa=0.265
+ sb=0.265 sd=0.28 area=0.063 perim=1.14
.ENDS sky130_fd_sc_hd__sdlclkp_2
* Copyright 2020 The SkyWater PDK Authors
*
* Licensed under the Apache License, Version 2.0 (the "License");
* you may not use this file except in compliance with the License.
* You may obtain a copy of the License at
*
*     https:  www.apache.org licenses LICENSE-2.0
*
* Unless required by applicable law or agreed to in writing, software
* distributed under the License is distributed on an "AS IS" BASIS,
* WITHOUT WARRANTIES OR CONDITIONS OF ANY KIND, either express or implied.
* See the License for the specific language governing permissions and
* limitations under the License.
*
* SPDX-License-Identifier: Apache-2.0

.SUBCKT sky130_fd_sc_hd__sdlclkp_4 CLK GATE SCE VGND VNB VNB net59 GCLK
*.PININFO CLK:I GATE:I SCE:I VGND:I VNB:I VNB:I net59:I GCLK:O
MI662 net88 m1 net59 VNB sky130_fd_pr__pfet_01v8_hvt m=1 w=0.42u l=0.15u mult=1
+ sa=0.265 sb=0.265 sd=0.28 area=0.063 perim=1.14
MI664 M0 clkpos net88 VNB sky130_fd_pr__pfet_01v8_hvt m=1 w=0.42u l=0.15u mult=1
+ sa=0.265 sb=0.265 sd=0.28 area=0.063 perim=1.14
MI659 net76 CLK net59 VNB sky130_fd_pr__pfet_01v8_hvt m=1 w=1.0u l=0.15u mult=1
+ sa=0.265 sb=0.265 sd=0.28 area=0.063 perim=1.14
MI658 net76 m1 net59 VNB sky130_fd_pr__pfet_01v8_hvt m=1 w=1.0u l=0.15u mult=1 sa=0.265
+ sb=0.265 sd=0.28 area=0.063 perim=1.14
MI19 m1 M0 net59 VNB sky130_fd_pr__pfet_01v8_hvt m=1 w=1.0u l=0.15u mult=1 sa=0.265
+ sb=0.265 sd=0.28 area=0.063 perim=1.14
MI22 net63 SCE net59 VNB sky130_fd_pr__pfet_01v8_hvt m=1 w=0.64u l=0.15u mult=1
+ sa=0.265 sb=0.265 sd=0.28 area=0.063 perim=1.14
MI21 net116 GATE net63 VNB sky130_fd_pr__pfet_01v8_hvt m=1 w=0.64u l=0.15u mult=1
+ sa=0.265 sb=0.265 sd=0.28 area=0.063 perim=1.14
MI47 clkneg clkpos net59 VNB sky130_fd_pr__pfet_01v8_hvt m=1 w=0.64u l=0.15u mult=1
+ sa=0.265 sb=0.265 sd=0.28 area=0.063 perim=1.14
MI45 clkpos CLK net59 VNB sky130_fd_pr__pfet_01v8_hvt m=1 w=0.64u l=0.15u mult=1
+ sa=0.265 sb=0.265 sd=0.28 area=0.063 perim=1.14
MI660 GCLK net76 net59 VNB sky130_fd_pr__pfet_01v8_hvt m=4 w=1.0u l=0.15u mult=1
+ sa=0.265 sb=0.265 sd=0.28 area=0.063 perim=1.14
MI43 net116 clkneg M0 VNB sky130_fd_pr__pfet_01v8_hvt m=1 w=0.42u l=0.15u mult=1
+ sa=0.265 sb=0.265 sd=0.28 area=0.063 perim=1.14
MI42 net116 clkpos M0 VNB sky130_fd_pr__nfet_01v8 m=1 w=0.36u l=0.15u mult=1 sa=0.265
+ sb=0.265 sd=0.28 area=0.063 perim=1.14
MI20 m1 M0 VGND VNB sky130_fd_pr__nfet_01v8 m=1 w=0.65u l=0.15u mult=1 sa=0.265
+ sb=0.265 sd=0.28 area=0.063 perim=1.14
MI655 M0 clkneg net123 VNB sky130_fd_pr__nfet_01v8 m=1 w=0.36u l=0.15u mult=1 sa=0.265
+ sb=0.265 sd=0.28 area=0.063 perim=1.14
MI654 net123 m1 VGND VNB sky130_fd_pr__nfet_01v8 m=1 w=0.42u l=0.15u mult=1 sa=0.265
+ sb=0.265 sd=0.28 area=0.063 perim=1.14
MI24 net116 SCE VGND VNB sky130_fd_pr__nfet_01v8 m=1 w=0.42u l=0.15u mult=1 sa=0.265
+ sb=0.265 sd=0.28 area=0.063 perim=1.14
MI657 net112 CLK VGND VNB sky130_fd_pr__nfet_01v8 m=1 w=0.65u l=0.15u mult=1 sa=0.265
+ sb=0.265 sd=0.28 area=0.063 perim=1.14
MI656 net76 m1 net112 VNB sky130_fd_pr__nfet_01v8 m=1 w=0.65u l=0.15u mult=1 sa=0.265
+ sb=0.265 sd=0.28 area=0.063 perim=1.14
MI23 net116 GATE VGND VNB sky130_fd_pr__nfet_01v8 m=1 w=0.42u l=0.15u mult=1 sa=0.265
+ sb=0.265 sd=0.28 area=0.063 perim=1.14
MI46 clkneg clkpos VGND VNB sky130_fd_pr__nfet_01v8 m=1 w=0.42u l=0.15u mult=1
+ sa=0.265 sb=0.265 sd=0.28 area=0.063 perim=1.14
MI44 clkpos CLK VGND VNB sky130_fd_pr__nfet_01v8 m=1 w=0.42u l=0.15u mult=1 sa=0.265
+ sb=0.265 sd=0.28 area=0.063 perim=1.14
MI653 GCLK net76 VGND VNB sky130_fd_pr__nfet_01v8 m=4 w=0.65u l=0.15u mult=1 sa=0.265
+ sb=0.265 sd=0.28 area=0.063 perim=1.14
.ENDS sky130_fd_sc_hd__sdlclkp_4
* Copyright 2020 The SkyWater PDK Authors
*
* Licensed under the Apache License, Version 2.0 (the "License");
* you may not use this file except in compliance with the License.
* You may obtain a copy of the License at
*
*     https:  www.apache.org licenses LICENSE-2.0
*
* Unless required by applicable law or agreed to in writing, software
* distributed under the License is distributed on an "AS IS" BASIS,
* WITHOUT WARRANTIES OR CONDITIONS OF ANY KIND, either express or implied.
* See the License for the specific language governing permissions and
* limitations under the License.
*
* SPDX-License-Identifier: Apache-2.0

.SUBCKT sky130_fd_sc_hd__sedfxbp_1 CLK D DE SCD SCE VGND VNB VNB net59 Q Q_N
*.PININFO CLK:I D:I DE:I SCD:I SCE:I VGND:I VNB:I VNB:I net59:I Q:O
*.PININFO Q_N:O
MI14 net155 M1 net59 VNB sky130_fd_pr__pfet_01v8_hvt m=1 w=0.42u l=0.15u mult=1
+ sa=0.265 sb=0.265 sd=0.28 area=0.063 perim=1.14
MI637 clkpos clkneg net59 VNB sky130_fd_pr__pfet_01v8_hvt m=1 w=0.64u l=0.15u mult=1
+ sa=0.265 sb=0.265 sd=0.28 area=0.063 perim=1.14
MI13 S0 clkneg net155 VNB sky130_fd_pr__pfet_01v8_hvt m=1 w=0.42u l=0.15u mult=1
+ sa=0.265 sb=0.265 sd=0.28 area=0.063 perim=1.14
MI651 db clkpos M0 VNB sky130_fd_pr__pfet_01v8_hvt m=1 w=0.42u l=0.15u mult=1 sa=0.265
+ sb=0.265 sd=0.28 area=0.063 perim=1.14
MI645 Q S0 net59 VNB sky130_fd_pr__pfet_01v8_hvt m=1 w=1.0u l=0.15u mult=1 sa=0.265
+ sb=0.265 sd=0.28 area=0.063 perim=1.14
MI658 net123 M1 net59 VNB sky130_fd_pr__pfet_01v8_hvt m=1 w=0.42u l=0.15u mult=1
+ sa=0.265 sb=0.265 sd=0.28 area=0.063 perim=1.14
MI638 clkneg CLK net59 VNB sky130_fd_pr__pfet_01v8_hvt m=1 w=0.64u l=0.15u mult=1
+ sa=0.265 sb=0.265 sd=0.28 area=0.063 perim=1.14
MI643 net127 q1 net59 VNB sky130_fd_pr__pfet_01v8_hvt m=1 w=0.42u l=0.15u mult=1
+ sa=0.265 sb=0.265 sd=0.28 area=0.063 perim=1.14
MI639 M1 M0 net59 VNB sky130_fd_pr__pfet_01v8_hvt m=1 w=0.75u l=0.15u mult=1 sa=0.265
+ sb=0.265 sd=0.28 area=0.063 perim=1.14
MI644 S0 clkpos net127 VNB sky130_fd_pr__pfet_01v8_hvt m=1 w=0.42u l=0.15u mult=1
+ sa=0.265 sb=0.265 sd=0.28 area=0.063 perim=1.14
MI659 M0 clkneg net123 VNB sky130_fd_pr__pfet_01v8_hvt m=1 w=0.42u l=0.15u mult=1
+ sa=0.265 sb=0.265 sd=0.28 area=0.063 perim=1.14
MI17 q1 S0 net59 VNB sky130_fd_pr__pfet_01v8_hvt m=1 w=0.64u l=0.15u mult=1 sa=0.265
+ sb=0.265 sd=0.28 area=0.063 perim=1.14
MI33 net116 deneg net59 VNB sky130_fd_pr__pfet_01v8_hvt m=1 w=0.64u l=0.15u mult=1
+ sa=0.265 sb=0.265 sd=0.28 area=0.063 perim=1.14
MI47 net107 sceneg db VNB sky130_fd_pr__pfet_01v8_hvt m=1 w=0.64u l=0.15u mult=1
+ sa=0.265 sb=0.265 sd=0.28 area=0.063 perim=1.14
MI46 net59 SCD net107 VNB sky130_fd_pr__pfet_01v8_hvt m=1 w=0.64u l=0.15u mult=1
+ sa=0.265 sb=0.265 sd=0.28 area=0.063 perim=1.14
MI31 net104 D net116 VNB sky130_fd_pr__pfet_01v8_hvt m=1 w=0.64u l=0.15u mult=1
+ sa=0.265 sb=0.265 sd=0.28 area=0.063 perim=1.14
MI42 net104 SCE db VNB sky130_fd_pr__pfet_01v8_hvt m=1 w=0.64u l=0.15u mult=1 sa=0.265
+ sb=0.265 sd=0.28 area=0.063 perim=1.14
MI40 net87 q1 net104 VNB sky130_fd_pr__pfet_01v8_hvt m=1 w=0.64u l=0.15u mult=1
+ sa=0.265 sb=0.265 sd=0.28 area=0.063 perim=1.14
MI36 deneg DE net59 VNB sky130_fd_pr__pfet_01v8_hvt m=1 w=0.64u l=0.15u mult=1 sa=0.265
+ sb=0.265 sd=0.28 area=0.063 perim=1.14
MI38 net59 DE net87 VNB sky130_fd_pr__pfet_01v8_hvt m=1 w=0.64u l=0.15u mult=1 sa=0.265
+ sb=0.265 sd=0.28 area=0.063 perim=1.14
MI44 sceneg SCE net59 VNB sky130_fd_pr__pfet_01v8_hvt m=1 w=0.64u l=0.15u mult=1
+ sa=0.265 sb=0.265 sd=0.28 area=0.063 perim=1.14
MI52 Q_N q1 net59 VNB sky130_fd_pr__pfet_01v8_hvt m=1 w=1.0u l=0.15u mult=1 sa=0.265
+ sb=0.265 sd=0.28 area=0.063 perim=1.14
MI634 M1 M0 VGND VNB sky130_fd_pr__nfet_01v8 m=1 w=0.64u l=0.15u mult=1 sa=0.265
+ sb=0.265 sd=0.28 area=0.063 perim=1.14
MI636 clkpos clkneg VGND VNB sky130_fd_pr__nfet_01v8 m=1 w=0.42u l=0.15u mult=1
+ sa=0.265 sb=0.265 sd=0.28 area=0.063 perim=1.14
MI635 clkneg CLK VGND VNB sky130_fd_pr__nfet_01v8 m=1 w=0.42u l=0.15u mult=1 sa=0.265
+ sb=0.265 sd=0.28 area=0.063 perim=1.14
MI641 net235 q1 VGND VNB sky130_fd_pr__nfet_01v8 m=1 w=0.42u l=0.15u mult=1 sa=0.265
+ sb=0.265 sd=0.28 area=0.063 perim=1.14
MI642 S0 clkneg net235 VNB sky130_fd_pr__nfet_01v8 m=1 w=0.36u l=0.15u mult=1 sa=0.265
+ sb=0.265 sd=0.28 area=0.063 perim=1.14
MI648 db clkneg M0 VNB sky130_fd_pr__nfet_01v8 m=1 w=0.36u l=0.15u mult=1 sa=0.265
+ sb=0.265 sd=0.28 area=0.063 perim=1.14
MI646 Q S0 VGND VNB sky130_fd_pr__nfet_01v8 m=1 w=0.65u l=0.15u mult=1 sa=0.265
+ sb=0.265 sd=0.28 area=0.063 perim=1.14
MI656 net224 M1 VGND VNB sky130_fd_pr__nfet_01v8 m=1 w=0.42u l=0.15u mult=1 sa=0.265
+ sb=0.265 sd=0.28 area=0.063 perim=1.14
MI657 M0 clkpos net224 VNB sky130_fd_pr__nfet_01v8 m=1 w=0.36u l=0.15u mult=1 sa=0.265
+ sb=0.265 sd=0.28 area=0.063 perim=1.14
MI43 net104 sceneg db VNB sky130_fd_pr__nfet_01v8 m=1 w=0.42u l=0.15u mult=1 sa=0.265
+ sb=0.265 sd=0.28 area=0.063 perim=1.14
MI18 q1 S0 VGND VNB sky130_fd_pr__nfet_01v8 m=1 w=0.42u l=0.15u mult=1 sa=0.265
+ sb=0.265 sd=0.28 area=0.063 perim=1.14
MI45 sceneg SCE VGND VNB sky130_fd_pr__nfet_01v8 m=1 w=0.42u l=0.15u mult=1 sa=0.265
+ sb=0.265 sd=0.28 area=0.063 perim=1.14
MI32 net104 D net203 VNB sky130_fd_pr__nfet_01v8 m=1 w=0.42u l=0.15u mult=1 sa=0.265
+ sb=0.265 sd=0.28 area=0.063 perim=1.14
MI16 net200 M1 VGND VNB sky130_fd_pr__nfet_01v8 m=1 w=0.42u l=0.15u mult=1 sa=0.265
+ sb=0.265 sd=0.28 area=0.063 perim=1.14
MI15 S0 clkpos net200 VNB sky130_fd_pr__nfet_01v8 m=1 w=0.36u l=0.15u mult=1 sa=0.265
+ sb=0.265 sd=0.28 area=0.063 perim=1.14
MI41 net192 q1 net104 VNB sky130_fd_pr__nfet_01v8 m=1 w=0.42u l=0.15u mult=1 sa=0.265
+ sb=0.265 sd=0.28 area=0.063 perim=1.14
MI39 VGND deneg net192 VNB sky130_fd_pr__nfet_01v8 m=1 w=0.42u l=0.15u mult=1 sa=0.265
+ sb=0.265 sd=0.28 area=0.063 perim=1.14
MI37 deneg DE VGND VNB sky130_fd_pr__nfet_01v8 m=1 w=0.42u l=0.15u mult=1 sa=0.265
+ sb=0.265 sd=0.28 area=0.063 perim=1.14
MI34 net203 DE VGND VNB sky130_fd_pr__nfet_01v8 m=1 w=0.42u l=0.15u mult=1 sa=0.265
+ sb=0.265 sd=0.28 area=0.063 perim=1.14
MI49 net176 SCE db VNB sky130_fd_pr__nfet_01v8 m=1 w=0.42u l=0.15u mult=1 sa=0.265
+ sb=0.265 sd=0.28 area=0.063 perim=1.14
MI48 VGND SCD net176 VNB sky130_fd_pr__nfet_01v8 m=1 w=0.42u l=0.15u mult=1 sa=0.265
+ sb=0.265 sd=0.28 area=0.063 perim=1.14
MI53 Q_N q1 VGND VNB sky130_fd_pr__nfet_01v8 m=1 w=0.65u l=0.15u mult=1 sa=0.265
+ sb=0.265 sd=0.28 area=0.063 perim=1.14
.ENDS sky130_fd_sc_hd__sedfxbp_1
* Copyright 2020 The SkyWater PDK Authors
*
* Licensed under the Apache License, Version 2.0 (the "License");
* you may not use this file except in compliance with the License.
* You may obtain a copy of the License at
*
*     https:  www.apache.org licenses LICENSE-2.0
*
* Unless required by applicable law or agreed to in writing, software
* distributed under the License is distributed on an "AS IS" BASIS,
* WITHOUT WARRANTIES OR CONDITIONS OF ANY KIND, either express or implied.
* See the License for the specific language governing permissions and
* limitations under the License.
*
* SPDX-License-Identifier: Apache-2.0

.SUBCKT sky130_fd_sc_hd__sedfxbp_2 CLK D DE SCD SCE VGND VNB VNB net59 Q Q_N
*.PININFO CLK:I D:I DE:I SCD:I SCE:I VGND:I VNB:I VNB:I net59:I Q:O
*.PININFO Q_N:O
MI14 net155 M1 net59 VNB sky130_fd_pr__pfet_01v8_hvt m=1 w=0.42u l=0.15u mult=1
+ sa=0.265 sb=0.265 sd=0.28 area=0.063 perim=1.14
MI637 clkpos clkneg net59 VNB sky130_fd_pr__pfet_01v8_hvt m=1 w=0.64u l=0.15u mult=1
+ sa=0.265 sb=0.265 sd=0.28 area=0.063 perim=1.14
MI13 S0 clkneg net155 VNB sky130_fd_pr__pfet_01v8_hvt m=1 w=0.42u l=0.15u mult=1
+ sa=0.265 sb=0.265 sd=0.28 area=0.063 perim=1.14
MI651 db clkpos M0 VNB sky130_fd_pr__pfet_01v8_hvt m=1 w=0.42u l=0.15u mult=1 sa=0.265
+ sb=0.265 sd=0.28 area=0.063 perim=1.14
MI645 Q S0 net59 VNB sky130_fd_pr__pfet_01v8_hvt m=2 w=1.0u l=0.15u mult=1 sa=0.265
+ sb=0.265 sd=0.28 area=0.063 perim=1.14
MI658 net144 M1 net59 VNB sky130_fd_pr__pfet_01v8_hvt m=1 w=0.42u l=0.15u mult=1
+ sa=0.265 sb=0.265 sd=0.28 area=0.063 perim=1.14
MI638 clkneg CLK net59 VNB sky130_fd_pr__pfet_01v8_hvt m=1 w=0.64u l=0.15u mult=1
+ sa=0.265 sb=0.265 sd=0.28 area=0.063 perim=1.14
MI643 net127 q1 net59 VNB sky130_fd_pr__pfet_01v8_hvt m=1 w=0.42u l=0.15u mult=1
+ sa=0.265 sb=0.265 sd=0.28 area=0.063 perim=1.14
MI639 M1 M0 net59 VNB sky130_fd_pr__pfet_01v8_hvt m=1 w=0.75u l=0.15u mult=1 sa=0.265
+ sb=0.265 sd=0.28 area=0.063 perim=1.14
MI644 S0 clkpos net127 VNB sky130_fd_pr__pfet_01v8_hvt m=1 w=0.42u l=0.15u mult=1
+ sa=0.265 sb=0.265 sd=0.28 area=0.063 perim=1.14
MI659 M0 clkneg net144 VNB sky130_fd_pr__pfet_01v8_hvt m=1 w=0.42u l=0.15u mult=1
+ sa=0.265 sb=0.265 sd=0.28 area=0.063 perim=1.14
MI17 q1 S0 net59 VNB sky130_fd_pr__pfet_01v8_hvt m=1 w=0.64u l=0.15u mult=1 sa=0.265
+ sb=0.265 sd=0.28 area=0.063 perim=1.14
MI33 net116 deneg net59 VNB sky130_fd_pr__pfet_01v8_hvt m=1 w=0.64u l=0.15u mult=1
+ sa=0.265 sb=0.265 sd=0.28 area=0.063 perim=1.14
MI47 net107 sceneg db VNB sky130_fd_pr__pfet_01v8_hvt m=1 w=0.64u l=0.15u mult=1
+ sa=0.265 sb=0.265 sd=0.28 area=0.063 perim=1.14
MI46 net59 SCD net107 VNB sky130_fd_pr__pfet_01v8_hvt m=1 w=0.64u l=0.15u mult=1
+ sa=0.265 sb=0.265 sd=0.28 area=0.063 perim=1.14
MI31 net104 D net116 VNB sky130_fd_pr__pfet_01v8_hvt m=1 w=0.64u l=0.15u mult=1
+ sa=0.265 sb=0.265 sd=0.28 area=0.063 perim=1.14
MI42 net104 SCE db VNB sky130_fd_pr__pfet_01v8_hvt m=1 w=0.64u l=0.15u mult=1 sa=0.265
+ sb=0.265 sd=0.28 area=0.063 perim=1.14
MI40 net87 q1 net104 VNB sky130_fd_pr__pfet_01v8_hvt m=1 w=0.64u l=0.15u mult=1
+ sa=0.265 sb=0.265 sd=0.28 area=0.063 perim=1.14
MI36 deneg DE net59 VNB sky130_fd_pr__pfet_01v8_hvt m=1 w=0.64u l=0.15u mult=1 sa=0.265
+ sb=0.265 sd=0.28 area=0.063 perim=1.14
MI38 net59 DE net87 VNB sky130_fd_pr__pfet_01v8_hvt m=1 w=0.64u l=0.15u mult=1 sa=0.265
+ sb=0.265 sd=0.28 area=0.063 perim=1.14
MI44 sceneg SCE net59 VNB sky130_fd_pr__pfet_01v8_hvt m=1 w=0.64u l=0.15u mult=1
+ sa=0.265 sb=0.265 sd=0.28 area=0.063 perim=1.14
MI52 Q_N q1 net59 VNB sky130_fd_pr__pfet_01v8_hvt m=2 w=1.0u l=0.15u mult=1 sa=0.265
+ sb=0.265 sd=0.28 area=0.063 perim=1.14
MI634 M1 M0 VGND VNB sky130_fd_pr__nfet_01v8 m=1 w=0.64u l=0.15u mult=1 sa=0.265
+ sb=0.265 sd=0.28 area=0.063 perim=1.14
MI636 clkpos clkneg VGND VNB sky130_fd_pr__nfet_01v8 m=1 w=0.42u l=0.15u mult=1
+ sa=0.265 sb=0.265 sd=0.28 area=0.063 perim=1.14
MI635 clkneg CLK VGND VNB sky130_fd_pr__nfet_01v8 m=1 w=0.42u l=0.15u mult=1 sa=0.265
+ sb=0.265 sd=0.28 area=0.063 perim=1.14
MI641 net240 q1 VGND VNB sky130_fd_pr__nfet_01v8 m=1 w=0.42u l=0.15u mult=1 sa=0.265
+ sb=0.265 sd=0.28 area=0.063 perim=1.14
MI642 S0 clkneg net240 VNB sky130_fd_pr__nfet_01v8 m=1 w=0.36u l=0.15u mult=1 sa=0.265
+ sb=0.265 sd=0.28 area=0.063 perim=1.14
MI648 db clkneg M0 VNB sky130_fd_pr__nfet_01v8 m=1 w=0.36u l=0.15u mult=1 sa=0.265
+ sb=0.265 sd=0.28 area=0.063 perim=1.14
MI646 Q S0 VGND VNB sky130_fd_pr__nfet_01v8 m=2 w=0.65u l=0.15u mult=1 sa=0.265
+ sb=0.265 sd=0.28 area=0.063 perim=1.14
MI656 net224 M1 VGND VNB sky130_fd_pr__nfet_01v8 m=1 w=0.42u l=0.15u mult=1 sa=0.265
+ sb=0.265 sd=0.28 area=0.063 perim=1.14
MI657 M0 clkpos net224 VNB sky130_fd_pr__nfet_01v8 m=1 w=0.36u l=0.15u mult=1 sa=0.265
+ sb=0.265 sd=0.28 area=0.063 perim=1.14
MI43 net104 sceneg db VNB sky130_fd_pr__nfet_01v8 m=1 w=0.42u l=0.15u mult=1 sa=0.265
+ sb=0.265 sd=0.28 area=0.063 perim=1.14
MI18 q1 S0 VGND VNB sky130_fd_pr__nfet_01v8 m=1 w=0.42u l=0.15u mult=1 sa=0.265
+ sb=0.265 sd=0.28 area=0.063 perim=1.14
MI45 sceneg SCE VGND VNB sky130_fd_pr__nfet_01v8 m=1 w=0.42u l=0.15u mult=1 sa=0.265
+ sb=0.265 sd=0.28 area=0.063 perim=1.14
MI32 net104 D net180 VNB sky130_fd_pr__nfet_01v8 m=1 w=0.42u l=0.15u mult=1 sa=0.265
+ sb=0.265 sd=0.28 area=0.063 perim=1.14
MI16 net200 M1 VGND VNB sky130_fd_pr__nfet_01v8 m=1 w=0.42u l=0.15u mult=1 sa=0.265
+ sb=0.265 sd=0.28 area=0.063 perim=1.14
MI15 S0 clkpos net200 VNB sky130_fd_pr__nfet_01v8 m=1 w=0.36u l=0.15u mult=1 sa=0.265
+ sb=0.265 sd=0.28 area=0.063 perim=1.14
MI41 net192 q1 net104 VNB sky130_fd_pr__nfet_01v8 m=1 w=0.42u l=0.15u mult=1 sa=0.265
+ sb=0.265 sd=0.28 area=0.063 perim=1.14
MI39 VGND deneg net192 VNB sky130_fd_pr__nfet_01v8 m=1 w=0.42u l=0.15u mult=1 sa=0.265
+ sb=0.265 sd=0.28 area=0.063 perim=1.14
MI37 deneg DE VGND VNB sky130_fd_pr__nfet_01v8 m=1 w=0.42u l=0.15u mult=1 sa=0.265
+ sb=0.265 sd=0.28 area=0.063 perim=1.14
MI34 net180 DE VGND VNB sky130_fd_pr__nfet_01v8 m=1 w=0.42u l=0.15u mult=1 sa=0.265
+ sb=0.265 sd=0.28 area=0.063 perim=1.14
MI49 net176 SCE db VNB sky130_fd_pr__nfet_01v8 m=1 w=0.42u l=0.15u mult=1 sa=0.265
+ sb=0.265 sd=0.28 area=0.063 perim=1.14
MI48 VGND SCD net176 VNB sky130_fd_pr__nfet_01v8 m=1 w=0.42u l=0.15u mult=1 sa=0.265
+ sb=0.265 sd=0.28 area=0.063 perim=1.14
MI53 Q_N q1 VGND VNB sky130_fd_pr__nfet_01v8 m=2 w=0.65u l=0.15u mult=1 sa=0.265
+ sb=0.265 sd=0.28 area=0.063 perim=1.14
.ENDS sky130_fd_sc_hd__sedfxbp_2
* Copyright 2020 The SkyWater PDK Authors
*
* Licensed under the Apache License, Version 2.0 (the "License");
* you may not use this file except in compliance with the License.
* You may obtain a copy of the License at
*
*     https:  www.apache.org licenses LICENSE-2.0
*
* Unless required by applicable law or agreed to in writing, software
* distributed under the License is distributed on an "AS IS" BASIS,
* WITHOUT WARRANTIES OR CONDITIONS OF ANY KIND, either express or implied.
* See the License for the specific language governing permissions and
* limitations under the License.
*
* SPDX-License-Identifier: Apache-2.0

.SUBCKT sky130_fd_sc_hd__sedfxtp_1 CLK D DE SCD SCE VGND VNB VNB net59 Q
*.PININFO CLK:I D:I DE:I SCD:I SCE:I VGND:I VNB:I VNB:I net59:I Q:O
MI14 net146 M1 net59 VNB sky130_fd_pr__pfet_01v8_hvt m=1 w=0.42u l=0.15u mult=1
+ sa=0.265 sb=0.265 sd=0.28 area=0.063 perim=1.14
MI637 clkpos clkneg net59 VNB sky130_fd_pr__pfet_01v8_hvt m=1 w=0.64u l=0.15u mult=1
+ sa=0.265 sb=0.265 sd=0.28 area=0.063 perim=1.14
MI13 S0 clkneg net146 VNB sky130_fd_pr__pfet_01v8_hvt m=1 w=0.42u l=0.15u mult=1
+ sa=0.265 sb=0.265 sd=0.28 area=0.063 perim=1.14
MI651 db clkpos M0 VNB sky130_fd_pr__pfet_01v8_hvt m=1 w=0.42u l=0.15u mult=1 sa=0.265
+ sb=0.265 sd=0.28 area=0.063 perim=1.14
MI645 Q S0 net59 VNB sky130_fd_pr__pfet_01v8_hvt m=1 w=1.0u l=0.15u mult=1 sa=0.265
+ sb=0.265 sd=0.28 area=0.063 perim=1.14
MI658 net114 M1 net59 VNB sky130_fd_pr__pfet_01v8_hvt m=1 w=0.42u l=0.15u mult=1
+ sa=0.265 sb=0.265 sd=0.28 area=0.063 perim=1.14
MI638 clkneg CLK net59 VNB sky130_fd_pr__pfet_01v8_hvt m=1 w=0.64u l=0.15u mult=1
+ sa=0.265 sb=0.265 sd=0.28 area=0.063 perim=1.14
MI643 net118 q1 net59 VNB sky130_fd_pr__pfet_01v8_hvt m=1 w=0.42u l=0.15u mult=1
+ sa=0.265 sb=0.265 sd=0.28 area=0.063 perim=1.14
MI639 M1 M0 net59 VNB sky130_fd_pr__pfet_01v8_hvt m=1 w=0.75u l=0.15u mult=1 sa=0.265
+ sb=0.265 sd=0.28 area=0.063 perim=1.14
MI644 S0 clkpos net118 VNB sky130_fd_pr__pfet_01v8_hvt m=1 w=0.42u l=0.15u mult=1
+ sa=0.265 sb=0.265 sd=0.28 area=0.063 perim=1.14
MI659 M0 clkneg net114 VNB sky130_fd_pr__pfet_01v8_hvt m=1 w=0.42u l=0.15u mult=1
+ sa=0.265 sb=0.265 sd=0.28 area=0.063 perim=1.14
MI17 q1 S0 net59 VNB sky130_fd_pr__pfet_01v8_hvt m=1 w=0.64u l=0.15u mult=1 sa=0.265
+ sb=0.265 sd=0.28 area=0.063 perim=1.14
MI33 net94 deneg net59 VNB sky130_fd_pr__pfet_01v8_hvt m=1 w=0.64u l=0.15u mult=1
+ sa=0.265 sb=0.265 sd=0.28 area=0.063 perim=1.14
MI47 net103 sceneg db VNB sky130_fd_pr__pfet_01v8_hvt m=1 w=0.64u l=0.15u mult=1
+ sa=0.265 sb=0.265 sd=0.28 area=0.063 perim=1.14
MI46 net59 SCD net103 VNB sky130_fd_pr__pfet_01v8_hvt m=1 w=0.64u l=0.15u mult=1
+ sa=0.265 sb=0.265 sd=0.28 area=0.063 perim=1.14
MI31 net95 D net94 VNB sky130_fd_pr__pfet_01v8_hvt m=1 w=0.64u l=0.15u mult=1 sa=0.265
+ sb=0.265 sd=0.28 area=0.063 perim=1.14
MI42 net95 SCE db VNB sky130_fd_pr__pfet_01v8_hvt m=1 w=0.64u l=0.15u mult=1 sa=0.265
+ sb=0.265 sd=0.28 area=0.063 perim=1.14
MI40 net87 q1 net95 VNB sky130_fd_pr__pfet_01v8_hvt m=1 w=0.64u l=0.15u mult=1
+ sa=0.265 sb=0.265 sd=0.28 area=0.063 perim=1.14
MI36 deneg DE net59 VNB sky130_fd_pr__pfet_01v8_hvt m=1 w=0.64u l=0.15u mult=1 sa=0.265
+ sb=0.265 sd=0.28 area=0.063 perim=1.14
MI38 net59 DE net87 VNB sky130_fd_pr__pfet_01v8_hvt m=1 w=0.64u l=0.15u mult=1 sa=0.265
+ sb=0.265 sd=0.28 area=0.063 perim=1.14
MI44 sceneg SCE net59 VNB sky130_fd_pr__pfet_01v8_hvt m=1 w=0.64u l=0.15u mult=1
+ sa=0.265 sb=0.265 sd=0.28 area=0.063 perim=1.14
MI634 M1 M0 VGND VNB sky130_fd_pr__nfet_01v8 m=1 w=0.64u l=0.15u mult=1 sa=0.265
+ sb=0.265 sd=0.28 area=0.063 perim=1.14
MI636 clkpos clkneg VGND VNB sky130_fd_pr__nfet_01v8 m=1 w=0.42u l=0.15u mult=1
+ sa=0.265 sb=0.265 sd=0.28 area=0.063 perim=1.14
MI635 clkneg CLK VGND VNB sky130_fd_pr__nfet_01v8 m=1 w=0.42u l=0.15u mult=1 sa=0.265
+ sb=0.265 sd=0.28 area=0.063 perim=1.14
MI641 net222 q1 VGND VNB sky130_fd_pr__nfet_01v8 m=1 w=0.42u l=0.15u mult=1 sa=0.265
+ sb=0.265 sd=0.28 area=0.063 perim=1.14
MI642 S0 clkneg net222 VNB sky130_fd_pr__nfet_01v8 m=1 w=0.36u l=0.15u mult=1 sa=0.265
+ sb=0.265 sd=0.28 area=0.063 perim=1.14
MI648 db clkneg M0 VNB sky130_fd_pr__nfet_01v8 m=1 w=0.36u l=0.15u mult=1 sa=0.265
+ sb=0.265 sd=0.28 area=0.063 perim=1.14
MI646 Q S0 VGND VNB sky130_fd_pr__nfet_01v8 m=1 w=0.65u l=0.15u mult=1 sa=0.265
+ sb=0.265 sd=0.28 area=0.063 perim=1.14
MI656 net211 M1 VGND VNB sky130_fd_pr__nfet_01v8 m=1 w=0.42u l=0.15u mult=1 sa=0.265
+ sb=0.265 sd=0.28 area=0.063 perim=1.14
MI657 M0 clkpos net211 VNB sky130_fd_pr__nfet_01v8 m=1 w=0.36u l=0.15u mult=1 sa=0.265
+ sb=0.265 sd=0.28 area=0.063 perim=1.14
MI43 net95 sceneg db VNB sky130_fd_pr__nfet_01v8 m=1 w=0.42u l=0.15u mult=1 sa=0.265
+ sb=0.265 sd=0.28 area=0.063 perim=1.14
MI18 q1 S0 VGND VNB sky130_fd_pr__nfet_01v8 m=1 w=0.42u l=0.15u mult=1 sa=0.265
+ sb=0.265 sd=0.28 area=0.063 perim=1.14
MI45 sceneg SCE VGND VNB sky130_fd_pr__nfet_01v8 m=1 w=0.42u l=0.15u mult=1 sa=0.265
+ sb=0.265 sd=0.28 area=0.063 perim=1.14
MI32 net95 D net167 VNB sky130_fd_pr__nfet_01v8 m=1 w=0.42u l=0.15u mult=1 sa=0.265
+ sb=0.265 sd=0.28 area=0.063 perim=1.14
MI16 net187 M1 VGND VNB sky130_fd_pr__nfet_01v8 m=1 w=0.42u l=0.15u mult=1 sa=0.265
+ sb=0.265 sd=0.28 area=0.063 perim=1.14
MI15 S0 clkpos net187 VNB sky130_fd_pr__nfet_01v8 m=1 w=0.36u l=0.15u mult=1 sa=0.265
+ sb=0.265 sd=0.28 area=0.063 perim=1.14
MI41 net179 q1 net95 VNB sky130_fd_pr__nfet_01v8 m=1 w=0.42u l=0.15u mult=1 sa=0.265
+ sb=0.265 sd=0.28 area=0.063 perim=1.14
MI39 VGND deneg net179 VNB sky130_fd_pr__nfet_01v8 m=1 w=0.42u l=0.15u mult=1 sa=0.265
+ sb=0.265 sd=0.28 area=0.063 perim=1.14
MI37 deneg DE VGND VNB sky130_fd_pr__nfet_01v8 m=1 w=0.42u l=0.15u mult=1 sa=0.265
+ sb=0.265 sd=0.28 area=0.063 perim=1.14
MI34 net167 DE VGND VNB sky130_fd_pr__nfet_01v8 m=1 w=0.42u l=0.15u mult=1 sa=0.265
+ sb=0.265 sd=0.28 area=0.063 perim=1.14
MI49 net158 SCE db VNB sky130_fd_pr__nfet_01v8 m=1 w=0.42u l=0.15u mult=1 sa=0.265
+ sb=0.265 sd=0.28 area=0.063 perim=1.14
MI48 VGND SCD net158 VNB sky130_fd_pr__nfet_01v8 m=1 w=0.42u l=0.15u mult=1 sa=0.265
+ sb=0.265 sd=0.28 area=0.063 perim=1.14
.ENDS sky130_fd_sc_hd__sedfxtp_1
* Copyright 2020 The SkyWater PDK Authors
*
* Licensed under the Apache License, Version 2.0 (the "License");
* you may not use this file except in compliance with the License.
* You may obtain a copy of the License at
*
*     https:  www.apache.org licenses LICENSE-2.0
*
* Unless required by applicable law or agreed to in writing, software
* distributed under the License is distributed on an "AS IS" BASIS,
* WITHOUT WARRANTIES OR CONDITIONS OF ANY KIND, either express or implied.
* See the License for the specific language governing permissions and
* limitations under the License.
*
* SPDX-License-Identifier: Apache-2.0

.SUBCKT sky130_fd_sc_hd__sedfxtp_2 CLK D DE SCD SCE VGND VNB VNB net59 Q
*.PININFO CLK:I D:I DE:I SCD:I SCE:I VGND:I VNB:I VNB:I net59:I Q:O
MI14 net146 M1 net59 VNB sky130_fd_pr__pfet_01v8_hvt m=1 w=0.42u l=0.15u mult=1
+ sa=0.265 sb=0.265 sd=0.28 area=0.063 perim=1.14
MI637 clkpos clkneg net59 VNB sky130_fd_pr__pfet_01v8_hvt m=1 w=0.64u l=0.15u mult=1
+ sa=0.265 sb=0.265 sd=0.28 area=0.063 perim=1.14
MI13 S0 clkneg net146 VNB sky130_fd_pr__pfet_01v8_hvt m=1 w=0.42u l=0.15u mult=1
+ sa=0.265 sb=0.265 sd=0.28 area=0.063 perim=1.14
MI651 db clkpos M0 VNB sky130_fd_pr__pfet_01v8_hvt m=1 w=0.42u l=0.15u mult=1 sa=0.265
+ sb=0.265 sd=0.28 area=0.063 perim=1.14
MI645 Q S0 net59 VNB sky130_fd_pr__pfet_01v8_hvt m=2 w=1.0u l=0.15u mult=1 sa=0.265
+ sb=0.265 sd=0.28 area=0.063 perim=1.14
MI658 net114 M1 net59 VNB sky130_fd_pr__pfet_01v8_hvt m=1 w=0.42u l=0.15u mult=1
+ sa=0.265 sb=0.265 sd=0.28 area=0.063 perim=1.14
MI638 clkneg CLK net59 VNB sky130_fd_pr__pfet_01v8_hvt m=1 w=0.64u l=0.15u mult=1
+ sa=0.265 sb=0.265 sd=0.28 area=0.063 perim=1.14
MI643 net118 q1 net59 VNB sky130_fd_pr__pfet_01v8_hvt m=1 w=0.42u l=0.15u mult=1
+ sa=0.265 sb=0.265 sd=0.28 area=0.063 perim=1.14
MI639 M1 M0 net59 VNB sky130_fd_pr__pfet_01v8_hvt m=1 w=0.75u l=0.15u mult=1 sa=0.265
+ sb=0.265 sd=0.28 area=0.063 perim=1.14
MI644 S0 clkpos net118 VNB sky130_fd_pr__pfet_01v8_hvt m=1 w=0.42u l=0.15u mult=1
+ sa=0.265 sb=0.265 sd=0.28 area=0.063 perim=1.14
MI659 M0 clkneg net114 VNB sky130_fd_pr__pfet_01v8_hvt m=1 w=0.42u l=0.15u mult=1
+ sa=0.265 sb=0.265 sd=0.28 area=0.063 perim=1.14
MI17 q1 S0 net59 VNB sky130_fd_pr__pfet_01v8_hvt m=1 w=0.64u l=0.15u mult=1 sa=0.265
+ sb=0.265 sd=0.28 area=0.063 perim=1.14
MI33 net94 deneg net59 VNB sky130_fd_pr__pfet_01v8_hvt m=1 w=0.64u l=0.15u mult=1
+ sa=0.265 sb=0.265 sd=0.28 area=0.063 perim=1.14
MI47 net98 sceneg db VNB sky130_fd_pr__pfet_01v8_hvt m=1 w=0.64u l=0.15u mult=1
+ sa=0.265 sb=0.265 sd=0.28 area=0.063 perim=1.14
MI46 net59 SCD net98 VNB sky130_fd_pr__pfet_01v8_hvt m=1 w=0.64u l=0.15u mult=1
+ sa=0.265 sb=0.265 sd=0.28 area=0.063 perim=1.14
MI31 net95 D net94 VNB sky130_fd_pr__pfet_01v8_hvt m=1 w=0.64u l=0.15u mult=1 sa=0.265
+ sb=0.265 sd=0.28 area=0.063 perim=1.14
MI42 net95 SCE db VNB sky130_fd_pr__pfet_01v8_hvt m=1 w=0.64u l=0.15u mult=1 sa=0.265
+ sb=0.265 sd=0.28 area=0.063 perim=1.14
MI40 net87 q1 net95 VNB sky130_fd_pr__pfet_01v8_hvt m=1 w=0.64u l=0.15u mult=1
+ sa=0.265 sb=0.265 sd=0.28 area=0.063 perim=1.14
MI36 deneg DE net59 VNB sky130_fd_pr__pfet_01v8_hvt m=1 w=0.64u l=0.15u mult=1 sa=0.265
+ sb=0.265 sd=0.28 area=0.063 perim=1.14
MI38 net59 DE net87 VNB sky130_fd_pr__pfet_01v8_hvt m=1 w=0.64u l=0.15u mult=1 sa=0.265
+ sb=0.265 sd=0.28 area=0.063 perim=1.14
MI44 sceneg SCE net59 VNB sky130_fd_pr__pfet_01v8_hvt m=1 w=0.64u l=0.15u mult=1
+ sa=0.265 sb=0.265 sd=0.28 area=0.063 perim=1.14
MI634 M1 M0 VGND VNB sky130_fd_pr__nfet_01v8 m=1 w=0.64u l=0.15u mult=1 sa=0.265
+ sb=0.265 sd=0.28 area=0.063 perim=1.14
MI636 clkpos clkneg VGND VNB sky130_fd_pr__nfet_01v8 m=1 w=0.42u l=0.15u mult=1
+ sa=0.265 sb=0.265 sd=0.28 area=0.063 perim=1.14
MI635 clkneg CLK VGND VNB sky130_fd_pr__nfet_01v8 m=1 w=0.42u l=0.15u mult=1 sa=0.265
+ sb=0.265 sd=0.28 area=0.063 perim=1.14
MI641 net222 q1 VGND VNB sky130_fd_pr__nfet_01v8 m=1 w=0.42u l=0.15u mult=1 sa=0.265
+ sb=0.265 sd=0.28 area=0.063 perim=1.14
MI642 S0 clkneg net222 VNB sky130_fd_pr__nfet_01v8 m=1 w=0.36u l=0.15u mult=1 sa=0.265
+ sb=0.265 sd=0.28 area=0.063 perim=1.14
MI648 db clkneg M0 VNB sky130_fd_pr__nfet_01v8 m=1 w=0.36u l=0.15u mult=1 sa=0.265
+ sb=0.265 sd=0.28 area=0.063 perim=1.14
MI646 Q S0 VGND VNB sky130_fd_pr__nfet_01v8 m=2 w=0.65u l=0.15u mult=1 sa=0.265
+ sb=0.265 sd=0.28 area=0.063 perim=1.14
MI656 net211 M1 VGND VNB sky130_fd_pr__nfet_01v8 m=1 w=0.42u l=0.15u mult=1 sa=0.265
+ sb=0.265 sd=0.28 area=0.063 perim=1.14
MI657 M0 clkpos net211 VNB sky130_fd_pr__nfet_01v8 m=1 w=0.36u l=0.15u mult=1 sa=0.265
+ sb=0.265 sd=0.28 area=0.063 perim=1.14
MI43 net95 sceneg db VNB sky130_fd_pr__nfet_01v8 m=1 w=0.42u l=0.15u mult=1 sa=0.265
+ sb=0.265 sd=0.28 area=0.063 perim=1.14
MI18 q1 S0 VGND VNB sky130_fd_pr__nfet_01v8 m=1 w=0.42u l=0.15u mult=1 sa=0.265
+ sb=0.265 sd=0.28 area=0.063 perim=1.14
MI45 sceneg SCE VGND VNB sky130_fd_pr__nfet_01v8 m=1 w=0.42u l=0.15u mult=1 sa=0.265
+ sb=0.265 sd=0.28 area=0.063 perim=1.14
MI32 net95 D net167 VNB sky130_fd_pr__nfet_01v8 m=1 w=0.42u l=0.15u mult=1 sa=0.265
+ sb=0.265 sd=0.28 area=0.063 perim=1.14
MI16 net187 M1 VGND VNB sky130_fd_pr__nfet_01v8 m=1 w=0.42u l=0.15u mult=1 sa=0.265
+ sb=0.265 sd=0.28 area=0.063 perim=1.14
MI15 S0 clkpos net187 VNB sky130_fd_pr__nfet_01v8 m=1 w=0.36u l=0.15u mult=1 sa=0.265
+ sb=0.265 sd=0.28 area=0.063 perim=1.14
MI41 net174 q1 net95 VNB sky130_fd_pr__nfet_01v8 m=1 w=0.42u l=0.15u mult=1 sa=0.265
+ sb=0.265 sd=0.28 area=0.063 perim=1.14
MI39 VGND deneg net174 VNB sky130_fd_pr__nfet_01v8 m=1 w=0.42u l=0.15u mult=1 sa=0.265
+ sb=0.265 sd=0.28 area=0.063 perim=1.14
MI37 deneg DE VGND VNB sky130_fd_pr__nfet_01v8 m=1 w=0.42u l=0.15u mult=1 sa=0.265
+ sb=0.265 sd=0.28 area=0.063 perim=1.14
MI34 net167 DE VGND VNB sky130_fd_pr__nfet_01v8 m=1 w=0.42u l=0.15u mult=1 sa=0.265
+ sb=0.265 sd=0.28 area=0.063 perim=1.14
MI49 net158 SCE db VNB sky130_fd_pr__nfet_01v8 m=1 w=0.42u l=0.15u mult=1 sa=0.265
+ sb=0.265 sd=0.28 area=0.063 perim=1.14
MI48 VGND SCD net158 VNB sky130_fd_pr__nfet_01v8 m=1 w=0.42u l=0.15u mult=1 sa=0.265
+ sb=0.265 sd=0.28 area=0.063 perim=1.14
.ENDS sky130_fd_sc_hd__sedfxtp_2
* Copyright 2020 The SkyWater PDK Authors
*
* Licensed under the Apache License, Version 2.0 (the "License");
* you may not use this file except in compliance with the License.
* You may obtain a copy of the License at
*
*     https:  www.apache.org licenses LICENSE-2.0
*
* Unless required by applicable law or agreed to in writing, software
* distributed under the License is distributed on an "AS IS" BASIS,
* WITHOUT WARRANTIES OR CONDITIONS OF ANY KIND, either express or implied.
* See the License for the specific language governing permissions and
* limitations under the License.
*
* SPDX-License-Identifier: Apache-2.0

.SUBCKT sky130_fd_sc_hd__sedfxtp_4 CLK D DE SCD SCE VGND VNB VNB net59 Q
*.PININFO CLK:I D:I DE:I SCD:I SCE:I VGND:I VNB:I VNB:I net59:I Q:O
MI14 net146 M1 net59 VNB sky130_fd_pr__pfet_01v8_hvt m=1 w=0.42u l=0.15u mult=1
+ sa=0.265 sb=0.265 sd=0.28 area=0.063 perim=1.14
MI637 clkpos clkneg net59 VNB sky130_fd_pr__pfet_01v8_hvt m=1 w=0.64u l=0.15u mult=1
+ sa=0.265 sb=0.265 sd=0.28 area=0.063 perim=1.14
MI13 S0 clkneg net146 VNB sky130_fd_pr__pfet_01v8_hvt m=1 w=0.42u l=0.15u mult=1
+ sa=0.265 sb=0.265 sd=0.28 area=0.063 perim=1.14
MI651 db clkpos M0 VNB sky130_fd_pr__pfet_01v8_hvt m=1 w=0.42u l=0.15u mult=1 sa=0.265
+ sb=0.265 sd=0.28 area=0.063 perim=1.14
MI645 Q S0 net59 VNB sky130_fd_pr__pfet_01v8_hvt m=4 w=1.0u l=0.15u mult=1 sa=0.265
+ sb=0.265 sd=0.28 area=0.063 perim=1.14
MI658 net135 M1 net59 VNB sky130_fd_pr__pfet_01v8_hvt m=1 w=0.42u l=0.15u mult=1
+ sa=0.265 sb=0.265 sd=0.28 area=0.063 perim=1.14
MI638 clkneg CLK net59 VNB sky130_fd_pr__pfet_01v8_hvt m=1 w=0.64u l=0.15u mult=1
+ sa=0.265 sb=0.265 sd=0.28 area=0.063 perim=1.14
MI643 net118 q1 net59 VNB sky130_fd_pr__pfet_01v8_hvt m=1 w=0.42u l=0.15u mult=1
+ sa=0.265 sb=0.265 sd=0.28 area=0.063 perim=1.14
MI639 M1 M0 net59 VNB sky130_fd_pr__pfet_01v8_hvt m=1 w=0.75u l=0.15u mult=1 sa=0.265
+ sb=0.265 sd=0.28 area=0.063 perim=1.14
MI644 S0 clkpos net118 VNB sky130_fd_pr__pfet_01v8_hvt m=1 w=0.42u l=0.15u mult=1
+ sa=0.265 sb=0.265 sd=0.28 area=0.063 perim=1.14
MI659 M0 clkneg net135 VNB sky130_fd_pr__pfet_01v8_hvt m=1 w=0.42u l=0.15u mult=1
+ sa=0.265 sb=0.265 sd=0.28 area=0.063 perim=1.14
MI17 q1 S0 net59 VNB sky130_fd_pr__pfet_01v8_hvt m=1 w=0.64u l=0.15u mult=1 sa=0.265
+ sb=0.265 sd=0.28 area=0.063 perim=1.14
MI33 net107 deneg net59 VNB sky130_fd_pr__pfet_01v8_hvt m=1 w=0.64u l=0.15u mult=1
+ sa=0.265 sb=0.265 sd=0.28 area=0.063 perim=1.14
MI47 net98 sceneg db VNB sky130_fd_pr__pfet_01v8_hvt m=1 w=0.64u l=0.15u mult=1
+ sa=0.265 sb=0.265 sd=0.28 area=0.063 perim=1.14
MI46 net59 SCD net98 VNB sky130_fd_pr__pfet_01v8_hvt m=1 w=0.64u l=0.15u mult=1
+ sa=0.265 sb=0.265 sd=0.28 area=0.063 perim=1.14
MI31 net95 D net107 VNB sky130_fd_pr__pfet_01v8_hvt m=1 w=0.64u l=0.15u mult=1
+ sa=0.265 sb=0.265 sd=0.28 area=0.063 perim=1.14
MI42 net95 SCE db VNB sky130_fd_pr__pfet_01v8_hvt m=1 w=0.64u l=0.15u mult=1 sa=0.265
+ sb=0.265 sd=0.28 area=0.063 perim=1.14
MI40 net87 q1 net95 VNB sky130_fd_pr__pfet_01v8_hvt m=1 w=0.64u l=0.15u mult=1
+ sa=0.265 sb=0.265 sd=0.28 area=0.063 perim=1.14
MI36 deneg DE net59 VNB sky130_fd_pr__pfet_01v8_hvt m=1 w=0.64u l=0.15u mult=1 sa=0.265
+ sb=0.265 sd=0.28 area=0.063 perim=1.14
MI38 net59 DE net87 VNB sky130_fd_pr__pfet_01v8_hvt m=1 w=0.64u l=0.15u mult=1 sa=0.265
+ sb=0.265 sd=0.28 area=0.063 perim=1.14
MI44 sceneg SCE net59 VNB sky130_fd_pr__pfet_01v8_hvt m=1 w=0.64u l=0.15u mult=1
+ sa=0.265 sb=0.265 sd=0.28 area=0.063 perim=1.14
MI634 M1 M0 VGND VNB sky130_fd_pr__nfet_01v8 m=1 w=0.64u l=0.15u mult=1 sa=0.265
+ sb=0.265 sd=0.28 area=0.063 perim=1.14
MI636 clkpos clkneg VGND VNB sky130_fd_pr__nfet_01v8 m=1 w=0.42u l=0.15u mult=1
+ sa=0.265 sb=0.265 sd=0.28 area=0.063 perim=1.14
MI635 clkneg CLK VGND VNB sky130_fd_pr__nfet_01v8 m=1 w=0.42u l=0.15u mult=1 sa=0.265
+ sb=0.265 sd=0.28 area=0.063 perim=1.14
MI641 net227 q1 VGND VNB sky130_fd_pr__nfet_01v8 m=1 w=0.42u l=0.15u mult=1 sa=0.265
+ sb=0.265 sd=0.28 area=0.063 perim=1.14
MI642 S0 clkneg net227 VNB sky130_fd_pr__nfet_01v8 m=1 w=0.36u l=0.15u mult=1 sa=0.265
+ sb=0.265 sd=0.28 area=0.063 perim=1.14
MI648 db clkneg M0 VNB sky130_fd_pr__nfet_01v8 m=1 w=0.36u l=0.15u mult=1 sa=0.265
+ sb=0.265 sd=0.28 area=0.063 perim=1.14
MI646 Q S0 VGND VNB sky130_fd_pr__nfet_01v8 m=4 w=0.65u l=0.15u mult=1 sa=0.265
+ sb=0.265 sd=0.28 area=0.063 perim=1.14
MI656 net206 M1 VGND VNB sky130_fd_pr__nfet_01v8 m=1 w=0.42u l=0.15u mult=1 sa=0.265
+ sb=0.265 sd=0.28 area=0.063 perim=1.14
MI657 M0 clkpos net206 VNB sky130_fd_pr__nfet_01v8 m=1 w=0.36u l=0.15u mult=1 sa=0.265
+ sb=0.265 sd=0.28 area=0.063 perim=1.14
MI43 net95 sceneg db VNB sky130_fd_pr__nfet_01v8 m=1 w=0.42u l=0.15u mult=1 sa=0.265
+ sb=0.265 sd=0.28 area=0.063 perim=1.14
MI18 q1 S0 VGND VNB sky130_fd_pr__nfet_01v8 m=1 w=0.42u l=0.15u mult=1 sa=0.265
+ sb=0.265 sd=0.28 area=0.063 perim=1.14
MI45 sceneg SCE VGND VNB sky130_fd_pr__nfet_01v8 m=1 w=0.42u l=0.15u mult=1 sa=0.265
+ sb=0.265 sd=0.28 area=0.063 perim=1.14
MI32 net95 D net190 VNB sky130_fd_pr__nfet_01v8 m=1 w=0.42u l=0.15u mult=1 sa=0.265
+ sb=0.265 sd=0.28 area=0.063 perim=1.14
MI16 net187 M1 VGND VNB sky130_fd_pr__nfet_01v8 m=1 w=0.42u l=0.15u mult=1 sa=0.265
+ sb=0.265 sd=0.28 area=0.063 perim=1.14
MI15 S0 clkpos net187 VNB sky130_fd_pr__nfet_01v8 m=1 w=0.36u l=0.15u mult=1 sa=0.265
+ sb=0.265 sd=0.28 area=0.063 perim=1.14
MI41 net174 q1 net95 VNB sky130_fd_pr__nfet_01v8 m=1 w=0.42u l=0.15u mult=1 sa=0.265
+ sb=0.265 sd=0.28 area=0.063 perim=1.14
MI39 VGND deneg net174 VNB sky130_fd_pr__nfet_01v8 m=1 w=0.42u l=0.15u mult=1 sa=0.265
+ sb=0.265 sd=0.28 area=0.063 perim=1.14
MI37 deneg DE VGND VNB sky130_fd_pr__nfet_01v8 m=1 w=0.42u l=0.15u mult=1 sa=0.265
+ sb=0.265 sd=0.28 area=0.063 perim=1.14
MI34 net190 DE VGND VNB sky130_fd_pr__nfet_01v8 m=1 w=0.42u l=0.15u mult=1 sa=0.265
+ sb=0.265 sd=0.28 area=0.063 perim=1.14
MI49 net163 SCE db VNB sky130_fd_pr__nfet_01v8 m=1 w=0.42u l=0.15u mult=1 sa=0.265
+ sb=0.265 sd=0.28 area=0.063 perim=1.14
MI48 VGND SCD net163 VNB sky130_fd_pr__nfet_01v8 m=1 w=0.42u l=0.15u mult=1 sa=0.265
+ sb=0.265 sd=0.28 area=0.063 perim=1.14
.ENDS sky130_fd_sc_hd__sedfxtp_4
* Copyright 2020 The SkyWater PDK Authors
*
* Licensed under the Apache License, Version 2.0 (the "License");
* you may not use this file except in compliance with the License.
* You may obtain a copy of the License at
*
*     https:  www.apache.org licenses LICENSE-2.0
*
* Unless required by applicable law or agreed to in writing, software
* distributed under the License is distributed on an "AS IS" BASIS,
* WITHOUT WARRANTIES OR CONDITIONS OF ANY KIND, either express or implied.
* See the License for the specific language governing permissions and
* limitations under the License.
*
* SPDX-License-Identifier: Apache-2.0

.SUBCKT sky130_fd_sc_hd__tap_1 VGND VNB VNB net59
*.PININFO VGND:I VNB:I VNB:I net59:I
* Notes: Tap pins in this cell are not connected to power buses.
.ENDS sky130_fd_sc_hd__tap_1
* Copyright 2020 The SkyWater PDK Authors
*
* Licensed under the Apache License, Version 2.0 (the "License");
* you may not use this file except in compliance with the License.
* You may obtain a copy of the License at
*
*     https:  www.apache.org licenses LICENSE-2.0
*
* Unless required by applicable law or agreed to in writing, software
* distributed under the License is distributed on an "AS IS" BASIS,
* WITHOUT WARRANTIES OR CONDITIONS OF ANY KIND, either express or implied.
* See the License for the specific language governing permissions and
* limitations under the License.
*
* SPDX-License-Identifier: Apache-2.0

.SUBCKT sky130_fd_sc_hd__tap_2 VGND VNB VNB net59
*.PININFO VGND:I VNB:I VNB:I net59:I
* Notes: Tap pins in this cell are not connected to power buses.
.ENDS sky130_fd_sc_hd__tap_2
* Copyright 2020 The SkyWater PDK Authors
*
* Licensed under the Apache License, Version 2.0 (the "License");
* you may not use this file except in compliance with the License.
* You may obtain a copy of the License at
*
*     https:  www.apache.org licenses LICENSE-2.0
*
* Unless required by applicable law or agreed to in writing, software
* distributed under the License is distributed on an "AS IS" BASIS,
* WITHOUT WARRANTIES OR CONDITIONS OF ANY KIND, either express or implied.
* See the License for the specific language governing permissions and
* limitations under the License.
*
* SPDX-License-Identifier: Apache-2.0

.SUBCKT sky130_fd_sc_hd__tapvgnd2_1 VGND VNB net59
*.PININFO VGND:I VNB:I net59:I
* Notes: substrate is tied to vgnd in the cell and does not appear as
*        a pin.
.ENDS sky130_fd_sc_hd__tapvgnd2_1
* Copyright 2020 The SkyWater PDK Authors
*
* Licensed under the Apache License, Version 2.0 (the "License");
* you may not use this file except in compliance with the License.
* You may obtain a copy of the License at
*
*     https:  www.apache.org licenses LICENSE-2.0
*
* Unless required by applicable law or agreed to in writing, software
* distributed under the License is distributed on an "AS IS" BASIS,
* WITHOUT WARRANTIES OR CONDITIONS OF ANY KIND, either express or implied.
* See the License for the specific language governing permissions and
* limitations under the License.
*
* SPDX-License-Identifier: Apache-2.0

.SUBCKT sky130_fd_sc_hd__tapvgnd_1 VGND VNB net59
*.PININFO VGND:I VNB:I net59:I
* Notes: substrate is tied to vgnd in the cell and does not appear as
*        a pin.
.ENDS sky130_fd_sc_hd__tapvgnd_1
* Copyright 2020 The SkyWater PDK Authors
*
* Licensed under the Apache License, Version 2.0 (the "License");
* you may not use this file except in compliance with the License.
* You may obtain a copy of the License at
*
*     https:  www.apache.org licenses LICENSE-2.0
*
* Unless required by applicable law or agreed to in writing, software
* distributed under the License is distributed on an "AS IS" BASIS,
* WITHOUT WARRANTIES OR CONDITIONS OF ANY KIND, either express or implied.
* See the License for the specific language governing permissions and
* limitations under the License.
*
* SPDX-License-Identifier: Apache-2.0

.SUBCKT sky130_fd_sc_hd__tapvpwrvgnd_1 VGND net59
*.PININFO VGND:I net59:I
* Notes: substrate is tied to vgnd and well is tied to vpwr in the
*        cell and do not appear as pins.
.ENDS sky130_fd_sc_hd__tapvpwrvgnd_1
* Copyright 2020 The SkyWater PDK Authors
*
* Licensed under the Apache License, Version 2.0 (the "License");
* you may not use this file except in compliance with the License.
* You may obtain a copy of the License at
*
*     https:  www.apache.org licenses LICENSE-2.0
*
* Unless required by applicable law or agreed to in writing, software
* distributed under the License is distributed on an "AS IS" BASIS,
* WITHOUT WARRANTIES OR CONDITIONS OF ANY KIND, either express or implied.
* See the License for the specific language governing permissions and
* limitations under the License.
*
* SPDX-License-Identifier: Apache-2.0

.SUBCKT sky130_fd_sc_hd__xnor2_1 A B VGND VNB VNB net59 Y
*.PININFO A:I B:I VGND:I VNB:I VNB:I net59:I Y:O
MMNnand0 VGND A sndNA VNB sky130_fd_pr__nfet_01v8 m=1 w=0.65u l=0.15u mult=1 sa=0.265
+ sb=0.265 sd=0.28 area=0.063 perim=1.14
MMNnand1 sndNA B inand VNB sky130_fd_pr__nfet_01v8 m=1 w=0.65u l=0.15u mult=1 sa=0.265
+ sb=0.265 sd=0.28 area=0.063 perim=1.14
MMNaoi10 nmid A VGND VNB sky130_fd_pr__nfet_01v8 m=1 w=0.65u l=0.15u mult=1 sa=0.265
+ sb=0.265 sd=0.28 area=0.063 perim=1.14
MMNaoi11 nmid B VGND VNB sky130_fd_pr__nfet_01v8 m=1 w=0.65u l=0.15u mult=1 sa=0.265
+ sb=0.265 sd=0.28 area=0.063 perim=1.14
MMNaoi20 Y inand nmid VNB sky130_fd_pr__nfet_01v8 m=1 w=0.65u l=0.15u mult=1 sa=0.265
+ sb=0.265 sd=0.28 area=0.063 perim=1.14
MMPnand0 inand A net59 VNB sky130_fd_pr__pfet_01v8_hvt m=1 w=1.0u l=0.15u mult=1
+ sa=0.265 sb=0.265 sd=0.28 area=0.063 perim=1.14
MMPnand1 inand B net59 VNB sky130_fd_pr__pfet_01v8_hvt m=1 w=1.0u l=0.15u mult=1
+ sa=0.265 sb=0.265 sd=0.28 area=0.063 perim=1.14
MMPaoi10 net59 A sndPA VNB sky130_fd_pr__pfet_01v8_hvt m=1 w=1.0u l=0.15u mult=1
+ sa=0.265 sb=0.265 sd=0.28 area=0.063 perim=1.14
MMPaoi11 sndPA B Y VNB sky130_fd_pr__pfet_01v8_hvt m=1 w=1.0u l=0.15u mult=1 sa=0.265
+ sb=0.265 sd=0.28 area=0.063 perim=1.14
MMPaoi20 Y inand net59 VNB sky130_fd_pr__pfet_01v8_hvt m=1 w=1.0u l=0.15u mult=1
+ sa=0.265 sb=0.265 sd=0.28 area=0.063 perim=1.14
.ENDS sky130_fd_sc_hd__xnor2_1
* Copyright 2020 The SkyWater PDK Authors
*
* Licensed under the Apache License, Version 2.0 (the "License");
* you may not use this file except in compliance with the License.
* You may obtain a copy of the License at
*
*     https:  www.apache.org licenses LICENSE-2.0
*
* Unless required by applicable law or agreed to in writing, software
* distributed under the License is distributed on an "AS IS" BASIS,
* WITHOUT WARRANTIES OR CONDITIONS OF ANY KIND, either express or implied.
* See the License for the specific language governing permissions and
* limitations under the License.
*
* SPDX-License-Identifier: Apache-2.0

.SUBCKT sky130_fd_sc_hd__xnor2_2 A B VGND VNB VNB net59 Y
*.PININFO A:I B:I VGND:I VNB:I VNB:I net59:I Y:O
MMNnand0 VGND A sndNA VNB sky130_fd_pr__nfet_01v8 m=2 w=0.65u l=0.15u mult=1 sa=0.265
+ sb=0.265 sd=0.28 area=0.063 perim=1.14
MMNnand1 sndNA B inand VNB sky130_fd_pr__nfet_01v8 m=2 w=0.65u l=0.15u mult=1 sa=0.265
+ sb=0.265 sd=0.28 area=0.063 perim=1.14
MMNaoi10 nmid A VGND VNB sky130_fd_pr__nfet_01v8 m=2 w=0.65u l=0.15u mult=1 sa=0.265
+ sb=0.265 sd=0.28 area=0.063 perim=1.14
MMNaoi11 nmid B VGND VNB sky130_fd_pr__nfet_01v8 m=2 w=0.65u l=0.15u mult=1 sa=0.265
+ sb=0.265 sd=0.28 area=0.063 perim=1.14
MMNaoi20 Y inand nmid VNB sky130_fd_pr__nfet_01v8 m=2 w=0.65u l=0.15u mult=1 sa=0.265
+ sb=0.265 sd=0.28 area=0.063 perim=1.14
MMPnand0 inand A net59 VNB sky130_fd_pr__pfet_01v8_hvt m=2 w=1.0u l=0.15u mult=1
+ sa=0.265 sb=0.265 sd=0.28 area=0.063 perim=1.14
MMPnand1 inand B net59 VNB sky130_fd_pr__pfet_01v8_hvt m=2 w=1.0u l=0.15u mult=1
+ sa=0.265 sb=0.265 sd=0.28 area=0.063 perim=1.14
MMPaoi10 net59 A sndPA VNB sky130_fd_pr__pfet_01v8_hvt m=2 w=1.0u l=0.15u mult=1
+ sa=0.265 sb=0.265 sd=0.28 area=0.063 perim=1.14
MMPaoi11 sndPA B Y VNB sky130_fd_pr__pfet_01v8_hvt m=2 w=1.0u l=0.15u mult=1 sa=0.265
+ sb=0.265 sd=0.28 area=0.063 perim=1.14
MMPaoi20 Y inand net59 VNB sky130_fd_pr__pfet_01v8_hvt m=2 w=1.0u l=0.15u mult=1
+ sa=0.265 sb=0.265 sd=0.28 area=0.063 perim=1.14
.ENDS sky130_fd_sc_hd__xnor2_2
* Copyright 2020 The SkyWater PDK Authors
*
* Licensed under the Apache License, Version 2.0 (the "License");
* you may not use this file except in compliance with the License.
* You may obtain a copy of the License at
*
*     https:  www.apache.org licenses LICENSE-2.0
*
* Unless required by applicable law or agreed to in writing, software
* distributed under the License is distributed on an "AS IS" BASIS,
* WITHOUT WARRANTIES OR CONDITIONS OF ANY KIND, either express or implied.
* See the License for the specific language governing permissions and
* limitations under the License.
*
* SPDX-License-Identifier: Apache-2.0

.SUBCKT sky130_fd_sc_hd__xnor2_4 A B VGND VNB VNB net59 Y
*.PININFO A:I B:I VGND:I VNB:I VNB:I net59:I Y:O
MMNnand0 VGND A sndNA VNB sky130_fd_pr__nfet_01v8 m=4 w=0.65u l=0.15u mult=1 sa=0.265
+ sb=0.265 sd=0.28 area=0.063 perim=1.14
MMNnand1 sndNA B inand VNB sky130_fd_pr__nfet_01v8 m=4 w=0.65u l=0.15u mult=1 sa=0.265
+ sb=0.265 sd=0.28 area=0.063 perim=1.14
MMNaoi10 nmid A VGND VNB sky130_fd_pr__nfet_01v8 m=4 w=0.65u l=0.15u mult=1 sa=0.265
+ sb=0.265 sd=0.28 area=0.063 perim=1.14
MMNaoi11 nmid B VGND VNB sky130_fd_pr__nfet_01v8 m=4 w=0.65u l=0.15u mult=1 sa=0.265
+ sb=0.265 sd=0.28 area=0.063 perim=1.14
MMNaoi20 Y inand nmid VNB sky130_fd_pr__nfet_01v8 m=4 w=0.65u l=0.15u mult=1 sa=0.265
+ sb=0.265 sd=0.28 area=0.063 perim=1.14
MMPnand0 inand A net59 VNB sky130_fd_pr__pfet_01v8_hvt m=4 w=1.0u l=0.15u mult=1
+ sa=0.265 sb=0.265 sd=0.28 area=0.063 perim=1.14
MMPnand1 inand B net59 VNB sky130_fd_pr__pfet_01v8_hvt m=4 w=1.0u l=0.15u mult=1
+ sa=0.265 sb=0.265 sd=0.28 area=0.063 perim=1.14
MMPaoi10 net59 A sndPA VNB sky130_fd_pr__pfet_01v8_hvt m=4 w=1.0u l=0.15u mult=1
+ sa=0.265 sb=0.265 sd=0.28 area=0.063 perim=1.14
MMPaoi11 sndPA B Y VNB sky130_fd_pr__pfet_01v8_hvt m=4 w=1.0u l=0.15u mult=1 sa=0.265
+ sb=0.265 sd=0.28 area=0.063 perim=1.14
MMPaoi20 Y inand net59 VNB sky130_fd_pr__pfet_01v8_hvt m=4 w=1.0u l=0.15u mult=1
+ sa=0.265 sb=0.265 sd=0.28 area=0.063 perim=1.14
.ENDS sky130_fd_sc_hd__xnor2_4
* Copyright 2020 The SkyWater PDK Authors
*
* Licensed under the Apache License, Version 2.0 (the "License");
* you may not use this file except in compliance with the License.
* You may obtain a copy of the License at
*
*     https:  www.apache.org licenses LICENSE-2.0
*
* Unless required by applicable law or agreed to in writing, software
* distributed under the License is distributed on an "AS IS" BASIS,
* WITHOUT WARRANTIES OR CONDITIONS OF ANY KIND, either express or implied.
* See the License for the specific language governing permissions and
* limitations under the License.
*
* SPDX-License-Identifier: Apache-2.0

.SUBCKT sky130_fd_sc_hd__xnor3_1 A B C VGND VNB VNB net59 X
*.PININFO A:I B:I C:I VGND:I VNB:I VNB:I net59:I X:O
MMIN3 X net57 VGND VNB sky130_fd_pr__nfet_01v8 m=1 w=0.65u l=0.15u mult=1 sa=0.265
+ sb=0.265 sd=0.28 area=0.063 perim=1.14
MI29 Ab Bb mid2 VNB sky130_fd_pr__nfet_01v8 m=1 w=0.6u l=0.15u mult=1 sa=0.265
+ sb=0.265 sd=0.28 area=0.063 perim=1.14
MI25 Abb Bb mid1 VNB sky130_fd_pr__nfet_01v8 m=1 w=0.42u l=0.15u mult=1 sa=0.265
+ sb=0.265 sd=0.28 area=0.063 perim=1.14
MI17 Bb B VGND VNB sky130_fd_pr__nfet_01v8 m=1 w=0.65u l=0.15u mult=1 sa=0.265
+ sb=0.265 sd=0.28 area=0.063 perim=1.14
MI649 mid1 Cb net57 VNB sky130_fd_pr__nfet_01v8 m=1 w=0.64u l=0.15u mult=1 sa=0.265
+ sb=0.265 sd=0.28 area=0.063 perim=1.14
MI44 Ab A VGND VNB sky130_fd_pr__nfet_01v8 m=1 w=0.64u l=0.15u mult=1 sa=0.265
+ sb=0.265 sd=0.28 area=0.063 perim=1.14
MI34 Cb C VGND VNB sky130_fd_pr__nfet_01v8 m=1 w=0.42u l=0.15u mult=1 sa=0.265
+ sb=0.265 sd=0.28 area=0.063 perim=1.14
MI2 mid2 C net57 VNB sky130_fd_pr__nfet_01v8 m=1 w=0.64u l=0.15u mult=1 sa=0.265
+ sb=0.265 sd=0.28 area=0.063 perim=1.14
MI46 Abb Ab VGND VNB sky130_fd_pr__nfet_01v8 m=1 w=0.64u l=0.15u mult=1 sa=0.265
+ sb=0.265 sd=0.28 area=0.063 perim=1.14
MI24 Ab B mid1 VNB sky130_fd_pr__nfet_01v8 m=1 w=0.64u l=0.15u mult=1 sa=0.265
+ sb=0.265 sd=0.28 area=0.063 perim=1.14
MI28 Abb B mid2 VNB sky130_fd_pr__nfet_01v8 m=1 w=0.64u l=0.15u mult=1 sa=0.265
+ sb=0.265 sd=0.28 area=0.063 perim=1.14
MMIP3 X net57 net59 VNB sky130_fd_pr__pfet_01v8_hvt m=1 w=1.0u l=0.15u mult=1 sa=0.265
+ sb=0.265 sd=0.28 area=0.063 perim=1.14
MI650 mid1 C net57 VNB sky130_fd_pr__pfet_01v8_hvt m=1 w=0.84u l=0.15u mult=1 sa=0.265
+ sb=0.265 sd=0.28 area=0.063 perim=1.14
MI27 mid2 B Ab VNB sky130_fd_pr__pfet_01v8_hvt m=1 w=0.84u l=0.15u mult=1 sa=0.265
+ sb=0.265 sd=0.28 area=0.063 perim=1.14
MI47 Abb Ab net59 VNB sky130_fd_pr__pfet_01v8_hvt m=1 w=1.0u l=0.15u mult=1 sa=0.265
+ sb=0.265 sd=0.28 area=0.063 perim=1.14
MI23 mid1 B Abb VNB sky130_fd_pr__pfet_01v8_hvt m=1 w=0.64u l=0.15u mult=1 sa=0.265
+ sb=0.265 sd=0.28 area=0.063 perim=1.14
MI26 mid2 Bb Abb VNB sky130_fd_pr__pfet_01v8_hvt m=1 w=0.64u l=0.15u mult=1 sa=0.265
+ sb=0.265 sd=0.28 area=0.063 perim=1.14
MI7 mid2 Cb net57 VNB sky130_fd_pr__pfet_01v8_hvt m=1 w=0.84u l=0.15u mult=1 sa=0.265
+ sb=0.265 sd=0.28 area=0.063 perim=1.14
MI33 Cb C net59 VNB sky130_fd_pr__pfet_01v8_hvt m=1 w=0.64u l=0.15u mult=1 sa=0.265
+ sb=0.265 sd=0.28 area=0.063 perim=1.14
MI45 Ab A net59 VNB sky130_fd_pr__pfet_01v8_hvt m=1 w=1.0u l=0.15u mult=1 sa=0.265
+ sb=0.265 sd=0.28 area=0.063 perim=1.14
MI16 Bb B net59 VNB sky130_fd_pr__pfet_01v8_hvt m=1 w=1.0u l=0.15u mult=1 sa=0.265
+ sb=0.265 sd=0.28 area=0.063 perim=1.14
MI19 mid1 Bb Ab VNB sky130_fd_pr__pfet_01v8_hvt m=1 w=0.84u l=0.15u mult=1 sa=0.265
+ sb=0.265 sd=0.28 area=0.063 perim=1.14
.ENDS sky130_fd_sc_hd__xnor3_1
* Copyright 2020 The SkyWater PDK Authors
*
* Licensed under the Apache License, Version 2.0 (the "License");
* you may not use this file except in compliance with the License.
* You may obtain a copy of the License at
*
*     https:  www.apache.org licenses LICENSE-2.0
*
* Unless required by applicable law or agreed to in writing, software
* distributed under the License is distributed on an "AS IS" BASIS,
* WITHOUT WARRANTIES OR CONDITIONS OF ANY KIND, either express or implied.
* See the License for the specific language governing permissions and
* limitations under the License.
*
* SPDX-License-Identifier: Apache-2.0

.SUBCKT sky130_fd_sc_hd__xnor3_2 A B C VGND VNB VNB net59 X
*.PININFO A:I B:I C:I VGND:I VNB:I VNB:I net59:I X:O
MMIN3 X net57 VGND VNB sky130_fd_pr__nfet_01v8 m=2 w=0.65u l=0.15u mult=1 sa=0.265
+ sb=0.265 sd=0.28 area=0.063 perim=1.14
MI29 Ab Bb mid2 VNB sky130_fd_pr__nfet_01v8 m=1 w=0.6u l=0.15u mult=1 sa=0.265
+ sb=0.265 sd=0.28 area=0.063 perim=1.14
MI25 Abb Bb mid1 VNB sky130_fd_pr__nfet_01v8 m=1 w=0.42u l=0.15u mult=1 sa=0.265
+ sb=0.265 sd=0.28 area=0.063 perim=1.14
MI17 Bb B VGND VNB sky130_fd_pr__nfet_01v8 m=1 w=0.65u l=0.15u mult=1 sa=0.265
+ sb=0.265 sd=0.28 area=0.063 perim=1.14
MI649 mid1 Cb net57 VNB sky130_fd_pr__nfet_01v8 m=1 w=0.64u l=0.15u mult=1 sa=0.265
+ sb=0.265 sd=0.28 area=0.063 perim=1.14
MI44 Ab A VGND VNB sky130_fd_pr__nfet_01v8 m=1 w=0.64u l=0.15u mult=1 sa=0.265
+ sb=0.265 sd=0.28 area=0.063 perim=1.14
MI34 Cb C VGND VNB sky130_fd_pr__nfet_01v8 m=1 w=0.42u l=0.15u mult=1 sa=0.265
+ sb=0.265 sd=0.28 area=0.063 perim=1.14
MI2 mid2 C net57 VNB sky130_fd_pr__nfet_01v8 m=1 w=0.64u l=0.15u mult=1 sa=0.265
+ sb=0.265 sd=0.28 area=0.063 perim=1.14
MI46 Abb Ab VGND VNB sky130_fd_pr__nfet_01v8 m=1 w=0.64u l=0.15u mult=1 sa=0.265
+ sb=0.265 sd=0.28 area=0.063 perim=1.14
MI24 Ab B mid1 VNB sky130_fd_pr__nfet_01v8 m=1 w=0.64u l=0.15u mult=1 sa=0.265
+ sb=0.265 sd=0.28 area=0.063 perim=1.14
MI28 Abb B mid2 VNB sky130_fd_pr__nfet_01v8 m=1 w=0.64u l=0.15u mult=1 sa=0.265
+ sb=0.265 sd=0.28 area=0.063 perim=1.14
MMIP3 X net57 net59 VNB sky130_fd_pr__pfet_01v8_hvt m=2 w=1.0u l=0.15u mult=1 sa=0.265
+ sb=0.265 sd=0.28 area=0.063 perim=1.14
MI650 mid1 C net57 VNB sky130_fd_pr__pfet_01v8_hvt m=1 w=0.84u l=0.15u mult=1 sa=0.265
+ sb=0.265 sd=0.28 area=0.063 perim=1.14
MI27 mid2 B Ab VNB sky130_fd_pr__pfet_01v8_hvt m=1 w=0.84u l=0.15u mult=1 sa=0.265
+ sb=0.265 sd=0.28 area=0.063 perim=1.14
MI47 Abb Ab net59 VNB sky130_fd_pr__pfet_01v8_hvt m=1 w=1.0u l=0.15u mult=1 sa=0.265
+ sb=0.265 sd=0.28 area=0.063 perim=1.14
MI23 mid1 B Abb VNB sky130_fd_pr__pfet_01v8_hvt m=1 w=0.64u l=0.15u mult=1 sa=0.265
+ sb=0.265 sd=0.28 area=0.063 perim=1.14
MI26 mid2 Bb Abb VNB sky130_fd_pr__pfet_01v8_hvt m=1 w=0.64u l=0.15u mult=1 sa=0.265
+ sb=0.265 sd=0.28 area=0.063 perim=1.14
MI7 mid2 Cb net57 VNB sky130_fd_pr__pfet_01v8_hvt m=1 w=0.84u l=0.15u mult=1 sa=0.265
+ sb=0.265 sd=0.28 area=0.063 perim=1.14
MI33 Cb C net59 VNB sky130_fd_pr__pfet_01v8_hvt m=1 w=0.64u l=0.15u mult=1 sa=0.265
+ sb=0.265 sd=0.28 area=0.063 perim=1.14
MI45 Ab A net59 VNB sky130_fd_pr__pfet_01v8_hvt m=1 w=1.0u l=0.15u mult=1 sa=0.265
+ sb=0.265 sd=0.28 area=0.063 perim=1.14
MI16 Bb B net59 VNB sky130_fd_pr__pfet_01v8_hvt m=1 w=1.0u l=0.15u mult=1 sa=0.265
+ sb=0.265 sd=0.28 area=0.063 perim=1.14
MI19 mid1 Bb Ab VNB sky130_fd_pr__pfet_01v8_hvt m=1 w=0.84u l=0.15u mult=1 sa=0.265
+ sb=0.265 sd=0.28 area=0.063 perim=1.14
.ENDS sky130_fd_sc_hd__xnor3_2
* Copyright 2020 The SkyWater PDK Authors
*
* Licensed under the Apache License, Version 2.0 (the "License");
* you may not use this file except in compliance with the License.
* You may obtain a copy of the License at
*
*     https:  www.apache.org licenses LICENSE-2.0
*
* Unless required by applicable law or agreed to in writing, software
* distributed under the License is distributed on an "AS IS" BASIS,
* WITHOUT WARRANTIES OR CONDITIONS OF ANY KIND, either express or implied.
* See the License for the specific language governing permissions and
* limitations under the License.
*
* SPDX-License-Identifier: Apache-2.0

.SUBCKT sky130_fd_sc_hd__xnor3_4 A B C VGND VNB VNB net59 X
*.PININFO A:I B:I C:I VGND:I VNB:I VNB:I net59:I X:O
MMIN3 X net57 VGND VNB sky130_fd_pr__nfet_01v8 m=4 w=0.65u l=0.15u mult=1 sa=0.265
+ sb=0.265 sd=0.28 area=0.063 perim=1.14
MI29 Ab Bb mid2 VNB sky130_fd_pr__nfet_01v8 m=1 w=0.6u l=0.15u mult=1 sa=0.265
+ sb=0.265 sd=0.28 area=0.063 perim=1.14
MI25 Abb Bb mid1 VNB sky130_fd_pr__nfet_01v8 m=1 w=0.42u l=0.15u mult=1 sa=0.265
+ sb=0.265 sd=0.28 area=0.063 perim=1.14
MI17 Bb B VGND VNB sky130_fd_pr__nfet_01v8 m=1 w=0.65u l=0.15u mult=1 sa=0.265
+ sb=0.265 sd=0.28 area=0.063 perim=1.14
MI649 mid1 Cb net57 VNB sky130_fd_pr__nfet_01v8 m=1 w=0.64u l=0.15u mult=1 sa=0.265
+ sb=0.265 sd=0.28 area=0.063 perim=1.14
MI44 Ab A VGND VNB sky130_fd_pr__nfet_01v8 m=1 w=0.64u l=0.15u mult=1 sa=0.265
+ sb=0.265 sd=0.28 area=0.063 perim=1.14
MI34 Cb C VGND VNB sky130_fd_pr__nfet_01v8 m=1 w=0.42u l=0.15u mult=1 sa=0.265
+ sb=0.265 sd=0.28 area=0.063 perim=1.14
MI2 mid2 C net57 VNB sky130_fd_pr__nfet_01v8 m=1 w=0.64u l=0.15u mult=1 sa=0.265
+ sb=0.265 sd=0.28 area=0.063 perim=1.14
MI46 Abb Ab VGND VNB sky130_fd_pr__nfet_01v8 m=1 w=0.64u l=0.15u mult=1 sa=0.265
+ sb=0.265 sd=0.28 area=0.063 perim=1.14
MI24 Ab B mid1 VNB sky130_fd_pr__nfet_01v8 m=1 w=0.64u l=0.15u mult=1 sa=0.265
+ sb=0.265 sd=0.28 area=0.063 perim=1.14
MI28 Abb B mid2 VNB sky130_fd_pr__nfet_01v8 m=1 w=0.64u l=0.15u mult=1 sa=0.265
+ sb=0.265 sd=0.28 area=0.063 perim=1.14
MMIP3 X net57 net59 VNB sky130_fd_pr__pfet_01v8_hvt m=4 w=1.0u l=0.15u mult=1 sa=0.265
+ sb=0.265 sd=0.28 area=0.063 perim=1.14
MI650 mid1 C net57 VNB sky130_fd_pr__pfet_01v8_hvt m=1 w=0.84u l=0.15u mult=1 sa=0.265
+ sb=0.265 sd=0.28 area=0.063 perim=1.14
MI27 mid2 B Ab VNB sky130_fd_pr__pfet_01v8_hvt m=1 w=0.84u l=0.15u mult=1 sa=0.265
+ sb=0.265 sd=0.28 area=0.063 perim=1.14
MI47 Abb Ab net59 VNB sky130_fd_pr__pfet_01v8_hvt m=1 w=1.0u l=0.15u mult=1 sa=0.265
+ sb=0.265 sd=0.28 area=0.063 perim=1.14
MI23 mid1 B Abb VNB sky130_fd_pr__pfet_01v8_hvt m=1 w=0.64u l=0.15u mult=1 sa=0.265
+ sb=0.265 sd=0.28 area=0.063 perim=1.14
MI26 mid2 Bb Abb VNB sky130_fd_pr__pfet_01v8_hvt m=1 w=0.64u l=0.15u mult=1 sa=0.265
+ sb=0.265 sd=0.28 area=0.063 perim=1.14
MI7 mid2 Cb net57 VNB sky130_fd_pr__pfet_01v8_hvt m=1 w=0.84u l=0.15u mult=1 sa=0.265
+ sb=0.265 sd=0.28 area=0.063 perim=1.14
MI33 Cb C net59 VNB sky130_fd_pr__pfet_01v8_hvt m=1 w=0.64u l=0.15u mult=1 sa=0.265
+ sb=0.265 sd=0.28 area=0.063 perim=1.14
MI45 Ab A net59 VNB sky130_fd_pr__pfet_01v8_hvt m=1 w=1.0u l=0.15u mult=1 sa=0.265
+ sb=0.265 sd=0.28 area=0.063 perim=1.14
MI16 Bb B net59 VNB sky130_fd_pr__pfet_01v8_hvt m=1 w=1.0u l=0.15u mult=1 sa=0.265
+ sb=0.265 sd=0.28 area=0.063 perim=1.14
MI19 mid1 Bb Ab VNB sky130_fd_pr__pfet_01v8_hvt m=1 w=0.84u l=0.15u mult=1 sa=0.265
+ sb=0.265 sd=0.28 area=0.063 perim=1.14
.ENDS sky130_fd_sc_hd__xnor3_4
* Copyright 2020 The SkyWater PDK Authors
*
* Licensed under the Apache License, Version 2.0 (the "License");
* you may not use this file except in compliance with the License.
* You may obtain a copy of the License at
*
*     https:  www.apache.org licenses LICENSE-2.0
*
* Unless required by applicable law or agreed to in writing, software
* distributed under the License is distributed on an "AS IS" BASIS,
* WITHOUT WARRANTIES OR CONDITIONS OF ANY KIND, either express or implied.
* See the License for the specific language governing permissions and
* limitations under the License.
*
* SPDX-License-Identifier: Apache-2.0

.SUBCKT sky130_fd_sc_hd__xor2_1 A B VGND VNB VNB net59 X
*.PININFO A:I B:I VGND:I VNB:I VNB:I net59:I X:O
MMNnor0 inor A VGND VNB sky130_fd_pr__nfet_01v8 m=1 w=0.65u l=0.15u mult=1 sa=0.265
+ sb=0.265 sd=0.28 area=0.063 perim=1.14
MMNnor1 inor B VGND VNB sky130_fd_pr__nfet_01v8 m=1 w=0.65u l=0.15u mult=1 sa=0.265
+ sb=0.265 sd=0.28 area=0.063 perim=1.14
MMNaoi10 VGND A sndNA VNB sky130_fd_pr__nfet_01v8 m=1 w=0.65u l=0.15u mult=1 sa=0.265
+ sb=0.265 sd=0.28 area=0.063 perim=1.14
MMNaoi11 sndNA B X VNB sky130_fd_pr__nfet_01v8 m=1 w=0.65u l=0.15u mult=1 sa=0.265
+ sb=0.265 sd=0.28 area=0.063 perim=1.14
MMNaoi20 X inor VGND VNB sky130_fd_pr__nfet_01v8 m=1 w=0.65u l=0.15u mult=1 sa=0.265
+ sb=0.265 sd=0.28 area=0.063 perim=1.14
MMPnor0 net59 A sndPA VNB sky130_fd_pr__pfet_01v8_hvt m=1 w=1.0u l=0.15u mult=1
+ sa=0.265 sb=0.265 sd=0.28 area=0.063 perim=1.14
MMPnor1 sndPA B inor VNB sky130_fd_pr__pfet_01v8_hvt m=1 w=1.0u l=0.15u mult=1
+ sa=0.265 sb=0.265 sd=0.28 area=0.063 perim=1.14
MMPaoi10 pmid A net59 VNB sky130_fd_pr__pfet_01v8_hvt m=1 w=1.0u l=0.15u mult=1
+ sa=0.265 sb=0.265 sd=0.28 area=0.063 perim=1.14
MMPaoi11 pmid B net59 VNB sky130_fd_pr__pfet_01v8_hvt m=1 w=1.0u l=0.15u mult=1
+ sa=0.265 sb=0.265 sd=0.28 area=0.063 perim=1.14
MMPaoi20 X inor pmid VNB sky130_fd_pr__pfet_01v8_hvt m=1 w=1.0u l=0.15u mult=1
+ sa=0.265 sb=0.265 sd=0.28 area=0.063 perim=1.14
.ENDS sky130_fd_sc_hd__xor2_1
* Copyright 2020 The SkyWater PDK Authors
*
* Licensed under the Apache License, Version 2.0 (the "License");
* you may not use this file except in compliance with the License.
* You may obtain a copy of the License at
*
*     https:  www.apache.org licenses LICENSE-2.0
*
* Unless required by applicable law or agreed to in writing, software
* distributed under the License is distributed on an "AS IS" BASIS,
* WITHOUT WARRANTIES OR CONDITIONS OF ANY KIND, either express or implied.
* See the License for the specific language governing permissions and
* limitations under the License.
*
* SPDX-License-Identifier: Apache-2.0

.SUBCKT sky130_fd_sc_hd__xor2_2 A B VGND VNB VNB net59 X
*.PININFO A:I B:I VGND:I VNB:I VNB:I net59:I X:O
MMNnor0 inor A VGND VNB sky130_fd_pr__nfet_01v8 m=2 w=0.65u l=0.15u mult=1 sa=0.265
+ sb=0.265 sd=0.28 area=0.063 perim=1.14
MMNnor1 inor B VGND VNB sky130_fd_pr__nfet_01v8 m=2 w=0.65u l=0.15u mult=1 sa=0.265
+ sb=0.265 sd=0.28 area=0.063 perim=1.14
MMNaoi10 VGND A sndNA VNB sky130_fd_pr__nfet_01v8 m=2 w=0.65u l=0.15u mult=1 sa=0.265
+ sb=0.265 sd=0.28 area=0.063 perim=1.14
MMNaoi11 sndNA B X VNB sky130_fd_pr__nfet_01v8 m=2 w=0.65u l=0.15u mult=1 sa=0.265
+ sb=0.265 sd=0.28 area=0.063 perim=1.14
MMNaoi20 X inor VGND VNB sky130_fd_pr__nfet_01v8 m=2 w=0.65u l=0.15u mult=1 sa=0.265
+ sb=0.265 sd=0.28 area=0.063 perim=1.14
MMPnor0 net59 A sndPA VNB sky130_fd_pr__pfet_01v8_hvt m=2 w=1.0u l=0.15u mult=1
+ sa=0.265 sb=0.265 sd=0.28 area=0.063 perim=1.14
MMPnor1 sndPA B inor VNB sky130_fd_pr__pfet_01v8_hvt m=2 w=1.0u l=0.15u mult=1
+ sa=0.265 sb=0.265 sd=0.28 area=0.063 perim=1.14
MMPaoi10 pmid A net59 VNB sky130_fd_pr__pfet_01v8_hvt m=2 w=1.0u l=0.15u mult=1
+ sa=0.265 sb=0.265 sd=0.28 area=0.063 perim=1.14
MMPaoi11 pmid B net59 VNB sky130_fd_pr__pfet_01v8_hvt m=2 w=1.0u l=0.15u mult=1
+ sa=0.265 sb=0.265 sd=0.28 area=0.063 perim=1.14
MMPaoi20 X inor pmid VNB sky130_fd_pr__pfet_01v8_hvt m=2 w=1.0u l=0.15u mult=1
+ sa=0.265 sb=0.265 sd=0.28 area=0.063 perim=1.14
.ENDS sky130_fd_sc_hd__xor2_2
* Copyright 2020 The SkyWater PDK Authors
*
* Licensed under the Apache License, Version 2.0 (the "License");
* you may not use this file except in compliance with the License.
* You may obtain a copy of the License at
*
*     https:  www.apache.org licenses LICENSE-2.0
*
* Unless required by applicable law or agreed to in writing, software
* distributed under the License is distributed on an "AS IS" BASIS,
* WITHOUT WARRANTIES OR CONDITIONS OF ANY KIND, either express or implied.
* See the License for the specific language governing permissions and
* limitations under the License.
*
* SPDX-License-Identifier: Apache-2.0

.SUBCKT sky130_fd_sc_hd__xor2_4 A B VGND VNB VNB net59 X
*.PININFO A:I B:I VGND:I VNB:I VNB:I net59:I X:O
MMNnor0 inor A VGND VNB sky130_fd_pr__nfet_01v8 m=4 w=0.65u l=0.15u mult=1 sa=0.265
+ sb=0.265 sd=0.28 area=0.063 perim=1.14
MMNnor1 inor B VGND VNB sky130_fd_pr__nfet_01v8 m=4 w=0.65u l=0.15u mult=1 sa=0.265
+ sb=0.265 sd=0.28 area=0.063 perim=1.14
MMNaoi10 VGND A sndNA VNB sky130_fd_pr__nfet_01v8 m=4 w=0.65u l=0.15u mult=1 sa=0.265
+ sb=0.265 sd=0.28 area=0.063 perim=1.14
MMNaoi11 sndNA B X VNB sky130_fd_pr__nfet_01v8 m=4 w=0.65u l=0.15u mult=1 sa=0.265
+ sb=0.265 sd=0.28 area=0.063 perim=1.14
MMNaoi20 X inor VGND VNB sky130_fd_pr__nfet_01v8 m=4 w=0.65u l=0.15u mult=1 sa=0.265
+ sb=0.265 sd=0.28 area=0.063 perim=1.14
MMPnor0 net59 A sndPA VNB sky130_fd_pr__pfet_01v8_hvt m=4 w=1.0u l=0.15u mult=1
+ sa=0.265 sb=0.265 sd=0.28 area=0.063 perim=1.14
MMPnor1 sndPA B inor VNB sky130_fd_pr__pfet_01v8_hvt m=4 w=1.0u l=0.15u mult=1
+ sa=0.265 sb=0.265 sd=0.28 area=0.063 perim=1.14
MMPaoi10 pmid A net59 VNB sky130_fd_pr__pfet_01v8_hvt m=4 w=1.0u l=0.15u mult=1
+ sa=0.265 sb=0.265 sd=0.28 area=0.063 perim=1.14
MMPaoi11 pmid B net59 VNB sky130_fd_pr__pfet_01v8_hvt m=4 w=1.0u l=0.15u mult=1
+ sa=0.265 sb=0.265 sd=0.28 area=0.063 perim=1.14
MMPaoi20 X inor pmid VNB sky130_fd_pr__pfet_01v8_hvt m=4 w=1.0u l=0.15u mult=1
+ sa=0.265 sb=0.265 sd=0.28 area=0.063 perim=1.14
.ENDS sky130_fd_sc_hd__xor2_4
* Copyright 2020 The SkyWater PDK Authors
*
* Licensed under the Apache License, Version 2.0 (the "License");
* you may not use this file except in compliance with the License.
* You may obtain a copy of the License at
*
*     https:  www.apache.org licenses LICENSE-2.0
*
* Unless required by applicable law or agreed to in writing, software
* distributed under the License is distributed on an "AS IS" BASIS,
* WITHOUT WARRANTIES OR CONDITIONS OF ANY KIND, either express or implied.
* See the License for the specific language governing permissions and
* limitations under the License.
*
* SPDX-License-Identifier: Apache-2.0

.SUBCKT sky130_fd_sc_hd__xor3_1 A B C VGND VNB VNB net59 X
*.PININFO A:I B:I C:I VGND:I VNB:I VNB:I net59:I X:O
MMIP3 X net117 net59 VNB sky130_fd_pr__pfet_01v8_hvt m=1 w=1.0u l=0.15u mult=1 sa=0.265
+ sb=0.265 sd=0.28 area=0.063 perim=1.14
MI650 mid1 Cb net117 VNB sky130_fd_pr__pfet_01v8_hvt m=1 w=0.84u l=0.15u mult=1
+ sa=0.265 sb=0.265 sd=0.28 area=0.063 perim=1.14
MI1 mid2 C net117 VNB sky130_fd_pr__pfet_01v8_hvt m=1 w=0.84u l=0.15u mult=1 sa=0.265
+ sb=0.265 sd=0.28 area=0.063 perim=1.14
MI33 Cb C net59 VNB sky130_fd_pr__pfet_01v8_hvt m=1 w=0.64u l=0.15u mult=1 sa=0.265
+ sb=0.265 sd=0.28 area=0.063 perim=1.14
MI45 Ab A net59 VNB sky130_fd_pr__pfet_01v8_hvt m=1 w=1.0u l=0.15u mult=1 sa=0.265
+ sb=0.265 sd=0.28 area=0.063 perim=1.14
MI47 Abb Ab net59 VNB sky130_fd_pr__pfet_01v8_hvt m=1 w=1.0u l=0.15u mult=1 sa=0.265
+ sb=0.265 sd=0.28 area=0.063 perim=1.14
MI19 mid1 Bb Ab VNB sky130_fd_pr__pfet_01v8_hvt m=1 w=0.84u l=0.15u mult=1 sa=0.265
+ sb=0.265 sd=0.28 area=0.063 perim=1.14
MI16 Bb B net59 VNB sky130_fd_pr__pfet_01v8_hvt m=1 w=1.0u l=0.15u mult=1 sa=0.265
+ sb=0.265 sd=0.28 area=0.063 perim=1.14
MI23 mid1 B Abb VNB sky130_fd_pr__pfet_01v8_hvt m=1 w=0.64u l=0.15u mult=1 sa=0.265
+ sb=0.265 sd=0.28 area=0.063 perim=1.14
MI26 mid2 Bb Abb VNB sky130_fd_pr__pfet_01v8_hvt m=1 w=0.64u l=0.15u mult=1 sa=0.265
+ sb=0.265 sd=0.28 area=0.063 perim=1.14
MI27 mid2 B Ab VNB sky130_fd_pr__pfet_01v8_hvt m=1 w=0.84u l=0.15u mult=1 sa=0.265
+ sb=0.265 sd=0.28 area=0.063 perim=1.14
MMIN3 X net117 VGND VNB sky130_fd_pr__nfet_01v8 m=1 w=0.65u l=0.15u mult=1 sa=0.265
+ sb=0.265 sd=0.28 area=0.063 perim=1.14
MI34 Cb C VGND VNB sky130_fd_pr__nfet_01v8 m=1 w=0.42u l=0.15u mult=1 sa=0.265
+ sb=0.265 sd=0.28 area=0.063 perim=1.14
MI649 mid1 C net117 VNB sky130_fd_pr__nfet_01v8 m=1 w=0.64u l=0.15u mult=1 sa=0.265
+ sb=0.265 sd=0.28 area=0.063 perim=1.14
MI2 mid2 Cb net117 VNB sky130_fd_pr__nfet_01v8 m=1 w=0.64u l=0.15u mult=1 sa=0.265
+ sb=0.265 sd=0.28 area=0.063 perim=1.14
MI44 Ab A VGND VNB sky130_fd_pr__nfet_01v8 m=1 w=0.64u l=0.15u mult=1 sa=0.265
+ sb=0.265 sd=0.28 area=0.063 perim=1.14
MI46 Abb Ab VGND VNB sky130_fd_pr__nfet_01v8 m=1 w=0.64u l=0.15u mult=1 sa=0.265
+ sb=0.265 sd=0.28 area=0.063 perim=1.14
MI17 Bb B VGND VNB sky130_fd_pr__nfet_01v8 m=1 w=0.65u l=0.15u mult=1 sa=0.265
+ sb=0.265 sd=0.28 area=0.063 perim=1.14
MI24 Ab B mid1 VNB sky130_fd_pr__nfet_01v8 m=1 w=0.64u l=0.15u mult=1 sa=0.265
+ sb=0.265 sd=0.28 area=0.063 perim=1.14
MI25 Abb Bb mid1 VNB sky130_fd_pr__nfet_01v8 m=1 w=0.42u l=0.15u mult=1 sa=0.265
+ sb=0.265 sd=0.28 area=0.063 perim=1.14
MI28 Abb B mid2 VNB sky130_fd_pr__nfet_01v8 m=1 w=0.64u l=0.15u mult=1 sa=0.265
+ sb=0.265 sd=0.28 area=0.063 perim=1.14
MI29 Ab Bb mid2 VNB sky130_fd_pr__nfet_01v8 m=1 w=0.6u l=0.15u mult=1 sa=0.265
+ sb=0.265 sd=0.28 area=0.063 perim=1.14
.ENDS sky130_fd_sc_hd__xor3_1
* Copyright 2020 The SkyWater PDK Authors
*
* Licensed under the Apache License, Version 2.0 (the "License");
* you may not use this file except in compliance with the License.
* You may obtain a copy of the License at
*
*     https:  www.apache.org licenses LICENSE-2.0
*
* Unless required by applicable law or agreed to in writing, software
* distributed under the License is distributed on an "AS IS" BASIS,
* WITHOUT WARRANTIES OR CONDITIONS OF ANY KIND, either express or implied.
* See the License for the specific language governing permissions and
* limitations under the License.
*
* SPDX-License-Identifier: Apache-2.0

.SUBCKT sky130_fd_sc_hd__xor3_2 A B C VGND VNB VNB net59 X
*.PININFO A:I B:I C:I VGND:I VNB:I VNB:I net59:I X:O
MMIP3 X net117 net59 VNB sky130_fd_pr__pfet_01v8_hvt m=2 w=1.0u l=0.15u mult=1 sa=0.265
+ sb=0.265 sd=0.28 area=0.063 perim=1.14
MI650 mid1 Cb net117 VNB sky130_fd_pr__pfet_01v8_hvt m=1 w=0.84u l=0.15u mult=1
+ sa=0.265 sb=0.265 sd=0.28 area=0.063 perim=1.14
MI1 mid2 C net117 VNB sky130_fd_pr__pfet_01v8_hvt m=1 w=0.84u l=0.15u mult=1 sa=0.265
+ sb=0.265 sd=0.28 area=0.063 perim=1.14
MI33 Cb C net59 VNB sky130_fd_pr__pfet_01v8_hvt m=1 w=0.64u l=0.15u mult=1 sa=0.265
+ sb=0.265 sd=0.28 area=0.063 perim=1.14
MI45 Ab A net59 VNB sky130_fd_pr__pfet_01v8_hvt m=1 w=1.0u l=0.15u mult=1 sa=0.265
+ sb=0.265 sd=0.28 area=0.063 perim=1.14
MI47 Abb Ab net59 VNB sky130_fd_pr__pfet_01v8_hvt m=1 w=1.0u l=0.15u mult=1 sa=0.265
+ sb=0.265 sd=0.28 area=0.063 perim=1.14
MI19 mid1 Bb Ab VNB sky130_fd_pr__pfet_01v8_hvt m=1 w=0.84u l=0.15u mult=1 sa=0.265
+ sb=0.265 sd=0.28 area=0.063 perim=1.14
MI16 Bb B net59 VNB sky130_fd_pr__pfet_01v8_hvt m=1 w=1.0u l=0.15u mult=1 sa=0.265
+ sb=0.265 sd=0.28 area=0.063 perim=1.14
MI23 mid1 B Abb VNB sky130_fd_pr__pfet_01v8_hvt m=1 w=0.64u l=0.15u mult=1 sa=0.265
+ sb=0.265 sd=0.28 area=0.063 perim=1.14
MI26 mid2 Bb Abb VNB sky130_fd_pr__pfet_01v8_hvt m=1 w=0.64u l=0.15u mult=1 sa=0.265
+ sb=0.265 sd=0.28 area=0.063 perim=1.14
MI27 mid2 B Ab VNB sky130_fd_pr__pfet_01v8_hvt m=1 w=0.84u l=0.15u mult=1 sa=0.265
+ sb=0.265 sd=0.28 area=0.063 perim=1.14
MMIN3 X net117 VGND VNB sky130_fd_pr__nfet_01v8 m=2 w=0.65u l=0.15u mult=1 sa=0.265
+ sb=0.265 sd=0.28 area=0.063 perim=1.14
MI34 Cb C VGND VNB sky130_fd_pr__nfet_01v8 m=1 w=0.42u l=0.15u mult=1 sa=0.265
+ sb=0.265 sd=0.28 area=0.063 perim=1.14
MI649 mid1 C net117 VNB sky130_fd_pr__nfet_01v8 m=1 w=0.64u l=0.15u mult=1 sa=0.265
+ sb=0.265 sd=0.28 area=0.063 perim=1.14
MI2 mid2 Cb net117 VNB sky130_fd_pr__nfet_01v8 m=1 w=0.64u l=0.15u mult=1 sa=0.265
+ sb=0.265 sd=0.28 area=0.063 perim=1.14
MI44 Ab A VGND VNB sky130_fd_pr__nfet_01v8 m=1 w=0.64u l=0.15u mult=1 sa=0.265
+ sb=0.265 sd=0.28 area=0.063 perim=1.14
MI46 Abb Ab VGND VNB sky130_fd_pr__nfet_01v8 m=1 w=0.64u l=0.15u mult=1 sa=0.265
+ sb=0.265 sd=0.28 area=0.063 perim=1.14
MI17 Bb B VGND VNB sky130_fd_pr__nfet_01v8 m=1 w=0.65u l=0.15u mult=1 sa=0.265
+ sb=0.265 sd=0.28 area=0.063 perim=1.14
MI24 Ab B mid1 VNB sky130_fd_pr__nfet_01v8 m=1 w=0.64u l=0.15u mult=1 sa=0.265
+ sb=0.265 sd=0.28 area=0.063 perim=1.14
MI25 Abb Bb mid1 VNB sky130_fd_pr__nfet_01v8 m=1 w=0.42u l=0.15u mult=1 sa=0.265
+ sb=0.265 sd=0.28 area=0.063 perim=1.14
MI28 Abb B mid2 VNB sky130_fd_pr__nfet_01v8 m=1 w=0.64u l=0.15u mult=1 sa=0.265
+ sb=0.265 sd=0.28 area=0.063 perim=1.14
MI29 Ab Bb mid2 VNB sky130_fd_pr__nfet_01v8 m=1 w=0.6u l=0.15u mult=1 sa=0.265
+ sb=0.265 sd=0.28 area=0.063 perim=1.14
.ENDS sky130_fd_sc_hd__xor3_2
* Copyright 2020 The SkyWater PDK Authors
*
* Licensed under the Apache License, Version 2.0 (the "License");
* you may not use this file except in compliance with the License.
* You may obtain a copy of the License at
*
*     https:  www.apache.org licenses LICENSE-2.0
*
* Unless required by applicable law or agreed to in writing, software
* distributed under the License is distributed on an "AS IS" BASIS,
* WITHOUT WARRANTIES OR CONDITIONS OF ANY KIND, either express or implied.
* See the License for the specific language governing permissions and
* limitations under the License.
*
* SPDX-License-Identifier: Apache-2.0

.SUBCKT sky130_fd_sc_hd__xor3_4 A B C VGND VNB VNB net59 X
*.PININFO A:I B:I C:I VGND:I VNB:I VNB:I net59:I X:O
MMIP3 X net117 net59 VNB sky130_fd_pr__pfet_01v8_hvt m=4 w=1.0u l=0.15u mult=1 sa=0.265
+ sb=0.265 sd=0.28 area=0.063 perim=1.14
MI650 mid1 Cb net117 VNB sky130_fd_pr__pfet_01v8_hvt m=1 w=0.84u l=0.15u mult=1
+ sa=0.265 sb=0.265 sd=0.28 area=0.063 perim=1.14
MI1 mid2 C net117 VNB sky130_fd_pr__pfet_01v8_hvt m=1 w=0.84u l=0.15u mult=1 sa=0.265
+ sb=0.265 sd=0.28 area=0.063 perim=1.14
MI33 Cb C net59 VNB sky130_fd_pr__pfet_01v8_hvt m=1 w=0.64u l=0.15u mult=1 sa=0.265
+ sb=0.265 sd=0.28 area=0.063 perim=1.14
MI45 Ab A net59 VNB sky130_fd_pr__pfet_01v8_hvt m=1 w=1.0u l=0.15u mult=1 sa=0.265
+ sb=0.265 sd=0.28 area=0.063 perim=1.14
MI47 Abb Ab net59 VNB sky130_fd_pr__pfet_01v8_hvt m=1 w=1.0u l=0.15u mult=1 sa=0.265
+ sb=0.265 sd=0.28 area=0.063 perim=1.14
MI19 mid1 Bb Ab VNB sky130_fd_pr__pfet_01v8_hvt m=1 w=0.84u l=0.15u mult=1 sa=0.265
+ sb=0.265 sd=0.28 area=0.063 perim=1.14
MI16 Bb B net59 VNB sky130_fd_pr__pfet_01v8_hvt m=1 w=1.0u l=0.15u mult=1 sa=0.265
+ sb=0.265 sd=0.28 area=0.063 perim=1.14
MI23 mid1 B Abb VNB sky130_fd_pr__pfet_01v8_hvt m=1 w=0.64u l=0.15u mult=1 sa=0.265
+ sb=0.265 sd=0.28 area=0.063 perim=1.14
MI26 mid2 Bb Abb VNB sky130_fd_pr__pfet_01v8_hvt m=1 w=0.64u l=0.15u mult=1 sa=0.265
+ sb=0.265 sd=0.28 area=0.063 perim=1.14
MI27 mid2 B Ab VNB sky130_fd_pr__pfet_01v8_hvt m=1 w=0.84u l=0.15u mult=1 sa=0.265
+ sb=0.265 sd=0.28 area=0.063 perim=1.14
MMIN3 X net117 VGND VNB sky130_fd_pr__nfet_01v8 m=4 w=0.65u l=0.15u mult=1 sa=0.265
+ sb=0.265 sd=0.28 area=0.063 perim=1.14
MI34 Cb C VGND VNB sky130_fd_pr__nfet_01v8 m=1 w=0.42u l=0.15u mult=1 sa=0.265
+ sb=0.265 sd=0.28 area=0.063 perim=1.14
MI649 mid1 C net117 VNB sky130_fd_pr__nfet_01v8 m=1 w=0.64u l=0.15u mult=1 sa=0.265
+ sb=0.265 sd=0.28 area=0.063 perim=1.14
MI2 mid2 Cb net117 VNB sky130_fd_pr__nfet_01v8 m=1 w=0.64u l=0.15u mult=1 sa=0.265
+ sb=0.265 sd=0.28 area=0.063 perim=1.14
MI44 Ab A VGND VNB sky130_fd_pr__nfet_01v8 m=1 w=0.64u l=0.15u mult=1 sa=0.265
+ sb=0.265 sd=0.28 area=0.063 perim=1.14
MI46 Abb Ab VGND VNB sky130_fd_pr__nfet_01v8 m=1 w=0.64u l=0.15u mult=1 sa=0.265
+ sb=0.265 sd=0.28 area=0.063 perim=1.14
MI17 Bb B VGND VNB sky130_fd_pr__nfet_01v8 m=1 w=0.65u l=0.15u mult=1 sa=0.265
+ sb=0.265 sd=0.28 area=0.063 perim=1.14
MI24 Ab B mid1 VNB sky130_fd_pr__nfet_01v8 m=1 w=0.64u l=0.15u mult=1 sa=0.265
+ sb=0.265 sd=0.28 area=0.063 perim=1.14
MI25 Abb Bb mid1 VNB sky130_fd_pr__nfet_01v8 m=1 w=0.42u l=0.15u mult=1 sa=0.265
+ sb=0.265 sd=0.28 area=0.063 perim=1.14
MI28 Abb B mid2 VNB sky130_fd_pr__nfet_01v8 m=1 w=0.64u l=0.15u mult=1 sa=0.265
+ sb=0.265 sd=0.28 area=0.063 perim=1.14
MI29 Ab Bb mid2 VNB sky130_fd_pr__nfet_01v8 m=1 w=0.6u l=0.15u mult=1 sa=0.265
+ sb=0.265 sd=0.28 area=0.063 perim=1.14
.ENDS sky130_fd_sc_hd__xor3_4
